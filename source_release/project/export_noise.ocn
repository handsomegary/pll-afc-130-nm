openResults("@PROJECT_ROOT@/results/vco_noise_smoke")
printf("RESULTS: %L\n" results())
pn = phaseNoise(1 "pss_fd" ?result "pnoise_pm")
ocnPrint(?output "@PROJECT_ROOT@/results/pn_ssb.txt" ?precision 12 ?width 20 ?numberNotation 'scientific pn)
printf("PN1MHz=%g\n" value(pn 1e6))
printf("PN10MHz=%g\n" value(pn 1e7))
exit()
