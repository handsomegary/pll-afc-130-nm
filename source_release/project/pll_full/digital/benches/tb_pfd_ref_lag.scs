simulator lang=spectre
global 0
include "@TECH_ROOT@/models/spectre/ms013_io33_v2p6_7p_spe.lib" section=tt
include "../pll130_digital_mos.scs"
parameters VD=1.2 REF_DELAY=7e-09 FB_DELAY=6e-09 FREF=100000000 FFB=100000000
simulatorOptions options temp=25 reltol=1e-5 vabstol=1e-7 iabstol=1e-12
VDD (vdd 0) vsource dc=VD
VRST (rst 0) vsource type=pwl wave=[0 VD 3n VD 3.02n 0]
VREF (ref 0) vsource type=pulse val0=0 val1=VD delay=REF_DELAY rise=20p fall=20p width=0.5/FREF-20p period=1/FREF
VFB (fb 0) vsource type=pulse val0=0 val1=VD delay=FB_DELAY rise=20p fall=20p width=0.5/FFB-20p period=1/FFB
XPFD (vdd 0 ref fb rst up dn) pll130_pfd
CUP (up 0) capacitor c=5f
CDN (dn 0) capacitor c=5f
saveOptions options save=selected
save vdd rst ref fb up dn VDD:p XPFD.reset XPFD.upn XPFD.dnn
tran tran stop=1e-07 maxstep=5p errpreset=conservative strobeperiod=5p strobeoutput=strobeonly
