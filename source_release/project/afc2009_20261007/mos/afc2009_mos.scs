// GENERATED transistor-only static-CMOS AFC: Jeong2009-inspired first-edge phase bracket.
// NEW130nm implementation; source design unverified until electrical units pass.
// All state physical TG DFFs, all compare/control staticMOS gates, no VA.
// REF100MHz, FB=VCO/32, positive frequency/code polarity; vdd=1.2V.
// VDD/VSS body rails; n12/p12 ordinary tt models required in top-level.
// Phase selector reset-release16physicalINV guard is not timing-signoff.
simulator lang=spectre
subckt afc2009_mos (vdd vss ref fb rst start s0 s1 s2 s3 s4 done fail hold fine_enable pfd_reset active)
MN3 (n1 fail vss vss) n12 w=0.8u l=0.13u
MN4 (n1 fine_enable vss vss) n12 w=0.8u l=0.13u
MP5 (n1 fail n2 vdd) p12 w=4.8u l=0.13u
MP6 (n2 fine_enable vdd vdd) p12 w=4.8u l=0.13u
MN8 (n7 n1 vss vss) n12 w=0.8u l=0.13u
MP9 (n7 n1 vdd vdd) p12 w=2.4u l=0.13u
MN11 (n10 n7 vss vss) n12 w=0.8u l=0.13u
MP12 (n10 n7 vdd vdd) p12 w=2.4u l=0.13u
MN15 (n13 n10 n14 vss) n12 w=1.6u l=0.13u
MN16 (n14 ref vss vss) n12 w=1.6u l=0.13u
MP17 (n13 n10 vdd vdd) p12 w=2.4u l=0.13u
MP18 (n13 ref vdd vdd) p12 w=2.4u l=0.13u
MN20 (n19 n13 vss vss) n12 w=0.8u l=0.13u
MP21 (n19 n13 vdd vdd) p12 w=2.4u l=0.13u
MN23 (n22 n19 vss vss) n12 w=0.8u l=0.13u
MP24 (n22 n19 vdd vdd) p12 w=2.4u l=0.13u
MN26 (n25 n22 vss vss) n12 w=0.8u l=0.13u
MP27 (n25 n22 vdd vdd) p12 w=2.4u l=0.13u
MN29 (n28 n25 vss vss) n12 w=0.8u l=0.13u
MP30 (n28 n25 vdd vdd) p12 w=2.4u l=0.13u
MN31 (control_clock n28 vss vss) n12 w=0.8u l=0.13u
MP32 (control_clock n28 vdd vdd) p12 w=2.4u l=0.13u
MN34 (n33 started vss vss) n12 w=0.8u l=0.13u
MP35 (n33 started vdd vdd) p12 w=2.4u l=0.13u
MN37 (n36 done vss vss) n12 w=0.8u l=0.13u
MP38 (n36 done vdd vdd) p12 w=2.4u l=0.13u
MN40 (n39 fail vss vss) n12 w=0.8u l=0.13u
MP41 (n39 fail vdd vdd) p12 w=2.4u l=0.13u
MN44 (n42 n33 n43 vss) n12 w=1.6u l=0.13u
MN45 (n43 start vss vss) n12 w=1.6u l=0.13u
MP46 (n42 n33 vdd vdd) p12 w=2.4u l=0.13u
MP47 (n42 start vdd vdd) p12 w=2.4u l=0.13u
MN49 (n48 n42 vss vss) n12 w=0.8u l=0.13u
MP50 (n48 n42 vdd vdd) p12 w=2.4u l=0.13u
MN53 (n51 n36 n52 vss) n12 w=1.6u l=0.13u
MN54 (n52 n39 vss vss) n12 w=1.6u l=0.13u
MP55 (n51 n36 vdd vdd) p12 w=2.4u l=0.13u
MP56 (n51 n39 vdd vdd) p12 w=2.4u l=0.13u
MN58 (n57 n51 vss vss) n12 w=0.8u l=0.13u
MP59 (n57 n51 vdd vdd) p12 w=2.4u l=0.13u
MN62 (n60 n48 n61 vss) n12 w=1.6u l=0.13u
MN63 (n61 n57 vss vss) n12 w=1.6u l=0.13u
MP64 (n60 n48 vdd vdd) p12 w=2.4u l=0.13u
MP65 (n60 n57 vdd vdd) p12 w=2.4u l=0.13u
MN67 (n66 n60 vss vss) n12 w=0.8u l=0.13u
MP68 (n66 n60 vdd vdd) p12 w=2.4u l=0.13u
MN70 (n69 n66 vss vss) n12 w=0.8u l=0.13u
MP71 (n69 n66 vdd vdd) p12 w=2.4u l=0.13u
MN74 (n72 n69 n73 vss) n12 w=1.6u l=0.13u
MN75 (n73 started vss vss) n12 w=1.6u l=0.13u
MP76 (n72 n69 vdd vdd) p12 w=2.4u l=0.13u
MP77 (n72 started vdd vdd) p12 w=2.4u l=0.13u
MN80 (n78 n69 n79 vss) n12 w=1.6u l=0.13u
MN81 (n79 n72 vss vss) n12 w=1.6u l=0.13u
MP82 (n78 n69 vdd vdd) p12 w=2.4u l=0.13u
MP83 (n78 n72 vdd vdd) p12 w=2.4u l=0.13u
MN85 (n84 rst vss vss) n12 w=0.8u l=0.13u
MP86 (n84 rst vdd vdd) p12 w=2.4u l=0.13u
MN89 (n87 n22 n88 vss) n12 w=1.6u l=0.13u
MN90 (n88 n84 vss vss) n12 w=1.6u l=0.13u
MP91 (n87 n22 vdd vdd) p12 w=2.4u l=0.13u
MP92 (n87 n84 vdd vdd) p12 w=2.4u l=0.13u
MN94 (n93 n87 vss vss) n12 w=0.8u l=0.13u
MP95 (n93 n87 vdd vdd) p12 w=2.4u l=0.13u
MN98 (n96 n19 n97 vss) n12 w=1.6u l=0.13u
MN99 (n97 n84 vss vss) n12 w=1.6u l=0.13u
MP100 (n96 n19 vdd vdd) p12 w=2.4u l=0.13u
MP101 (n96 n84 vdd vdd) p12 w=2.4u l=0.13u
MN103 (n102 n96 vss vss) n12 w=0.8u l=0.13u
MP104 (n102 n96 vdd vdd) p12 w=2.4u l=0.13u
MN106 (n105 n93 vss vss) n12 w=0.8u l=0.13u
MP107 (n105 n93 vdd vdd) p12 w=2.4u l=0.13u
MN109 (n108 n102 vss vss) n12 w=0.8u l=0.13u
MP110 (n108 n102 vdd vdd) p12 w=2.4u l=0.13u
MN115 (n78 n93 storage114 vss) n12 w=1.2u l=0.13u
MP116 (n78 n105 storage114 vdd) p12 w=3.6u l=0.13u
MN117 (qm111 n102 storage114 vss) n12 w=1.2u l=0.13u
MP118 (qm111 n108 storage114 vdd) p12 w=3.6u l=0.13u
MN119 (qmb112 storage114 vss vss) n12 w=0.5u l=0.13u
MP120 (qmb112 storage114 vdd vdd) p12 w=1.5u l=0.13u
MN121 (qm111 qmb112 vss vss) n12 w=0.5u l=0.13u
MP122 (qm111 qmb112 vdd vdd) p12 w=1.5u l=0.13u
MN123 (storage114 rst vss vss) n12 w=2u l=0.13u
MN125 (qm111 n102 storage124 vss) n12 w=1.2u l=0.13u
MP126 (qm111 n108 storage124 vdd) p12 w=3.6u l=0.13u
MN127 (started n93 storage124 vss) n12 w=1.2u l=0.13u
MP128 (started n105 storage124 vdd) p12 w=3.6u l=0.13u
MN129 (qb113 storage124 vss vss) n12 w=0.5u l=0.13u
MP130 (qb113 storage124 vdd vdd) p12 w=1.5u l=0.13u
MN131 (started qb113 vss vss) n12 w=0.5u l=0.13u
MP132 (started qb113 vdd vdd) p12 w=1.5u l=0.13u
MN133 (storage124 rst vss vss) n12 w=2u l=0.13u
MN136 (n134 arm vss vss) n12 w=0.8u l=0.13u
MN137 (n134 settle vss vss) n12 w=0.8u l=0.13u
MP138 (n134 arm n135 vdd) p12 w=4.8u l=0.13u
MP139 (n135 settle vdd vdd) p12 w=4.8u l=0.13u
MN141 (n140 n134 vss vss) n12 w=0.8u l=0.13u
MP142 (n140 n134 vdd vdd) p12 w=2.4u l=0.13u
MN145 (n143 drain vss vss) n12 w=0.8u l=0.13u
MN146 (n143 measure vss vss) n12 w=0.8u l=0.13u
MP147 (n143 drain n144 vdd) p12 w=4.8u l=0.13u
MP148 (n144 measure vdd vdd) p12 w=4.8u l=0.13u
MN150 (n149 n143 vss vss) n12 w=0.8u l=0.13u
MP151 (n149 n143 vdd vdd) p12 w=2.4u l=0.13u
MN154 (n152 n140 vss vss) n12 w=0.8u l=0.13u
MN155 (n152 n149 vss vss) n12 w=0.8u l=0.13u
MP156 (n152 n140 n153 vdd) p12 w=4.8u l=0.13u
MP157 (n153 n149 vdd vdd) p12 w=4.8u l=0.13u
MN159 (n158 n152 vss vss) n12 w=0.8u l=0.13u
MP160 (n158 n152 vdd vdd) p12 w=2.4u l=0.13u
MN163 (n161 done vss vss) n12 w=0.8u l=0.13u
MN164 (n161 fail vss vss) n12 w=0.8u l=0.13u
MP165 (n161 done n162 vdd) p12 w=4.8u l=0.13u
MP166 (n162 fail vdd vdd) p12 w=4.8u l=0.13u
MN168 (n167 n161 vss vss) n12 w=0.8u l=0.13u
MP169 (n167 n161 vdd vdd) p12 w=2.4u l=0.13u
MN171 (n170 n167 vss vss) n12 w=0.8u l=0.13u
MP172 (n170 n167 vdd vdd) p12 w=2.4u l=0.13u
MN175 (n173 n170 n174 vss) n12 w=1.6u l=0.13u
MN176 (n174 started vss vss) n12 w=1.6u l=0.13u
MP177 (n173 n170 vdd vdd) p12 w=2.4u l=0.13u
MP178 (n173 started vdd vdd) p12 w=2.4u l=0.13u
MN180 (n179 n173 vss vss) n12 w=0.8u l=0.13u
MP181 (n179 n173 vdd vdd) p12 w=2.4u l=0.13u
MN183 (n182 n179 vss vss) n12 w=0.8u l=0.13u
MP184 (n182 n179 vdd vdd) p12 w=2.4u l=0.13u
MN186 (n185 n182 vss vss) n12 w=0.8u l=0.13u
MP187 (n185 n182 vdd vdd) p12 w=2.4u l=0.13u
MN189 (n188 n185 vss vss) n12 w=0.8u l=0.13u
MP190 (n188 n185 vdd vdd) p12 w=2.4u l=0.13u
MN191 (active n188 vss vss) n12 w=0.8u l=0.13u
MP192 (active n188 vdd vdd) p12 w=2.4u l=0.13u
MN194 (n193 count_run vss vss) n12 w=0.8u l=0.13u
MP195 (n193 count_run vdd vdd) p12 w=2.4u l=0.13u
MN198 (n196 n193 vss vss) n12 w=0.8u l=0.13u
MN199 (n196 rst vss vss) n12 w=0.8u l=0.13u
MP200 (n196 n193 n197 vdd) p12 w=4.8u l=0.13u
MP201 (n197 rst vdd vdd) p12 w=4.8u l=0.13u
MN203 (n202 n196 vss vss) n12 w=0.8u l=0.13u
MP204 (n202 n196 vdd vdd) p12 w=2.4u l=0.13u
MN206 (n205 n202 vss vss) n12 w=0.8u l=0.13u
MP207 (n205 n202 vdd vdd) p12 w=2.4u l=0.13u
MN209 (n208 n205 vss vss) n12 w=0.8u l=0.13u
MP210 (n208 n205 vdd vdd) p12 w=2.4u l=0.13u
MN212 (n211 n208 vss vss) n12 w=0.8u l=0.13u
MP213 (n211 n208 vdd vdd) p12 w=2.4u l=0.13u
MN214 (count_rst n211 vss vss) n12 w=0.8u l=0.13u
MP215 (count_rst n211 vdd vdd) p12 w=2.4u l=0.13u
MN217 (n216 fb vss vss) n12 w=0.8u l=0.13u
MP218 (n216 fb vdd vdd) p12 w=2.4u l=0.13u
MN221 (n219 n205 n220 vss) n12 w=1.6u l=0.13u
MN222 (n220 n216 vss vss) n12 w=1.6u l=0.13u
MP223 (n219 n205 vdd vdd) p12 w=2.4u l=0.13u
MP224 (n219 n216 vdd vdd) p12 w=2.4u l=0.13u
MN226 (n225 n219 vss vss) n12 w=0.8u l=0.13u
MP227 (n225 n219 vdd vdd) p12 w=2.4u l=0.13u
MN230 (n228 fb n229 vss) n12 w=1.6u l=0.13u
MN231 (n229 n205 vss vss) n12 w=1.6u l=0.13u
MP232 (n228 fb vdd vdd) p12 w=2.4u l=0.13u
MP233 (n228 n205 vdd vdd) p12 w=2.4u l=0.13u
MN235 (n234 n228 vss vss) n12 w=0.8u l=0.13u
MP236 (n234 n228 vdd vdd) p12 w=2.4u l=0.13u
MN238 (n237 n225 vss vss) n12 w=0.8u l=0.13u
MP239 (n237 n225 vdd vdd) p12 w=2.4u l=0.13u
MN241 (n240 n234 vss vss) n12 w=0.8u l=0.13u
MP242 (n240 n234 vdd vdd) p12 w=2.4u l=0.13u
MN247 (vdd n225 storage246 vss) n12 w=1.2u l=0.13u
MP248 (vdd n237 storage246 vdd) p12 w=3.6u l=0.13u
MN249 (qm243 n234 storage246 vss) n12 w=1.2u l=0.13u
MP250 (qm243 n240 storage246 vdd) p12 w=3.6u l=0.13u
MN251 (qmb244 storage246 vss vss) n12 w=0.5u l=0.13u
MP252 (qmb244 storage246 vdd vdd) p12 w=1.5u l=0.13u
MN253 (qm243 qmb244 vss vss) n12 w=0.5u l=0.13u
MP254 (qm243 qmb244 vdd vdd) p12 w=1.5u l=0.13u
MN255 (storage246 n202 vss vss) n12 w=2u l=0.13u
MN257 (qm243 n234 storage256 vss) n12 w=1.2u l=0.13u
MP258 (qm243 n240 storage256 vdd) p12 w=3.6u l=0.13u
MN259 (seen n225 storage256 vss) n12 w=1.2u l=0.13u
MP260 (seen n237 storage256 vdd) p12 w=3.6u l=0.13u
MN261 (qb245 storage256 vss vss) n12 w=0.5u l=0.13u
MP262 (qb245 storage256 vdd vdd) p12 w=1.5u l=0.13u
MN263 (seen qb245 vss vss) n12 w=0.5u l=0.13u
MP264 (seen qb245 vdd vdd) p12 w=1.5u l=0.13u
MN265 (storage256 n202 vss vss) n12 w=2u l=0.13u
MN267 (n266 seen vss vss) n12 w=0.8u l=0.13u
MP268 (n266 seen vdd vdd) p12 w=2.4u l=0.13u
MN271 (n269 n266 n270 vss) n12 w=1.6u l=0.13u
MN272 (n270 ref vss vss) n12 w=1.6u l=0.13u
MP273 (n269 n266 vdd vdd) p12 w=2.4u l=0.13u
MP274 (n269 ref vdd vdd) p12 w=2.4u l=0.13u
MN276 (n275 n266 vss vss) n12 w=0.8u l=0.13u
MP277 (n275 n266 vdd vdd) p12 w=2.4u l=0.13u
MN280 (n278 n275 n279 vss) n12 w=1.6u l=0.13u
MN281 (n279 phase vss vss) n12 w=1.6u l=0.13u
MP282 (n278 n275 vdd vdd) p12 w=2.4u l=0.13u
MP283 (n278 phase vdd vdd) p12 w=2.4u l=0.13u
MN286 (n284 n269 n285 vss) n12 w=1.6u l=0.13u
MN287 (n285 n278 vss vss) n12 w=1.6u l=0.13u
MP288 (n284 n269 vdd vdd) p12 w=2.4u l=0.13u
MP289 (n284 n278 vdd vdd) p12 w=2.4u l=0.13u
MN294 (n284 n225 storage293 vss) n12 w=1.2u l=0.13u
MP295 (n284 n237 storage293 vdd) p12 w=3.6u l=0.13u
MN296 (qm290 n234 storage293 vss) n12 w=1.2u l=0.13u
MP297 (qm290 n240 storage293 vdd) p12 w=3.6u l=0.13u
MN298 (qmb291 storage293 vss vss) n12 w=0.5u l=0.13u
MP299 (qmb291 storage293 vdd vdd) p12 w=1.5u l=0.13u
MN300 (qm290 qmb291 vss vss) n12 w=0.5u l=0.13u
MP301 (qm290 qmb291 vdd vdd) p12 w=1.5u l=0.13u
MN302 (storage293 n202 vss vss) n12 w=2u l=0.13u
MN304 (qm290 n234 storage303 vss) n12 w=1.2u l=0.13u
MP305 (qm290 n240 storage303 vdd) p12 w=3.6u l=0.13u
MN306 (phase n225 storage303 vss) n12 w=1.2u l=0.13u
MP307 (phase n237 storage303 vdd) p12 w=3.6u l=0.13u
MN308 (qb292 storage303 vss vss) n12 w=0.5u l=0.13u
MP309 (qb292 storage303 vdd vdd) p12 w=1.5u l=0.13u
MN310 (phase qb292 vss vss) n12 w=0.5u l=0.13u
MP311 (phase qb292 vdd vdd) p12 w=1.5u l=0.13u
MN312 (storage303 n202 vss vss) n12 w=2u l=0.13u
MN314 (delay313 seen vss vss) n12 w=0.8u l=0.13u
MP315 (delay313 seen vdd vdd) p12 w=2.4u l=0.13u
MN317 (delay316 delay313 vss vss) n12 w=0.8u l=0.13u
MP318 (delay316 delay313 vdd vdd) p12 w=2.4u l=0.13u
MN320 (delay319 delay316 vss vss) n12 w=0.8u l=0.13u
MP321 (delay319 delay316 vdd vdd) p12 w=2.4u l=0.13u
MN323 (delay322 delay319 vss vss) n12 w=0.8u l=0.13u
MP324 (delay322 delay319 vdd vdd) p12 w=2.4u l=0.13u
MN326 (delay325 delay322 vss vss) n12 w=0.8u l=0.13u
MP327 (delay325 delay322 vdd vdd) p12 w=2.4u l=0.13u
MN329 (delay328 delay325 vss vss) n12 w=0.8u l=0.13u
MP330 (delay328 delay325 vdd vdd) p12 w=2.4u l=0.13u
MN332 (delay331 delay328 vss vss) n12 w=0.8u l=0.13u
MP333 (delay331 delay328 vdd vdd) p12 w=2.4u l=0.13u
MN335 (delay334 delay331 vss vss) n12 w=0.8u l=0.13u
MP336 (delay334 delay331 vdd vdd) p12 w=2.4u l=0.13u
MN338 (delay337 delay334 vss vss) n12 w=0.8u l=0.13u
MP339 (delay337 delay334 vdd vdd) p12 w=2.4u l=0.13u
MN341 (delay340 delay337 vss vss) n12 w=0.8u l=0.13u
MP342 (delay340 delay337 vdd vdd) p12 w=2.4u l=0.13u
MN344 (delay343 delay340 vss vss) n12 w=0.8u l=0.13u
MP345 (delay343 delay340 vdd vdd) p12 w=2.4u l=0.13u
MN347 (delay346 delay343 vss vss) n12 w=0.8u l=0.13u
MP348 (delay346 delay343 vdd vdd) p12 w=2.4u l=0.13u
MN350 (delay349 delay346 vss vss) n12 w=0.8u l=0.13u
MP351 (delay349 delay346 vdd vdd) p12 w=2.4u l=0.13u
MN353 (delay352 delay349 vss vss) n12 w=0.8u l=0.13u
MP354 (delay352 delay349 vdd vdd) p12 w=2.4u l=0.13u
MN356 (delay355 delay352 vss vss) n12 w=0.8u l=0.13u
MP357 (delay355 delay352 vdd vdd) p12 w=2.4u l=0.13u
MN359 (delay358 delay355 vss vss) n12 w=0.8u l=0.13u
MP360 (delay358 delay355 vdd vdd) p12 w=2.4u l=0.13u
MN362 (n361 delay358 vss vss) n12 w=0.8u l=0.13u
MP363 (n361 delay358 vdd vdd) p12 w=2.4u l=0.13u
MN366 (n364 n202 vss vss) n12 w=0.8u l=0.13u
MN367 (n364 n361 vss vss) n12 w=0.8u l=0.13u
MP368 (n364 n202 n365 vdd) p12 w=4.8u l=0.13u
MP369 (n365 n361 vdd vdd) p12 w=4.8u l=0.13u
MN371 (n370 n364 vss vss) n12 w=0.8u l=0.13u
MP372 (n370 n364 vdd vdd) p12 w=2.4u l=0.13u
MN374 (n373 n370 vss vss) n12 w=0.8u l=0.13u
MP375 (n373 n370 vdd vdd) p12 w=2.4u l=0.13u
MN377 (n376 n373 vss vss) n12 w=0.8u l=0.13u
MP378 (n376 n373 vdd vdd) p12 w=2.4u l=0.13u
MN380 (n379 n376 vss vss) n12 w=0.8u l=0.13u
MP381 (n379 n376 vdd vdd) p12 w=2.4u l=0.13u
MN382 (reference_count_rst n379 vss vss) n12 w=0.8u l=0.13u
MP383 (reference_count_rst n379 vdd vdd) p12 w=2.4u l=0.13u
MN385 (n384 ref vss vss) n12 w=0.8u l=0.13u
MP386 (n384 ref vdd vdd) p12 w=2.4u l=0.13u
MN389 (n387 phase n388 vss) n12 w=1.6u l=0.13u
MN390 (n388 ref vss vss) n12 w=1.6u l=0.13u
MP391 (n387 phase vdd vdd) p12 w=2.4u l=0.13u
MP392 (n387 ref vdd vdd) p12 w=2.4u l=0.13u
MN394 (n393 phase vss vss) n12 w=0.8u l=0.13u
MP395 (n393 phase vdd vdd) p12 w=2.4u l=0.13u
MN398 (n396 n384 n397 vss) n12 w=1.6u l=0.13u
MN399 (n397 n393 vss vss) n12 w=1.6u l=0.13u
MP400 (n396 n384 vdd vdd) p12 w=2.4u l=0.13u
MP401 (n396 n393 vdd vdd) p12 w=2.4u l=0.13u
MN404 (n402 n387 n403 vss) n12 w=1.6u l=0.13u
MN405 (n403 n396 vss vss) n12 w=1.6u l=0.13u
MP406 (n402 n387 vdd vdd) p12 w=2.4u l=0.13u
MP407 (n402 n396 vdd vdd) p12 w=2.4u l=0.13u
MN410 (n408 n384 n409 vss) n12 w=1.6u l=0.13u
MN411 (n409 phase vss vss) n12 w=1.6u l=0.13u
MP412 (n408 n384 vdd vdd) p12 w=2.4u l=0.13u
MP413 (n408 phase vdd vdd) p12 w=2.4u l=0.13u
MN416 (n414 n393 n415 vss) n12 w=1.6u l=0.13u
MN417 (n415 ref vss vss) n12 w=1.6u l=0.13u
MP418 (n414 n393 vdd vdd) p12 w=2.4u l=0.13u
MP419 (n414 ref vdd vdd) p12 w=2.4u l=0.13u
MN422 (n420 n408 n421 vss) n12 w=1.6u l=0.13u
MN423 (n421 n414 vss vss) n12 w=1.6u l=0.13u
MP424 (n420 n408 vdd vdd) p12 w=2.4u l=0.13u
MP425 (n420 n414 vdd vdd) p12 w=2.4u l=0.13u
MN427 (n426 n402 vss vss) n12 w=0.8u l=0.13u
MP428 (n426 n402 vdd vdd) p12 w=2.4u l=0.13u
MN430 (n429 n426 vss vss) n12 w=0.8u l=0.13u
MP431 (n429 n426 vdd vdd) p12 w=2.4u l=0.13u
MN433 (n432 n429 vss vss) n12 w=0.8u l=0.13u
MP434 (n432 n429 vdd vdd) p12 w=2.4u l=0.13u
MN435 (lead_clock n432 vss vss) n12 w=0.8u l=0.13u
MP436 (lead_clock n432 vdd vdd) p12 w=2.4u l=0.13u
MN438 (n437 n420 vss vss) n12 w=0.8u l=0.13u
MP439 (n437 n420 vdd vdd) p12 w=2.4u l=0.13u
MN441 (n440 n437 vss vss) n12 w=0.8u l=0.13u
MP442 (n440 n437 vdd vdd) p12 w=2.4u l=0.13u
MN444 (n443 n440 vss vss) n12 w=0.8u l=0.13u
MP445 (n443 n440 vdd vdd) p12 w=2.4u l=0.13u
MN446 (lag_clock n443 vss vss) n12 w=0.8u l=0.13u
MP447 (lag_clock n443 vdd vdd) p12 w=2.4u l=0.13u
MN450 (n448 count_run n449 vss) n12 w=1.6u l=0.13u
MN451 (n449 n402 vss vss) n12 w=1.6u l=0.13u
MP452 (n448 count_run vdd vdd) p12 w=2.4u l=0.13u
MP453 (n448 n402 vdd vdd) p12 w=2.4u l=0.13u
MN455 (n454 n448 vss vss) n12 w=0.8u l=0.13u
MP456 (n454 n448 vdd vdd) p12 w=2.4u l=0.13u
MN459 (n457 count_run n458 vss) n12 w=1.6u l=0.13u
MN460 (n458 n420 vss vss) n12 w=1.6u l=0.13u
MP461 (n457 count_run vdd vdd) p12 w=2.4u l=0.13u
MP462 (n457 n420 vdd vdd) p12 w=2.4u l=0.13u
MN464 (n463 n457 vss vss) n12 w=0.8u l=0.13u
MP465 (n463 n457 vdd vdd) p12 w=2.4u l=0.13u
MN468 (n466 lead_g6 n467 vss) n12 w=1.6u l=0.13u
MN469 (n467 lead_g7 vss vss) n12 w=1.6u l=0.13u
MP470 (n466 lead_g6 vdd vdd) p12 w=2.4u l=0.13u
MP471 (n466 lead_g7 vdd vdd) p12 w=2.4u l=0.13u
MN474 (n472 lead_g6 n473 vss) n12 w=1.6u l=0.13u
MN475 (n473 n466 vss vss) n12 w=1.6u l=0.13u
MP476 (n472 lead_g6 vdd vdd) p12 w=2.4u l=0.13u
MP477 (n472 n466 vdd vdd) p12 w=2.4u l=0.13u
MN480 (n478 lead_g7 n479 vss) n12 w=1.6u l=0.13u
MN481 (n479 n466 vss vss) n12 w=1.6u l=0.13u
MP482 (n478 lead_g7 vdd vdd) p12 w=2.4u l=0.13u
MP483 (n478 n466 vdd vdd) p12 w=2.4u l=0.13u
MN486 (n484 n472 n485 vss) n12 w=1.6u l=0.13u
MN487 (n485 n478 vss vss) n12 w=1.6u l=0.13u
MP488 (n484 n472 vdd vdd) p12 w=2.4u l=0.13u
MP489 (n484 n478 vdd vdd) p12 w=2.4u l=0.13u
MN492 (n490 lead_g5 n491 vss) n12 w=1.6u l=0.13u
MN493 (n491 n484 vss vss) n12 w=1.6u l=0.13u
MP494 (n490 lead_g5 vdd vdd) p12 w=2.4u l=0.13u
MP495 (n490 n484 vdd vdd) p12 w=2.4u l=0.13u
MN498 (n496 lead_g5 n497 vss) n12 w=1.6u l=0.13u
MN499 (n497 n490 vss vss) n12 w=1.6u l=0.13u
MP500 (n496 lead_g5 vdd vdd) p12 w=2.4u l=0.13u
MP501 (n496 n490 vdd vdd) p12 w=2.4u l=0.13u
MN504 (n502 n484 n503 vss) n12 w=1.6u l=0.13u
MN505 (n503 n490 vss vss) n12 w=1.6u l=0.13u
MP506 (n502 n484 vdd vdd) p12 w=2.4u l=0.13u
MP507 (n502 n490 vdd vdd) p12 w=2.4u l=0.13u
MN510 (n508 n496 n509 vss) n12 w=1.6u l=0.13u
MN511 (n509 n502 vss vss) n12 w=1.6u l=0.13u
MP512 (n508 n496 vdd vdd) p12 w=2.4u l=0.13u
MP513 (n508 n502 vdd vdd) p12 w=2.4u l=0.13u
MN516 (n514 lead_g4 n515 vss) n12 w=1.6u l=0.13u
MN517 (n515 n508 vss vss) n12 w=1.6u l=0.13u
MP518 (n514 lead_g4 vdd vdd) p12 w=2.4u l=0.13u
MP519 (n514 n508 vdd vdd) p12 w=2.4u l=0.13u
MN522 (n520 lead_g4 n521 vss) n12 w=1.6u l=0.13u
MN523 (n521 n514 vss vss) n12 w=1.6u l=0.13u
MP524 (n520 lead_g4 vdd vdd) p12 w=2.4u l=0.13u
MP525 (n520 n514 vdd vdd) p12 w=2.4u l=0.13u
MN528 (n526 n508 n527 vss) n12 w=1.6u l=0.13u
MN529 (n527 n514 vss vss) n12 w=1.6u l=0.13u
MP530 (n526 n508 vdd vdd) p12 w=2.4u l=0.13u
MP531 (n526 n514 vdd vdd) p12 w=2.4u l=0.13u
MN534 (n532 n520 n533 vss) n12 w=1.6u l=0.13u
MN535 (n533 n526 vss vss) n12 w=1.6u l=0.13u
MP536 (n532 n520 vdd vdd) p12 w=2.4u l=0.13u
MP537 (n532 n526 vdd vdd) p12 w=2.4u l=0.13u
MN540 (n538 lead_g3 n539 vss) n12 w=1.6u l=0.13u
MN541 (n539 n532 vss vss) n12 w=1.6u l=0.13u
MP542 (n538 lead_g3 vdd vdd) p12 w=2.4u l=0.13u
MP543 (n538 n532 vdd vdd) p12 w=2.4u l=0.13u
MN546 (n544 lead_g3 n545 vss) n12 w=1.6u l=0.13u
MN547 (n545 n538 vss vss) n12 w=1.6u l=0.13u
MP548 (n544 lead_g3 vdd vdd) p12 w=2.4u l=0.13u
MP549 (n544 n538 vdd vdd) p12 w=2.4u l=0.13u
MN552 (n550 n532 n551 vss) n12 w=1.6u l=0.13u
MN553 (n551 n538 vss vss) n12 w=1.6u l=0.13u
MP554 (n550 n532 vdd vdd) p12 w=2.4u l=0.13u
MP555 (n550 n538 vdd vdd) p12 w=2.4u l=0.13u
MN558 (n556 n544 n557 vss) n12 w=1.6u l=0.13u
MN559 (n557 n550 vss vss) n12 w=1.6u l=0.13u
MP560 (n556 n544 vdd vdd) p12 w=2.4u l=0.13u
MP561 (n556 n550 vdd vdd) p12 w=2.4u l=0.13u
MN564 (n562 lead_g2 n563 vss) n12 w=1.6u l=0.13u
MN565 (n563 n556 vss vss) n12 w=1.6u l=0.13u
MP566 (n562 lead_g2 vdd vdd) p12 w=2.4u l=0.13u
MP567 (n562 n556 vdd vdd) p12 w=2.4u l=0.13u
MN570 (n568 lead_g2 n569 vss) n12 w=1.6u l=0.13u
MN571 (n569 n562 vss vss) n12 w=1.6u l=0.13u
MP572 (n568 lead_g2 vdd vdd) p12 w=2.4u l=0.13u
MP573 (n568 n562 vdd vdd) p12 w=2.4u l=0.13u
MN576 (n574 n556 n575 vss) n12 w=1.6u l=0.13u
MN577 (n575 n562 vss vss) n12 w=1.6u l=0.13u
MP578 (n574 n556 vdd vdd) p12 w=2.4u l=0.13u
MP579 (n574 n562 vdd vdd) p12 w=2.4u l=0.13u
MN582 (n580 n568 n581 vss) n12 w=1.6u l=0.13u
MN583 (n581 n574 vss vss) n12 w=1.6u l=0.13u
MP584 (n580 n568 vdd vdd) p12 w=2.4u l=0.13u
MP585 (n580 n574 vdd vdd) p12 w=2.4u l=0.13u
MN588 (n586 lead_g1 n587 vss) n12 w=1.6u l=0.13u
MN589 (n587 n580 vss vss) n12 w=1.6u l=0.13u
MP590 (n586 lead_g1 vdd vdd) p12 w=2.4u l=0.13u
MP591 (n586 n580 vdd vdd) p12 w=2.4u l=0.13u
MN594 (n592 lead_g1 n593 vss) n12 w=1.6u l=0.13u
MN595 (n593 n586 vss vss) n12 w=1.6u l=0.13u
MP596 (n592 lead_g1 vdd vdd) p12 w=2.4u l=0.13u
MP597 (n592 n586 vdd vdd) p12 w=2.4u l=0.13u
MN600 (n598 n580 n599 vss) n12 w=1.6u l=0.13u
MN601 (n599 n586 vss vss) n12 w=1.6u l=0.13u
MP602 (n598 n580 vdd vdd) p12 w=2.4u l=0.13u
MP603 (n598 n586 vdd vdd) p12 w=2.4u l=0.13u
MN606 (n604 n592 n605 vss) n12 w=1.6u l=0.13u
MN607 (n605 n598 vss vss) n12 w=1.6u l=0.13u
MP608 (n604 n592 vdd vdd) p12 w=2.4u l=0.13u
MP609 (n604 n598 vdd vdd) p12 w=2.4u l=0.13u
MN612 (n610 lead_g0 n611 vss) n12 w=1.6u l=0.13u
MN613 (n611 n604 vss vss) n12 w=1.6u l=0.13u
MP614 (n610 lead_g0 vdd vdd) p12 w=2.4u l=0.13u
MP615 (n610 n604 vdd vdd) p12 w=2.4u l=0.13u
MN618 (n616 lead_g0 n617 vss) n12 w=1.6u l=0.13u
MN619 (n617 n610 vss vss) n12 w=1.6u l=0.13u
MP620 (n616 lead_g0 vdd vdd) p12 w=2.4u l=0.13u
MP621 (n616 n610 vdd vdd) p12 w=2.4u l=0.13u
MN624 (n622 n604 n623 vss) n12 w=1.6u l=0.13u
MN625 (n623 n610 vss vss) n12 w=1.6u l=0.13u
MP626 (n622 n604 vdd vdd) p12 w=2.4u l=0.13u
MP627 (n622 n610 vdd vdd) p12 w=2.4u l=0.13u
MN630 (n628 n616 n629 vss) n12 w=1.6u l=0.13u
MN631 (n629 n622 vss vss) n12 w=1.6u l=0.13u
MP632 (n628 n616 vdd vdd) p12 w=2.4u l=0.13u
MP633 (n628 n622 vdd vdd) p12 w=2.4u l=0.13u
MN635 (n634 n628 vss vss) n12 w=0.8u l=0.13u
MP636 (n634 n628 vdd vdd) p12 w=2.4u l=0.13u
MN639 (n637 n604 n638 vss) n12 w=1.6u l=0.13u
MN640 (n638 n628 vss vss) n12 w=1.6u l=0.13u
MP641 (n637 n604 vdd vdd) p12 w=2.4u l=0.13u
MP642 (n637 n628 vdd vdd) p12 w=2.4u l=0.13u
MN645 (n643 n604 n644 vss) n12 w=1.6u l=0.13u
MN646 (n644 n637 vss vss) n12 w=1.6u l=0.13u
MP647 (n643 n604 vdd vdd) p12 w=2.4u l=0.13u
MP648 (n643 n637 vdd vdd) p12 w=2.4u l=0.13u
MN651 (n649 n628 n650 vss) n12 w=1.6u l=0.13u
MN652 (n650 n637 vss vss) n12 w=1.6u l=0.13u
MP653 (n649 n628 vdd vdd) p12 w=2.4u l=0.13u
MP654 (n649 n637 vdd vdd) p12 w=2.4u l=0.13u
MN657 (n655 n643 n656 vss) n12 w=1.6u l=0.13u
MN658 (n656 n649 vss vss) n12 w=1.6u l=0.13u
MP659 (n655 n643 vdd vdd) p12 w=2.4u l=0.13u
MP660 (n655 n649 vdd vdd) p12 w=2.4u l=0.13u
MN662 (n661 n637 vss vss) n12 w=0.8u l=0.13u
MP663 (n661 n637 vdd vdd) p12 w=2.4u l=0.13u
MN666 (n664 n580 n665 vss) n12 w=1.6u l=0.13u
MN667 (n665 n661 vss vss) n12 w=1.6u l=0.13u
MP668 (n664 n580 vdd vdd) p12 w=2.4u l=0.13u
MP669 (n664 n661 vdd vdd) p12 w=2.4u l=0.13u
MN672 (n670 n580 n671 vss) n12 w=1.6u l=0.13u
MN673 (n671 n664 vss vss) n12 w=1.6u l=0.13u
MP674 (n670 n580 vdd vdd) p12 w=2.4u l=0.13u
MP675 (n670 n664 vdd vdd) p12 w=2.4u l=0.13u
MN678 (n676 n661 n677 vss) n12 w=1.6u l=0.13u
MN679 (n677 n664 vss vss) n12 w=1.6u l=0.13u
MP680 (n676 n661 vdd vdd) p12 w=2.4u l=0.13u
MP681 (n676 n664 vdd vdd) p12 w=2.4u l=0.13u
MN684 (n682 n670 n683 vss) n12 w=1.6u l=0.13u
MN685 (n683 n676 vss vss) n12 w=1.6u l=0.13u
MP686 (n682 n670 vdd vdd) p12 w=2.4u l=0.13u
MP687 (n682 n676 vdd vdd) p12 w=2.4u l=0.13u
MN689 (n688 n664 vss vss) n12 w=0.8u l=0.13u
MP690 (n688 n664 vdd vdd) p12 w=2.4u l=0.13u
MN693 (n691 n556 n692 vss) n12 w=1.6u l=0.13u
MN694 (n692 n688 vss vss) n12 w=1.6u l=0.13u
MP695 (n691 n556 vdd vdd) p12 w=2.4u l=0.13u
MP696 (n691 n688 vdd vdd) p12 w=2.4u l=0.13u
MN699 (n697 n556 n698 vss) n12 w=1.6u l=0.13u
MN700 (n698 n691 vss vss) n12 w=1.6u l=0.13u
MP701 (n697 n556 vdd vdd) p12 w=2.4u l=0.13u
MP702 (n697 n691 vdd vdd) p12 w=2.4u l=0.13u
MN705 (n703 n688 n704 vss) n12 w=1.6u l=0.13u
MN706 (n704 n691 vss vss) n12 w=1.6u l=0.13u
MP707 (n703 n688 vdd vdd) p12 w=2.4u l=0.13u
MP708 (n703 n691 vdd vdd) p12 w=2.4u l=0.13u
MN711 (n709 n697 n710 vss) n12 w=1.6u l=0.13u
MN712 (n710 n703 vss vss) n12 w=1.6u l=0.13u
MP713 (n709 n697 vdd vdd) p12 w=2.4u l=0.13u
MP714 (n709 n703 vdd vdd) p12 w=2.4u l=0.13u
MN716 (n715 n691 vss vss) n12 w=0.8u l=0.13u
MP717 (n715 n691 vdd vdd) p12 w=2.4u l=0.13u
MN720 (n718 n532 n719 vss) n12 w=1.6u l=0.13u
MN721 (n719 n715 vss vss) n12 w=1.6u l=0.13u
MP722 (n718 n532 vdd vdd) p12 w=2.4u l=0.13u
MP723 (n718 n715 vdd vdd) p12 w=2.4u l=0.13u
MN726 (n724 n532 n725 vss) n12 w=1.6u l=0.13u
MN727 (n725 n718 vss vss) n12 w=1.6u l=0.13u
MP728 (n724 n532 vdd vdd) p12 w=2.4u l=0.13u
MP729 (n724 n718 vdd vdd) p12 w=2.4u l=0.13u
MN732 (n730 n715 n731 vss) n12 w=1.6u l=0.13u
MN733 (n731 n718 vss vss) n12 w=1.6u l=0.13u
MP734 (n730 n715 vdd vdd) p12 w=2.4u l=0.13u
MP735 (n730 n718 vdd vdd) p12 w=2.4u l=0.13u
MN738 (n736 n724 n737 vss) n12 w=1.6u l=0.13u
MN739 (n737 n730 vss vss) n12 w=1.6u l=0.13u
MP740 (n736 n724 vdd vdd) p12 w=2.4u l=0.13u
MP741 (n736 n730 vdd vdd) p12 w=2.4u l=0.13u
MN743 (n742 n718 vss vss) n12 w=0.8u l=0.13u
MP744 (n742 n718 vdd vdd) p12 w=2.4u l=0.13u
MN747 (n745 n508 n746 vss) n12 w=1.6u l=0.13u
MN748 (n746 n742 vss vss) n12 w=1.6u l=0.13u
MP749 (n745 n508 vdd vdd) p12 w=2.4u l=0.13u
MP750 (n745 n742 vdd vdd) p12 w=2.4u l=0.13u
MN753 (n751 n508 n752 vss) n12 w=1.6u l=0.13u
MN754 (n752 n745 vss vss) n12 w=1.6u l=0.13u
MP755 (n751 n508 vdd vdd) p12 w=2.4u l=0.13u
MP756 (n751 n745 vdd vdd) p12 w=2.4u l=0.13u
MN759 (n757 n742 n758 vss) n12 w=1.6u l=0.13u
MN760 (n758 n745 vss vss) n12 w=1.6u l=0.13u
MP761 (n757 n742 vdd vdd) p12 w=2.4u l=0.13u
MP762 (n757 n745 vdd vdd) p12 w=2.4u l=0.13u
MN765 (n763 n751 n764 vss) n12 w=1.6u l=0.13u
MN766 (n764 n757 vss vss) n12 w=1.6u l=0.13u
MP767 (n763 n751 vdd vdd) p12 w=2.4u l=0.13u
MP768 (n763 n757 vdd vdd) p12 w=2.4u l=0.13u
MN770 (n769 n745 vss vss) n12 w=0.8u l=0.13u
MP771 (n769 n745 vdd vdd) p12 w=2.4u l=0.13u
MN774 (n772 n484 n773 vss) n12 w=1.6u l=0.13u
MN775 (n773 n769 vss vss) n12 w=1.6u l=0.13u
MP776 (n772 n484 vdd vdd) p12 w=2.4u l=0.13u
MP777 (n772 n769 vdd vdd) p12 w=2.4u l=0.13u
MN780 (n778 n484 n779 vss) n12 w=1.6u l=0.13u
MN781 (n779 n772 vss vss) n12 w=1.6u l=0.13u
MP782 (n778 n484 vdd vdd) p12 w=2.4u l=0.13u
MP783 (n778 n772 vdd vdd) p12 w=2.4u l=0.13u
MN786 (n784 n769 n785 vss) n12 w=1.6u l=0.13u
MN787 (n785 n772 vss vss) n12 w=1.6u l=0.13u
MP788 (n784 n769 vdd vdd) p12 w=2.4u l=0.13u
MP789 (n784 n772 vdd vdd) p12 w=2.4u l=0.13u
MN792 (n790 n778 n791 vss) n12 w=1.6u l=0.13u
MN793 (n791 n784 vss vss) n12 w=1.6u l=0.13u
MP794 (n790 n778 vdd vdd) p12 w=2.4u l=0.13u
MP795 (n790 n784 vdd vdd) p12 w=2.4u l=0.13u
MN797 (n796 n772 vss vss) n12 w=0.8u l=0.13u
MP798 (n796 n772 vdd vdd) p12 w=2.4u l=0.13u
MN801 (n799 lead_g7 n800 vss) n12 w=1.6u l=0.13u
MN802 (n800 n796 vss vss) n12 w=1.6u l=0.13u
MP803 (n799 lead_g7 vdd vdd) p12 w=2.4u l=0.13u
MP804 (n799 n796 vdd vdd) p12 w=2.4u l=0.13u
MN807 (n805 lead_g7 n806 vss) n12 w=1.6u l=0.13u
MN808 (n806 n799 vss vss) n12 w=1.6u l=0.13u
MP809 (n805 lead_g7 vdd vdd) p12 w=2.4u l=0.13u
MP810 (n805 n799 vdd vdd) p12 w=2.4u l=0.13u
MN813 (n811 n796 n812 vss) n12 w=1.6u l=0.13u
MN814 (n812 n799 vss vss) n12 w=1.6u l=0.13u
MP815 (n811 n796 vdd vdd) p12 w=2.4u l=0.13u
MP816 (n811 n799 vdd vdd) p12 w=2.4u l=0.13u
MN819 (n817 n805 n818 vss) n12 w=1.6u l=0.13u
MN820 (n818 n811 vss vss) n12 w=1.6u l=0.13u
MP821 (n817 n805 vdd vdd) p12 w=2.4u l=0.13u
MP822 (n817 n811 vdd vdd) p12 w=2.4u l=0.13u
MN824 (n823 n799 vss vss) n12 w=0.8u l=0.13u
MP825 (n823 n799 vdd vdd) p12 w=2.4u l=0.13u
MN828 (n826 n634 n827 vss) n12 w=1.6u l=0.13u
MN829 (n827 n655 vss vss) n12 w=1.6u l=0.13u
MP830 (n826 n634 vdd vdd) p12 w=2.4u l=0.13u
MP831 (n826 n655 vdd vdd) p12 w=2.4u l=0.13u
MN834 (n832 n634 n833 vss) n12 w=1.6u l=0.13u
MN835 (n833 n826 vss vss) n12 w=1.6u l=0.13u
MP836 (n832 n634 vdd vdd) p12 w=2.4u l=0.13u
MP837 (n832 n826 vdd vdd) p12 w=2.4u l=0.13u
MN840 (n838 n655 n839 vss) n12 w=1.6u l=0.13u
MN841 (n839 n826 vss vss) n12 w=1.6u l=0.13u
MP842 (n838 n655 vdd vdd) p12 w=2.4u l=0.13u
MP843 (n838 n826 vdd vdd) p12 w=2.4u l=0.13u
MN846 (n844 n832 n845 vss) n12 w=1.6u l=0.13u
MN847 (n845 n838 vss vss) n12 w=1.6u l=0.13u
MP848 (n844 n832 vdd vdd) p12 w=2.4u l=0.13u
MP849 (n844 n838 vdd vdd) p12 w=2.4u l=0.13u
MN852 (n850 n655 n851 vss) n12 w=1.6u l=0.13u
MN853 (n851 n682 vss vss) n12 w=1.6u l=0.13u
MP854 (n850 n655 vdd vdd) p12 w=2.4u l=0.13u
MP855 (n850 n682 vdd vdd) p12 w=2.4u l=0.13u
MN858 (n856 n655 n857 vss) n12 w=1.6u l=0.13u
MN859 (n857 n850 vss vss) n12 w=1.6u l=0.13u
MP860 (n856 n655 vdd vdd) p12 w=2.4u l=0.13u
MP861 (n856 n850 vdd vdd) p12 w=2.4u l=0.13u
MN864 (n862 n682 n863 vss) n12 w=1.6u l=0.13u
MN865 (n863 n850 vss vss) n12 w=1.6u l=0.13u
MP866 (n862 n682 vdd vdd) p12 w=2.4u l=0.13u
MP867 (n862 n850 vdd vdd) p12 w=2.4u l=0.13u
MN870 (n868 n856 n869 vss) n12 w=1.6u l=0.13u
MN871 (n869 n862 vss vss) n12 w=1.6u l=0.13u
MP872 (n868 n856 vdd vdd) p12 w=2.4u l=0.13u
MP873 (n868 n862 vdd vdd) p12 w=2.4u l=0.13u
MN876 (n874 n682 n875 vss) n12 w=1.6u l=0.13u
MN877 (n875 n709 vss vss) n12 w=1.6u l=0.13u
MP878 (n874 n682 vdd vdd) p12 w=2.4u l=0.13u
MP879 (n874 n709 vdd vdd) p12 w=2.4u l=0.13u
MN882 (n880 n682 n881 vss) n12 w=1.6u l=0.13u
MN883 (n881 n874 vss vss) n12 w=1.6u l=0.13u
MP884 (n880 n682 vdd vdd) p12 w=2.4u l=0.13u
MP885 (n880 n874 vdd vdd) p12 w=2.4u l=0.13u
MN888 (n886 n709 n887 vss) n12 w=1.6u l=0.13u
MN889 (n887 n874 vss vss) n12 w=1.6u l=0.13u
MP890 (n886 n709 vdd vdd) p12 w=2.4u l=0.13u
MP891 (n886 n874 vdd vdd) p12 w=2.4u l=0.13u
MN894 (n892 n880 n893 vss) n12 w=1.6u l=0.13u
MN895 (n893 n886 vss vss) n12 w=1.6u l=0.13u
MP896 (n892 n880 vdd vdd) p12 w=2.4u l=0.13u
MP897 (n892 n886 vdd vdd) p12 w=2.4u l=0.13u
MN900 (n898 n709 n899 vss) n12 w=1.6u l=0.13u
MN901 (n899 n736 vss vss) n12 w=1.6u l=0.13u
MP902 (n898 n709 vdd vdd) p12 w=2.4u l=0.13u
MP903 (n898 n736 vdd vdd) p12 w=2.4u l=0.13u
MN906 (n904 n709 n905 vss) n12 w=1.6u l=0.13u
MN907 (n905 n898 vss vss) n12 w=1.6u l=0.13u
MP908 (n904 n709 vdd vdd) p12 w=2.4u l=0.13u
MP909 (n904 n898 vdd vdd) p12 w=2.4u l=0.13u
MN912 (n910 n736 n911 vss) n12 w=1.6u l=0.13u
MN913 (n911 n898 vss vss) n12 w=1.6u l=0.13u
MP914 (n910 n736 vdd vdd) p12 w=2.4u l=0.13u
MP915 (n910 n898 vdd vdd) p12 w=2.4u l=0.13u
MN918 (n916 n904 n917 vss) n12 w=1.6u l=0.13u
MN919 (n917 n910 vss vss) n12 w=1.6u l=0.13u
MP920 (n916 n904 vdd vdd) p12 w=2.4u l=0.13u
MP921 (n916 n910 vdd vdd) p12 w=2.4u l=0.13u
MN924 (n922 n736 n923 vss) n12 w=1.6u l=0.13u
MN925 (n923 n763 vss vss) n12 w=1.6u l=0.13u
MP926 (n922 n736 vdd vdd) p12 w=2.4u l=0.13u
MP927 (n922 n763 vdd vdd) p12 w=2.4u l=0.13u
MN930 (n928 n736 n929 vss) n12 w=1.6u l=0.13u
MN931 (n929 n922 vss vss) n12 w=1.6u l=0.13u
MP932 (n928 n736 vdd vdd) p12 w=2.4u l=0.13u
MP933 (n928 n922 vdd vdd) p12 w=2.4u l=0.13u
MN936 (n934 n763 n935 vss) n12 w=1.6u l=0.13u
MN937 (n935 n922 vss vss) n12 w=1.6u l=0.13u
MP938 (n934 n763 vdd vdd) p12 w=2.4u l=0.13u
MP939 (n934 n922 vdd vdd) p12 w=2.4u l=0.13u
MN942 (n940 n928 n941 vss) n12 w=1.6u l=0.13u
MN943 (n941 n934 vss vss) n12 w=1.6u l=0.13u
MP944 (n940 n928 vdd vdd) p12 w=2.4u l=0.13u
MP945 (n940 n934 vdd vdd) p12 w=2.4u l=0.13u
MN948 (n946 n763 n947 vss) n12 w=1.6u l=0.13u
MN949 (n947 n790 vss vss) n12 w=1.6u l=0.13u
MP950 (n946 n763 vdd vdd) p12 w=2.4u l=0.13u
MP951 (n946 n790 vdd vdd) p12 w=2.4u l=0.13u
MN954 (n952 n763 n953 vss) n12 w=1.6u l=0.13u
MN955 (n953 n946 vss vss) n12 w=1.6u l=0.13u
MP956 (n952 n763 vdd vdd) p12 w=2.4u l=0.13u
MP957 (n952 n946 vdd vdd) p12 w=2.4u l=0.13u
MN960 (n958 n790 n959 vss) n12 w=1.6u l=0.13u
MN961 (n959 n946 vss vss) n12 w=1.6u l=0.13u
MP962 (n958 n790 vdd vdd) p12 w=2.4u l=0.13u
MP963 (n958 n946 vdd vdd) p12 w=2.4u l=0.13u
MN966 (n964 n952 n965 vss) n12 w=1.6u l=0.13u
MN967 (n965 n958 vss vss) n12 w=1.6u l=0.13u
MP968 (n964 n952 vdd vdd) p12 w=2.4u l=0.13u
MP969 (n964 n958 vdd vdd) p12 w=2.4u l=0.13u
MN972 (n970 n790 n971 vss) n12 w=1.6u l=0.13u
MN973 (n971 n817 vss vss) n12 w=1.6u l=0.13u
MP974 (n970 n790 vdd vdd) p12 w=2.4u l=0.13u
MP975 (n970 n817 vdd vdd) p12 w=2.4u l=0.13u
MN978 (n976 n790 n977 vss) n12 w=1.6u l=0.13u
MN979 (n977 n970 vss vss) n12 w=1.6u l=0.13u
MP980 (n976 n790 vdd vdd) p12 w=2.4u l=0.13u
MP981 (n976 n970 vdd vdd) p12 w=2.4u l=0.13u
MN984 (n982 n817 n983 vss) n12 w=1.6u l=0.13u
MN985 (n983 n970 vss vss) n12 w=1.6u l=0.13u
MP986 (n982 n817 vdd vdd) p12 w=2.4u l=0.13u
MP987 (n982 n970 vdd vdd) p12 w=2.4u l=0.13u
MN990 (n988 n976 n989 vss) n12 w=1.6u l=0.13u
MN991 (n989 n982 vss vss) n12 w=1.6u l=0.13u
MP992 (n988 n976 vdd vdd) p12 w=2.4u l=0.13u
MP993 (n988 n982 vdd vdd) p12 w=2.4u l=0.13u
MN995 (n994 n454 vss vss) n12 w=0.8u l=0.13u
MP996 (n994 n454 vdd vdd) p12 w=2.4u l=0.13u
MN998 (n997 reference_count_rst vss vss) n12 w=0.8u l=0.13u
MP999 (n997 reference_count_rst vdd vdd) p12 w=2.4u l=0.13u
MN1002 (n1000 n994 n1001 vss) n12 w=1.6u l=0.13u
MN1003 (n1001 n997 vss vss) n12 w=1.6u l=0.13u
MP1004 (n1000 n994 vdd vdd) p12 w=2.4u l=0.13u
MP1005 (n1000 n997 vdd vdd) p12 w=2.4u l=0.13u
MN1007 (n1006 n1000 vss vss) n12 w=0.8u l=0.13u
MP1008 (n1006 n1000 vdd vdd) p12 w=2.4u l=0.13u
MN1011 (n1009 n454 n1010 vss) n12 w=1.6u l=0.13u
MN1012 (n1010 n997 vss vss) n12 w=1.6u l=0.13u
MP1013 (n1009 n454 vdd vdd) p12 w=2.4u l=0.13u
MP1014 (n1009 n997 vdd vdd) p12 w=2.4u l=0.13u
MN1016 (n1015 n1009 vss vss) n12 w=0.8u l=0.13u
MP1017 (n1015 n1009 vdd vdd) p12 w=2.4u l=0.13u
MN1019 (n1018 n1006 vss vss) n12 w=0.8u l=0.13u
MP1020 (n1018 n1006 vdd vdd) p12 w=2.4u l=0.13u
MN1022 (n1021 n1015 vss vss) n12 w=0.8u l=0.13u
MP1023 (n1021 n1015 vdd vdd) p12 w=2.4u l=0.13u
MN1027 (n1026 n844 vss vss) n12 w=0.8u l=0.13u
MP1028 (n1026 n844 vdd vdd) p12 w=2.4u l=0.13u
MN1031 (n1026 n1006 storage1030 vss) n12 w=1.2u l=0.13u
MP1032 (n1026 n1018 storage1030 vdd) p12 w=3.6u l=0.13u
MN1033 (qm1024 n1015 storage1030 vss) n12 w=1.2u l=0.13u
MP1034 (qm1024 n1021 storage1030 vdd) p12 w=3.6u l=0.13u
MN1035 (qmb1025 storage1030 vss vss) n12 w=0.5u l=0.13u
MP1036 (qmb1025 storage1030 vdd vdd) p12 w=1.5u l=0.13u
MN1037 (qm1024 qmb1025 vss vss) n12 w=0.5u l=0.13u
MP1038 (qm1024 qmb1025 vdd vdd) p12 w=1.5u l=0.13u
MN1039 (storage1030 reference_count_rst vss vss) n12 w=2u l=0.13u
MN1041 (qm1024 n1015 storage1040 vss) n12 w=1.2u l=0.13u
MP1042 (qm1024 n1021 storage1040 vdd) p12 w=3.6u l=0.13u
MN1043 (qneg1029 n1006 storage1040 vss) n12 w=1.2u l=0.13u
MP1044 (qneg1029 n1018 storage1040 vdd) p12 w=3.6u l=0.13u
MN1045 (lead_g0 storage1040 vss vss) n12 w=0.5u l=0.13u
MP1046 (lead_g0 storage1040 vdd vdd) p12 w=1.5u l=0.13u
MN1047 (qneg1029 lead_g0 vss vss) n12 w=0.5u l=0.13u
MP1048 (qneg1029 lead_g0 vdd vdd) p12 w=1.5u l=0.13u
MN1049 (storage1040 reference_count_rst vss vss) n12 w=2u l=0.13u
MN1054 (n868 n1006 storage1053 vss) n12 w=1.2u l=0.13u
MP1055 (n868 n1018 storage1053 vdd) p12 w=3.6u l=0.13u
MN1056 (qm1050 n1015 storage1053 vss) n12 w=1.2u l=0.13u
MP1057 (qm1050 n1021 storage1053 vdd) p12 w=3.6u l=0.13u
MN1058 (qmb1051 storage1053 vss vss) n12 w=0.5u l=0.13u
MP1059 (qmb1051 storage1053 vdd vdd) p12 w=1.5u l=0.13u
MN1060 (qm1050 qmb1051 vss vss) n12 w=0.5u l=0.13u
MP1061 (qm1050 qmb1051 vdd vdd) p12 w=1.5u l=0.13u
MN1062 (storage1053 reference_count_rst vss vss) n12 w=2u l=0.13u
MN1064 (qm1050 n1015 storage1063 vss) n12 w=1.2u l=0.13u
MP1065 (qm1050 n1021 storage1063 vdd) p12 w=3.6u l=0.13u
MN1066 (lead_g1 n1006 storage1063 vss) n12 w=1.2u l=0.13u
MP1067 (lead_g1 n1018 storage1063 vdd) p12 w=3.6u l=0.13u
MN1068 (qb1052 storage1063 vss vss) n12 w=0.5u l=0.13u
MP1069 (qb1052 storage1063 vdd vdd) p12 w=1.5u l=0.13u
MN1070 (lead_g1 qb1052 vss vss) n12 w=0.5u l=0.13u
MP1071 (lead_g1 qb1052 vdd vdd) p12 w=1.5u l=0.13u
MN1072 (storage1063 reference_count_rst vss vss) n12 w=2u l=0.13u
MN1077 (n892 n1006 storage1076 vss) n12 w=1.2u l=0.13u
MP1078 (n892 n1018 storage1076 vdd) p12 w=3.6u l=0.13u
MN1079 (qm1073 n1015 storage1076 vss) n12 w=1.2u l=0.13u
MP1080 (qm1073 n1021 storage1076 vdd) p12 w=3.6u l=0.13u
MN1081 (qmb1074 storage1076 vss vss) n12 w=0.5u l=0.13u
MP1082 (qmb1074 storage1076 vdd vdd) p12 w=1.5u l=0.13u
MN1083 (qm1073 qmb1074 vss vss) n12 w=0.5u l=0.13u
MP1084 (qm1073 qmb1074 vdd vdd) p12 w=1.5u l=0.13u
MN1085 (storage1076 reference_count_rst vss vss) n12 w=2u l=0.13u
MN1087 (qm1073 n1015 storage1086 vss) n12 w=1.2u l=0.13u
MP1088 (qm1073 n1021 storage1086 vdd) p12 w=3.6u l=0.13u
MN1089 (lead_g2 n1006 storage1086 vss) n12 w=1.2u l=0.13u
MP1090 (lead_g2 n1018 storage1086 vdd) p12 w=3.6u l=0.13u
MN1091 (qb1075 storage1086 vss vss) n12 w=0.5u l=0.13u
MP1092 (qb1075 storage1086 vdd vdd) p12 w=1.5u l=0.13u
MN1093 (lead_g2 qb1075 vss vss) n12 w=0.5u l=0.13u
MP1094 (lead_g2 qb1075 vdd vdd) p12 w=1.5u l=0.13u
MN1095 (storage1086 reference_count_rst vss vss) n12 w=2u l=0.13u
MN1100 (n916 n1006 storage1099 vss) n12 w=1.2u l=0.13u
MP1101 (n916 n1018 storage1099 vdd) p12 w=3.6u l=0.13u
MN1102 (qm1096 n1015 storage1099 vss) n12 w=1.2u l=0.13u
MP1103 (qm1096 n1021 storage1099 vdd) p12 w=3.6u l=0.13u
MN1104 (qmb1097 storage1099 vss vss) n12 w=0.5u l=0.13u
MP1105 (qmb1097 storage1099 vdd vdd) p12 w=1.5u l=0.13u
MN1106 (qm1096 qmb1097 vss vss) n12 w=0.5u l=0.13u
MP1107 (qm1096 qmb1097 vdd vdd) p12 w=1.5u l=0.13u
MN1108 (storage1099 reference_count_rst vss vss) n12 w=2u l=0.13u
MN1110 (qm1096 n1015 storage1109 vss) n12 w=1.2u l=0.13u
MP1111 (qm1096 n1021 storage1109 vdd) p12 w=3.6u l=0.13u
MN1112 (lead_g3 n1006 storage1109 vss) n12 w=1.2u l=0.13u
MP1113 (lead_g3 n1018 storage1109 vdd) p12 w=3.6u l=0.13u
MN1114 (qb1098 storage1109 vss vss) n12 w=0.5u l=0.13u
MP1115 (qb1098 storage1109 vdd vdd) p12 w=1.5u l=0.13u
MN1116 (lead_g3 qb1098 vss vss) n12 w=0.5u l=0.13u
MP1117 (lead_g3 qb1098 vdd vdd) p12 w=1.5u l=0.13u
MN1118 (storage1109 reference_count_rst vss vss) n12 w=2u l=0.13u
MN1123 (n940 n1006 storage1122 vss) n12 w=1.2u l=0.13u
MP1124 (n940 n1018 storage1122 vdd) p12 w=3.6u l=0.13u
MN1125 (qm1119 n1015 storage1122 vss) n12 w=1.2u l=0.13u
MP1126 (qm1119 n1021 storage1122 vdd) p12 w=3.6u l=0.13u
MN1127 (qmb1120 storage1122 vss vss) n12 w=0.5u l=0.13u
MP1128 (qmb1120 storage1122 vdd vdd) p12 w=1.5u l=0.13u
MN1129 (qm1119 qmb1120 vss vss) n12 w=0.5u l=0.13u
MP1130 (qm1119 qmb1120 vdd vdd) p12 w=1.5u l=0.13u
MN1131 (storage1122 reference_count_rst vss vss) n12 w=2u l=0.13u
MN1133 (qm1119 n1015 storage1132 vss) n12 w=1.2u l=0.13u
MP1134 (qm1119 n1021 storage1132 vdd) p12 w=3.6u l=0.13u
MN1135 (lead_g4 n1006 storage1132 vss) n12 w=1.2u l=0.13u
MP1136 (lead_g4 n1018 storage1132 vdd) p12 w=3.6u l=0.13u
MN1137 (qb1121 storage1132 vss vss) n12 w=0.5u l=0.13u
MP1138 (qb1121 storage1132 vdd vdd) p12 w=1.5u l=0.13u
MN1139 (lead_g4 qb1121 vss vss) n12 w=0.5u l=0.13u
MP1140 (lead_g4 qb1121 vdd vdd) p12 w=1.5u l=0.13u
MN1141 (storage1132 reference_count_rst vss vss) n12 w=2u l=0.13u
MN1146 (n964 n1006 storage1145 vss) n12 w=1.2u l=0.13u
MP1147 (n964 n1018 storage1145 vdd) p12 w=3.6u l=0.13u
MN1148 (qm1142 n1015 storage1145 vss) n12 w=1.2u l=0.13u
MP1149 (qm1142 n1021 storage1145 vdd) p12 w=3.6u l=0.13u
MN1150 (qmb1143 storage1145 vss vss) n12 w=0.5u l=0.13u
MP1151 (qmb1143 storage1145 vdd vdd) p12 w=1.5u l=0.13u
MN1152 (qm1142 qmb1143 vss vss) n12 w=0.5u l=0.13u
MP1153 (qm1142 qmb1143 vdd vdd) p12 w=1.5u l=0.13u
MN1154 (storage1145 reference_count_rst vss vss) n12 w=2u l=0.13u
MN1156 (qm1142 n1015 storage1155 vss) n12 w=1.2u l=0.13u
MP1157 (qm1142 n1021 storage1155 vdd) p12 w=3.6u l=0.13u
MN1158 (lead_g5 n1006 storage1155 vss) n12 w=1.2u l=0.13u
MP1159 (lead_g5 n1018 storage1155 vdd) p12 w=3.6u l=0.13u
MN1160 (qb1144 storage1155 vss vss) n12 w=0.5u l=0.13u
MP1161 (qb1144 storage1155 vdd vdd) p12 w=1.5u l=0.13u
MN1162 (lead_g5 qb1144 vss vss) n12 w=0.5u l=0.13u
MP1163 (lead_g5 qb1144 vdd vdd) p12 w=1.5u l=0.13u
MN1164 (storage1155 reference_count_rst vss vss) n12 w=2u l=0.13u
MN1169 (n988 n1006 storage1168 vss) n12 w=1.2u l=0.13u
MP1170 (n988 n1018 storage1168 vdd) p12 w=3.6u l=0.13u
MN1171 (qm1165 n1015 storage1168 vss) n12 w=1.2u l=0.13u
MP1172 (qm1165 n1021 storage1168 vdd) p12 w=3.6u l=0.13u
MN1173 (qmb1166 storage1168 vss vss) n12 w=0.5u l=0.13u
MP1174 (qmb1166 storage1168 vdd vdd) p12 w=1.5u l=0.13u
MN1175 (qm1165 qmb1166 vss vss) n12 w=0.5u l=0.13u
MP1176 (qm1165 qmb1166 vdd vdd) p12 w=1.5u l=0.13u
MN1177 (storage1168 reference_count_rst vss vss) n12 w=2u l=0.13u
MN1179 (qm1165 n1015 storage1178 vss) n12 w=1.2u l=0.13u
MP1180 (qm1165 n1021 storage1178 vdd) p12 w=3.6u l=0.13u
MN1181 (lead_g6 n1006 storage1178 vss) n12 w=1.2u l=0.13u
MP1182 (lead_g6 n1018 storage1178 vdd) p12 w=3.6u l=0.13u
MN1183 (qb1167 storage1178 vss vss) n12 w=0.5u l=0.13u
MP1184 (qb1167 storage1178 vdd vdd) p12 w=1.5u l=0.13u
MN1185 (lead_g6 qb1167 vss vss) n12 w=0.5u l=0.13u
MP1186 (lead_g6 qb1167 vdd vdd) p12 w=1.5u l=0.13u
MN1187 (storage1178 reference_count_rst vss vss) n12 w=2u l=0.13u
MN1192 (n817 n1006 storage1191 vss) n12 w=1.2u l=0.13u
MP1193 (n817 n1018 storage1191 vdd) p12 w=3.6u l=0.13u
MN1194 (qm1188 n1015 storage1191 vss) n12 w=1.2u l=0.13u
MP1195 (qm1188 n1021 storage1191 vdd) p12 w=3.6u l=0.13u
MN1196 (qmb1189 storage1191 vss vss) n12 w=0.5u l=0.13u
MP1197 (qmb1189 storage1191 vdd vdd) p12 w=1.5u l=0.13u
MN1198 (qm1188 qmb1189 vss vss) n12 w=0.5u l=0.13u
MP1199 (qm1188 qmb1189 vdd vdd) p12 w=1.5u l=0.13u
MN1200 (storage1191 reference_count_rst vss vss) n12 w=2u l=0.13u
MN1202 (qm1188 n1015 storage1201 vss) n12 w=1.2u l=0.13u
MP1203 (qm1188 n1021 storage1201 vdd) p12 w=3.6u l=0.13u
MN1204 (lead_g7 n1006 storage1201 vss) n12 w=1.2u l=0.13u
MP1205 (lead_g7 n1018 storage1201 vdd) p12 w=3.6u l=0.13u
MN1206 (qb1190 storage1201 vss vss) n12 w=0.5u l=0.13u
MP1207 (qb1190 storage1201 vdd vdd) p12 w=1.5u l=0.13u
MN1208 (lead_g7 qb1190 vss vss) n12 w=0.5u l=0.13u
MP1209 (lead_g7 qb1190 vdd vdd) p12 w=1.5u l=0.13u
MN1210 (storage1201 reference_count_rst vss vss) n12 w=2u l=0.13u
MN1213 (n1211 lag_g6 n1212 vss) n12 w=1.6u l=0.13u
MN1214 (n1212 lag_g7 vss vss) n12 w=1.6u l=0.13u
MP1215 (n1211 lag_g6 vdd vdd) p12 w=2.4u l=0.13u
MP1216 (n1211 lag_g7 vdd vdd) p12 w=2.4u l=0.13u
MN1219 (n1217 lag_g6 n1218 vss) n12 w=1.6u l=0.13u
MN1220 (n1218 n1211 vss vss) n12 w=1.6u l=0.13u
MP1221 (n1217 lag_g6 vdd vdd) p12 w=2.4u l=0.13u
MP1222 (n1217 n1211 vdd vdd) p12 w=2.4u l=0.13u
MN1225 (n1223 lag_g7 n1224 vss) n12 w=1.6u l=0.13u
MN1226 (n1224 n1211 vss vss) n12 w=1.6u l=0.13u
MP1227 (n1223 lag_g7 vdd vdd) p12 w=2.4u l=0.13u
MP1228 (n1223 n1211 vdd vdd) p12 w=2.4u l=0.13u
MN1231 (n1229 n1217 n1230 vss) n12 w=1.6u l=0.13u
MN1232 (n1230 n1223 vss vss) n12 w=1.6u l=0.13u
MP1233 (n1229 n1217 vdd vdd) p12 w=2.4u l=0.13u
MP1234 (n1229 n1223 vdd vdd) p12 w=2.4u l=0.13u
MN1237 (n1235 lag_g5 n1236 vss) n12 w=1.6u l=0.13u
MN1238 (n1236 n1229 vss vss) n12 w=1.6u l=0.13u
MP1239 (n1235 lag_g5 vdd vdd) p12 w=2.4u l=0.13u
MP1240 (n1235 n1229 vdd vdd) p12 w=2.4u l=0.13u
MN1243 (n1241 lag_g5 n1242 vss) n12 w=1.6u l=0.13u
MN1244 (n1242 n1235 vss vss) n12 w=1.6u l=0.13u
MP1245 (n1241 lag_g5 vdd vdd) p12 w=2.4u l=0.13u
MP1246 (n1241 n1235 vdd vdd) p12 w=2.4u l=0.13u
MN1249 (n1247 n1229 n1248 vss) n12 w=1.6u l=0.13u
MN1250 (n1248 n1235 vss vss) n12 w=1.6u l=0.13u
MP1251 (n1247 n1229 vdd vdd) p12 w=2.4u l=0.13u
MP1252 (n1247 n1235 vdd vdd) p12 w=2.4u l=0.13u
MN1255 (n1253 n1241 n1254 vss) n12 w=1.6u l=0.13u
MN1256 (n1254 n1247 vss vss) n12 w=1.6u l=0.13u
MP1257 (n1253 n1241 vdd vdd) p12 w=2.4u l=0.13u
MP1258 (n1253 n1247 vdd vdd) p12 w=2.4u l=0.13u
MN1261 (n1259 lag_g4 n1260 vss) n12 w=1.6u l=0.13u
MN1262 (n1260 n1253 vss vss) n12 w=1.6u l=0.13u
MP1263 (n1259 lag_g4 vdd vdd) p12 w=2.4u l=0.13u
MP1264 (n1259 n1253 vdd vdd) p12 w=2.4u l=0.13u
MN1267 (n1265 lag_g4 n1266 vss) n12 w=1.6u l=0.13u
MN1268 (n1266 n1259 vss vss) n12 w=1.6u l=0.13u
MP1269 (n1265 lag_g4 vdd vdd) p12 w=2.4u l=0.13u
MP1270 (n1265 n1259 vdd vdd) p12 w=2.4u l=0.13u
MN1273 (n1271 n1253 n1272 vss) n12 w=1.6u l=0.13u
MN1274 (n1272 n1259 vss vss) n12 w=1.6u l=0.13u
MP1275 (n1271 n1253 vdd vdd) p12 w=2.4u l=0.13u
MP1276 (n1271 n1259 vdd vdd) p12 w=2.4u l=0.13u
MN1279 (n1277 n1265 n1278 vss) n12 w=1.6u l=0.13u
MN1280 (n1278 n1271 vss vss) n12 w=1.6u l=0.13u
MP1281 (n1277 n1265 vdd vdd) p12 w=2.4u l=0.13u
MP1282 (n1277 n1271 vdd vdd) p12 w=2.4u l=0.13u
MN1285 (n1283 lag_g3 n1284 vss) n12 w=1.6u l=0.13u
MN1286 (n1284 n1277 vss vss) n12 w=1.6u l=0.13u
MP1287 (n1283 lag_g3 vdd vdd) p12 w=2.4u l=0.13u
MP1288 (n1283 n1277 vdd vdd) p12 w=2.4u l=0.13u
MN1291 (n1289 lag_g3 n1290 vss) n12 w=1.6u l=0.13u
MN1292 (n1290 n1283 vss vss) n12 w=1.6u l=0.13u
MP1293 (n1289 lag_g3 vdd vdd) p12 w=2.4u l=0.13u
MP1294 (n1289 n1283 vdd vdd) p12 w=2.4u l=0.13u
MN1297 (n1295 n1277 n1296 vss) n12 w=1.6u l=0.13u
MN1298 (n1296 n1283 vss vss) n12 w=1.6u l=0.13u
MP1299 (n1295 n1277 vdd vdd) p12 w=2.4u l=0.13u
MP1300 (n1295 n1283 vdd vdd) p12 w=2.4u l=0.13u
MN1303 (n1301 n1289 n1302 vss) n12 w=1.6u l=0.13u
MN1304 (n1302 n1295 vss vss) n12 w=1.6u l=0.13u
MP1305 (n1301 n1289 vdd vdd) p12 w=2.4u l=0.13u
MP1306 (n1301 n1295 vdd vdd) p12 w=2.4u l=0.13u
MN1309 (n1307 lag_g2 n1308 vss) n12 w=1.6u l=0.13u
MN1310 (n1308 n1301 vss vss) n12 w=1.6u l=0.13u
MP1311 (n1307 lag_g2 vdd vdd) p12 w=2.4u l=0.13u
MP1312 (n1307 n1301 vdd vdd) p12 w=2.4u l=0.13u
MN1315 (n1313 lag_g2 n1314 vss) n12 w=1.6u l=0.13u
MN1316 (n1314 n1307 vss vss) n12 w=1.6u l=0.13u
MP1317 (n1313 lag_g2 vdd vdd) p12 w=2.4u l=0.13u
MP1318 (n1313 n1307 vdd vdd) p12 w=2.4u l=0.13u
MN1321 (n1319 n1301 n1320 vss) n12 w=1.6u l=0.13u
MN1322 (n1320 n1307 vss vss) n12 w=1.6u l=0.13u
MP1323 (n1319 n1301 vdd vdd) p12 w=2.4u l=0.13u
MP1324 (n1319 n1307 vdd vdd) p12 w=2.4u l=0.13u
MN1327 (n1325 n1313 n1326 vss) n12 w=1.6u l=0.13u
MN1328 (n1326 n1319 vss vss) n12 w=1.6u l=0.13u
MP1329 (n1325 n1313 vdd vdd) p12 w=2.4u l=0.13u
MP1330 (n1325 n1319 vdd vdd) p12 w=2.4u l=0.13u
MN1333 (n1331 lag_g1 n1332 vss) n12 w=1.6u l=0.13u
MN1334 (n1332 n1325 vss vss) n12 w=1.6u l=0.13u
MP1335 (n1331 lag_g1 vdd vdd) p12 w=2.4u l=0.13u
MP1336 (n1331 n1325 vdd vdd) p12 w=2.4u l=0.13u
MN1339 (n1337 lag_g1 n1338 vss) n12 w=1.6u l=0.13u
MN1340 (n1338 n1331 vss vss) n12 w=1.6u l=0.13u
MP1341 (n1337 lag_g1 vdd vdd) p12 w=2.4u l=0.13u
MP1342 (n1337 n1331 vdd vdd) p12 w=2.4u l=0.13u
MN1345 (n1343 n1325 n1344 vss) n12 w=1.6u l=0.13u
MN1346 (n1344 n1331 vss vss) n12 w=1.6u l=0.13u
MP1347 (n1343 n1325 vdd vdd) p12 w=2.4u l=0.13u
MP1348 (n1343 n1331 vdd vdd) p12 w=2.4u l=0.13u
MN1351 (n1349 n1337 n1350 vss) n12 w=1.6u l=0.13u
MN1352 (n1350 n1343 vss vss) n12 w=1.6u l=0.13u
MP1353 (n1349 n1337 vdd vdd) p12 w=2.4u l=0.13u
MP1354 (n1349 n1343 vdd vdd) p12 w=2.4u l=0.13u
MN1357 (n1355 lag_g0 n1356 vss) n12 w=1.6u l=0.13u
MN1358 (n1356 n1349 vss vss) n12 w=1.6u l=0.13u
MP1359 (n1355 lag_g0 vdd vdd) p12 w=2.4u l=0.13u
MP1360 (n1355 n1349 vdd vdd) p12 w=2.4u l=0.13u
MN1363 (n1361 lag_g0 n1362 vss) n12 w=1.6u l=0.13u
MN1364 (n1362 n1355 vss vss) n12 w=1.6u l=0.13u
MP1365 (n1361 lag_g0 vdd vdd) p12 w=2.4u l=0.13u
MP1366 (n1361 n1355 vdd vdd) p12 w=2.4u l=0.13u
MN1369 (n1367 n1349 n1368 vss) n12 w=1.6u l=0.13u
MN1370 (n1368 n1355 vss vss) n12 w=1.6u l=0.13u
MP1371 (n1367 n1349 vdd vdd) p12 w=2.4u l=0.13u
MP1372 (n1367 n1355 vdd vdd) p12 w=2.4u l=0.13u
MN1375 (n1373 n1361 n1374 vss) n12 w=1.6u l=0.13u
MN1376 (n1374 n1367 vss vss) n12 w=1.6u l=0.13u
MP1377 (n1373 n1361 vdd vdd) p12 w=2.4u l=0.13u
MP1378 (n1373 n1367 vdd vdd) p12 w=2.4u l=0.13u
MN1380 (n1379 n1373 vss vss) n12 w=0.8u l=0.13u
MP1381 (n1379 n1373 vdd vdd) p12 w=2.4u l=0.13u
MN1384 (n1382 n1349 n1383 vss) n12 w=1.6u l=0.13u
MN1385 (n1383 n1373 vss vss) n12 w=1.6u l=0.13u
MP1386 (n1382 n1349 vdd vdd) p12 w=2.4u l=0.13u
MP1387 (n1382 n1373 vdd vdd) p12 w=2.4u l=0.13u
MN1390 (n1388 n1349 n1389 vss) n12 w=1.6u l=0.13u
MN1391 (n1389 n1382 vss vss) n12 w=1.6u l=0.13u
MP1392 (n1388 n1349 vdd vdd) p12 w=2.4u l=0.13u
MP1393 (n1388 n1382 vdd vdd) p12 w=2.4u l=0.13u
MN1396 (n1394 n1373 n1395 vss) n12 w=1.6u l=0.13u
MN1397 (n1395 n1382 vss vss) n12 w=1.6u l=0.13u
MP1398 (n1394 n1373 vdd vdd) p12 w=2.4u l=0.13u
MP1399 (n1394 n1382 vdd vdd) p12 w=2.4u l=0.13u
MN1402 (n1400 n1388 n1401 vss) n12 w=1.6u l=0.13u
MN1403 (n1401 n1394 vss vss) n12 w=1.6u l=0.13u
MP1404 (n1400 n1388 vdd vdd) p12 w=2.4u l=0.13u
MP1405 (n1400 n1394 vdd vdd) p12 w=2.4u l=0.13u
MN1407 (n1406 n1382 vss vss) n12 w=0.8u l=0.13u
MP1408 (n1406 n1382 vdd vdd) p12 w=2.4u l=0.13u
MN1411 (n1409 n1325 n1410 vss) n12 w=1.6u l=0.13u
MN1412 (n1410 n1406 vss vss) n12 w=1.6u l=0.13u
MP1413 (n1409 n1325 vdd vdd) p12 w=2.4u l=0.13u
MP1414 (n1409 n1406 vdd vdd) p12 w=2.4u l=0.13u
MN1417 (n1415 n1325 n1416 vss) n12 w=1.6u l=0.13u
MN1418 (n1416 n1409 vss vss) n12 w=1.6u l=0.13u
MP1419 (n1415 n1325 vdd vdd) p12 w=2.4u l=0.13u
MP1420 (n1415 n1409 vdd vdd) p12 w=2.4u l=0.13u
MN1423 (n1421 n1406 n1422 vss) n12 w=1.6u l=0.13u
MN1424 (n1422 n1409 vss vss) n12 w=1.6u l=0.13u
MP1425 (n1421 n1406 vdd vdd) p12 w=2.4u l=0.13u
MP1426 (n1421 n1409 vdd vdd) p12 w=2.4u l=0.13u
MN1429 (n1427 n1415 n1428 vss) n12 w=1.6u l=0.13u
MN1430 (n1428 n1421 vss vss) n12 w=1.6u l=0.13u
MP1431 (n1427 n1415 vdd vdd) p12 w=2.4u l=0.13u
MP1432 (n1427 n1421 vdd vdd) p12 w=2.4u l=0.13u
MN1434 (n1433 n1409 vss vss) n12 w=0.8u l=0.13u
MP1435 (n1433 n1409 vdd vdd) p12 w=2.4u l=0.13u
MN1438 (n1436 n1301 n1437 vss) n12 w=1.6u l=0.13u
MN1439 (n1437 n1433 vss vss) n12 w=1.6u l=0.13u
MP1440 (n1436 n1301 vdd vdd) p12 w=2.4u l=0.13u
MP1441 (n1436 n1433 vdd vdd) p12 w=2.4u l=0.13u
MN1444 (n1442 n1301 n1443 vss) n12 w=1.6u l=0.13u
MN1445 (n1443 n1436 vss vss) n12 w=1.6u l=0.13u
MP1446 (n1442 n1301 vdd vdd) p12 w=2.4u l=0.13u
MP1447 (n1442 n1436 vdd vdd) p12 w=2.4u l=0.13u
MN1450 (n1448 n1433 n1449 vss) n12 w=1.6u l=0.13u
MN1451 (n1449 n1436 vss vss) n12 w=1.6u l=0.13u
MP1452 (n1448 n1433 vdd vdd) p12 w=2.4u l=0.13u
MP1453 (n1448 n1436 vdd vdd) p12 w=2.4u l=0.13u
MN1456 (n1454 n1442 n1455 vss) n12 w=1.6u l=0.13u
MN1457 (n1455 n1448 vss vss) n12 w=1.6u l=0.13u
MP1458 (n1454 n1442 vdd vdd) p12 w=2.4u l=0.13u
MP1459 (n1454 n1448 vdd vdd) p12 w=2.4u l=0.13u
MN1461 (n1460 n1436 vss vss) n12 w=0.8u l=0.13u
MP1462 (n1460 n1436 vdd vdd) p12 w=2.4u l=0.13u
MN1465 (n1463 n1277 n1464 vss) n12 w=1.6u l=0.13u
MN1466 (n1464 n1460 vss vss) n12 w=1.6u l=0.13u
MP1467 (n1463 n1277 vdd vdd) p12 w=2.4u l=0.13u
MP1468 (n1463 n1460 vdd vdd) p12 w=2.4u l=0.13u
MN1471 (n1469 n1277 n1470 vss) n12 w=1.6u l=0.13u
MN1472 (n1470 n1463 vss vss) n12 w=1.6u l=0.13u
MP1473 (n1469 n1277 vdd vdd) p12 w=2.4u l=0.13u
MP1474 (n1469 n1463 vdd vdd) p12 w=2.4u l=0.13u
MN1477 (n1475 n1460 n1476 vss) n12 w=1.6u l=0.13u
MN1478 (n1476 n1463 vss vss) n12 w=1.6u l=0.13u
MP1479 (n1475 n1460 vdd vdd) p12 w=2.4u l=0.13u
MP1480 (n1475 n1463 vdd vdd) p12 w=2.4u l=0.13u
MN1483 (n1481 n1469 n1482 vss) n12 w=1.6u l=0.13u
MN1484 (n1482 n1475 vss vss) n12 w=1.6u l=0.13u
MP1485 (n1481 n1469 vdd vdd) p12 w=2.4u l=0.13u
MP1486 (n1481 n1475 vdd vdd) p12 w=2.4u l=0.13u
MN1488 (n1487 n1463 vss vss) n12 w=0.8u l=0.13u
MP1489 (n1487 n1463 vdd vdd) p12 w=2.4u l=0.13u
MN1492 (n1490 n1253 n1491 vss) n12 w=1.6u l=0.13u
MN1493 (n1491 n1487 vss vss) n12 w=1.6u l=0.13u
MP1494 (n1490 n1253 vdd vdd) p12 w=2.4u l=0.13u
MP1495 (n1490 n1487 vdd vdd) p12 w=2.4u l=0.13u
MN1498 (n1496 n1253 n1497 vss) n12 w=1.6u l=0.13u
MN1499 (n1497 n1490 vss vss) n12 w=1.6u l=0.13u
MP1500 (n1496 n1253 vdd vdd) p12 w=2.4u l=0.13u
MP1501 (n1496 n1490 vdd vdd) p12 w=2.4u l=0.13u
MN1504 (n1502 n1487 n1503 vss) n12 w=1.6u l=0.13u
MN1505 (n1503 n1490 vss vss) n12 w=1.6u l=0.13u
MP1506 (n1502 n1487 vdd vdd) p12 w=2.4u l=0.13u
MP1507 (n1502 n1490 vdd vdd) p12 w=2.4u l=0.13u
MN1510 (n1508 n1496 n1509 vss) n12 w=1.6u l=0.13u
MN1511 (n1509 n1502 vss vss) n12 w=1.6u l=0.13u
MP1512 (n1508 n1496 vdd vdd) p12 w=2.4u l=0.13u
MP1513 (n1508 n1502 vdd vdd) p12 w=2.4u l=0.13u
MN1515 (n1514 n1490 vss vss) n12 w=0.8u l=0.13u
MP1516 (n1514 n1490 vdd vdd) p12 w=2.4u l=0.13u
MN1519 (n1517 n1229 n1518 vss) n12 w=1.6u l=0.13u
MN1520 (n1518 n1514 vss vss) n12 w=1.6u l=0.13u
MP1521 (n1517 n1229 vdd vdd) p12 w=2.4u l=0.13u
MP1522 (n1517 n1514 vdd vdd) p12 w=2.4u l=0.13u
MN1525 (n1523 n1229 n1524 vss) n12 w=1.6u l=0.13u
MN1526 (n1524 n1517 vss vss) n12 w=1.6u l=0.13u
MP1527 (n1523 n1229 vdd vdd) p12 w=2.4u l=0.13u
MP1528 (n1523 n1517 vdd vdd) p12 w=2.4u l=0.13u
MN1531 (n1529 n1514 n1530 vss) n12 w=1.6u l=0.13u
MN1532 (n1530 n1517 vss vss) n12 w=1.6u l=0.13u
MP1533 (n1529 n1514 vdd vdd) p12 w=2.4u l=0.13u
MP1534 (n1529 n1517 vdd vdd) p12 w=2.4u l=0.13u
MN1537 (n1535 n1523 n1536 vss) n12 w=1.6u l=0.13u
MN1538 (n1536 n1529 vss vss) n12 w=1.6u l=0.13u
MP1539 (n1535 n1523 vdd vdd) p12 w=2.4u l=0.13u
MP1540 (n1535 n1529 vdd vdd) p12 w=2.4u l=0.13u
MN1542 (n1541 n1517 vss vss) n12 w=0.8u l=0.13u
MP1543 (n1541 n1517 vdd vdd) p12 w=2.4u l=0.13u
MN1546 (n1544 lag_g7 n1545 vss) n12 w=1.6u l=0.13u
MN1547 (n1545 n1541 vss vss) n12 w=1.6u l=0.13u
MP1548 (n1544 lag_g7 vdd vdd) p12 w=2.4u l=0.13u
MP1549 (n1544 n1541 vdd vdd) p12 w=2.4u l=0.13u
MN1552 (n1550 lag_g7 n1551 vss) n12 w=1.6u l=0.13u
MN1553 (n1551 n1544 vss vss) n12 w=1.6u l=0.13u
MP1554 (n1550 lag_g7 vdd vdd) p12 w=2.4u l=0.13u
MP1555 (n1550 n1544 vdd vdd) p12 w=2.4u l=0.13u
MN1558 (n1556 n1541 n1557 vss) n12 w=1.6u l=0.13u
MN1559 (n1557 n1544 vss vss) n12 w=1.6u l=0.13u
MP1560 (n1556 n1541 vdd vdd) p12 w=2.4u l=0.13u
MP1561 (n1556 n1544 vdd vdd) p12 w=2.4u l=0.13u
MN1564 (n1562 n1550 n1563 vss) n12 w=1.6u l=0.13u
MN1565 (n1563 n1556 vss vss) n12 w=1.6u l=0.13u
MP1566 (n1562 n1550 vdd vdd) p12 w=2.4u l=0.13u
MP1567 (n1562 n1556 vdd vdd) p12 w=2.4u l=0.13u
MN1569 (n1568 n1544 vss vss) n12 w=0.8u l=0.13u
MP1570 (n1568 n1544 vdd vdd) p12 w=2.4u l=0.13u
MN1573 (n1571 n1379 n1572 vss) n12 w=1.6u l=0.13u
MN1574 (n1572 n1400 vss vss) n12 w=1.6u l=0.13u
MP1575 (n1571 n1379 vdd vdd) p12 w=2.4u l=0.13u
MP1576 (n1571 n1400 vdd vdd) p12 w=2.4u l=0.13u
MN1579 (n1577 n1379 n1578 vss) n12 w=1.6u l=0.13u
MN1580 (n1578 n1571 vss vss) n12 w=1.6u l=0.13u
MP1581 (n1577 n1379 vdd vdd) p12 w=2.4u l=0.13u
MP1582 (n1577 n1571 vdd vdd) p12 w=2.4u l=0.13u
MN1585 (n1583 n1400 n1584 vss) n12 w=1.6u l=0.13u
MN1586 (n1584 n1571 vss vss) n12 w=1.6u l=0.13u
MP1587 (n1583 n1400 vdd vdd) p12 w=2.4u l=0.13u
MP1588 (n1583 n1571 vdd vdd) p12 w=2.4u l=0.13u
MN1591 (n1589 n1577 n1590 vss) n12 w=1.6u l=0.13u
MN1592 (n1590 n1583 vss vss) n12 w=1.6u l=0.13u
MP1593 (n1589 n1577 vdd vdd) p12 w=2.4u l=0.13u
MP1594 (n1589 n1583 vdd vdd) p12 w=2.4u l=0.13u
MN1597 (n1595 n1400 n1596 vss) n12 w=1.6u l=0.13u
MN1598 (n1596 n1427 vss vss) n12 w=1.6u l=0.13u
MP1599 (n1595 n1400 vdd vdd) p12 w=2.4u l=0.13u
MP1600 (n1595 n1427 vdd vdd) p12 w=2.4u l=0.13u
MN1603 (n1601 n1400 n1602 vss) n12 w=1.6u l=0.13u
MN1604 (n1602 n1595 vss vss) n12 w=1.6u l=0.13u
MP1605 (n1601 n1400 vdd vdd) p12 w=2.4u l=0.13u
MP1606 (n1601 n1595 vdd vdd) p12 w=2.4u l=0.13u
MN1609 (n1607 n1427 n1608 vss) n12 w=1.6u l=0.13u
MN1610 (n1608 n1595 vss vss) n12 w=1.6u l=0.13u
MP1611 (n1607 n1427 vdd vdd) p12 w=2.4u l=0.13u
MP1612 (n1607 n1595 vdd vdd) p12 w=2.4u l=0.13u
MN1615 (n1613 n1601 n1614 vss) n12 w=1.6u l=0.13u
MN1616 (n1614 n1607 vss vss) n12 w=1.6u l=0.13u
MP1617 (n1613 n1601 vdd vdd) p12 w=2.4u l=0.13u
MP1618 (n1613 n1607 vdd vdd) p12 w=2.4u l=0.13u
MN1621 (n1619 n1427 n1620 vss) n12 w=1.6u l=0.13u
MN1622 (n1620 n1454 vss vss) n12 w=1.6u l=0.13u
MP1623 (n1619 n1427 vdd vdd) p12 w=2.4u l=0.13u
MP1624 (n1619 n1454 vdd vdd) p12 w=2.4u l=0.13u
MN1627 (n1625 n1427 n1626 vss) n12 w=1.6u l=0.13u
MN1628 (n1626 n1619 vss vss) n12 w=1.6u l=0.13u
MP1629 (n1625 n1427 vdd vdd) p12 w=2.4u l=0.13u
MP1630 (n1625 n1619 vdd vdd) p12 w=2.4u l=0.13u
MN1633 (n1631 n1454 n1632 vss) n12 w=1.6u l=0.13u
MN1634 (n1632 n1619 vss vss) n12 w=1.6u l=0.13u
MP1635 (n1631 n1454 vdd vdd) p12 w=2.4u l=0.13u
MP1636 (n1631 n1619 vdd vdd) p12 w=2.4u l=0.13u
MN1639 (n1637 n1625 n1638 vss) n12 w=1.6u l=0.13u
MN1640 (n1638 n1631 vss vss) n12 w=1.6u l=0.13u
MP1641 (n1637 n1625 vdd vdd) p12 w=2.4u l=0.13u
MP1642 (n1637 n1631 vdd vdd) p12 w=2.4u l=0.13u
MN1645 (n1643 n1454 n1644 vss) n12 w=1.6u l=0.13u
MN1646 (n1644 n1481 vss vss) n12 w=1.6u l=0.13u
MP1647 (n1643 n1454 vdd vdd) p12 w=2.4u l=0.13u
MP1648 (n1643 n1481 vdd vdd) p12 w=2.4u l=0.13u
MN1651 (n1649 n1454 n1650 vss) n12 w=1.6u l=0.13u
MN1652 (n1650 n1643 vss vss) n12 w=1.6u l=0.13u
MP1653 (n1649 n1454 vdd vdd) p12 w=2.4u l=0.13u
MP1654 (n1649 n1643 vdd vdd) p12 w=2.4u l=0.13u
MN1657 (n1655 n1481 n1656 vss) n12 w=1.6u l=0.13u
MN1658 (n1656 n1643 vss vss) n12 w=1.6u l=0.13u
MP1659 (n1655 n1481 vdd vdd) p12 w=2.4u l=0.13u
MP1660 (n1655 n1643 vdd vdd) p12 w=2.4u l=0.13u
MN1663 (n1661 n1649 n1662 vss) n12 w=1.6u l=0.13u
MN1664 (n1662 n1655 vss vss) n12 w=1.6u l=0.13u
MP1665 (n1661 n1649 vdd vdd) p12 w=2.4u l=0.13u
MP1666 (n1661 n1655 vdd vdd) p12 w=2.4u l=0.13u
MN1669 (n1667 n1481 n1668 vss) n12 w=1.6u l=0.13u
MN1670 (n1668 n1508 vss vss) n12 w=1.6u l=0.13u
MP1671 (n1667 n1481 vdd vdd) p12 w=2.4u l=0.13u
MP1672 (n1667 n1508 vdd vdd) p12 w=2.4u l=0.13u
MN1675 (n1673 n1481 n1674 vss) n12 w=1.6u l=0.13u
MN1676 (n1674 n1667 vss vss) n12 w=1.6u l=0.13u
MP1677 (n1673 n1481 vdd vdd) p12 w=2.4u l=0.13u
MP1678 (n1673 n1667 vdd vdd) p12 w=2.4u l=0.13u
MN1681 (n1679 n1508 n1680 vss) n12 w=1.6u l=0.13u
MN1682 (n1680 n1667 vss vss) n12 w=1.6u l=0.13u
MP1683 (n1679 n1508 vdd vdd) p12 w=2.4u l=0.13u
MP1684 (n1679 n1667 vdd vdd) p12 w=2.4u l=0.13u
MN1687 (n1685 n1673 n1686 vss) n12 w=1.6u l=0.13u
MN1688 (n1686 n1679 vss vss) n12 w=1.6u l=0.13u
MP1689 (n1685 n1673 vdd vdd) p12 w=2.4u l=0.13u
MP1690 (n1685 n1679 vdd vdd) p12 w=2.4u l=0.13u
MN1693 (n1691 n1508 n1692 vss) n12 w=1.6u l=0.13u
MN1694 (n1692 n1535 vss vss) n12 w=1.6u l=0.13u
MP1695 (n1691 n1508 vdd vdd) p12 w=2.4u l=0.13u
MP1696 (n1691 n1535 vdd vdd) p12 w=2.4u l=0.13u
MN1699 (n1697 n1508 n1698 vss) n12 w=1.6u l=0.13u
MN1700 (n1698 n1691 vss vss) n12 w=1.6u l=0.13u
MP1701 (n1697 n1508 vdd vdd) p12 w=2.4u l=0.13u
MP1702 (n1697 n1691 vdd vdd) p12 w=2.4u l=0.13u
MN1705 (n1703 n1535 n1704 vss) n12 w=1.6u l=0.13u
MN1706 (n1704 n1691 vss vss) n12 w=1.6u l=0.13u
MP1707 (n1703 n1535 vdd vdd) p12 w=2.4u l=0.13u
MP1708 (n1703 n1691 vdd vdd) p12 w=2.4u l=0.13u
MN1711 (n1709 n1697 n1710 vss) n12 w=1.6u l=0.13u
MN1712 (n1710 n1703 vss vss) n12 w=1.6u l=0.13u
MP1713 (n1709 n1697 vdd vdd) p12 w=2.4u l=0.13u
MP1714 (n1709 n1703 vdd vdd) p12 w=2.4u l=0.13u
MN1717 (n1715 n1535 n1716 vss) n12 w=1.6u l=0.13u
MN1718 (n1716 n1562 vss vss) n12 w=1.6u l=0.13u
MP1719 (n1715 n1535 vdd vdd) p12 w=2.4u l=0.13u
MP1720 (n1715 n1562 vdd vdd) p12 w=2.4u l=0.13u
MN1723 (n1721 n1535 n1722 vss) n12 w=1.6u l=0.13u
MN1724 (n1722 n1715 vss vss) n12 w=1.6u l=0.13u
MP1725 (n1721 n1535 vdd vdd) p12 w=2.4u l=0.13u
MP1726 (n1721 n1715 vdd vdd) p12 w=2.4u l=0.13u
MN1729 (n1727 n1562 n1728 vss) n12 w=1.6u l=0.13u
MN1730 (n1728 n1715 vss vss) n12 w=1.6u l=0.13u
MP1731 (n1727 n1562 vdd vdd) p12 w=2.4u l=0.13u
MP1732 (n1727 n1715 vdd vdd) p12 w=2.4u l=0.13u
MN1735 (n1733 n1721 n1734 vss) n12 w=1.6u l=0.13u
MN1736 (n1734 n1727 vss vss) n12 w=1.6u l=0.13u
MP1737 (n1733 n1721 vdd vdd) p12 w=2.4u l=0.13u
MP1738 (n1733 n1727 vdd vdd) p12 w=2.4u l=0.13u
MN1740 (n1739 n463 vss vss) n12 w=0.8u l=0.13u
MP1741 (n1739 n463 vdd vdd) p12 w=2.4u l=0.13u
MN1744 (n1742 n1739 n1743 vss) n12 w=1.6u l=0.13u
MN1745 (n1743 n997 vss vss) n12 w=1.6u l=0.13u
MP1746 (n1742 n1739 vdd vdd) p12 w=2.4u l=0.13u
MP1747 (n1742 n997 vdd vdd) p12 w=2.4u l=0.13u
MN1749 (n1748 n1742 vss vss) n12 w=0.8u l=0.13u
MP1750 (n1748 n1742 vdd vdd) p12 w=2.4u l=0.13u
MN1753 (n1751 n463 n1752 vss) n12 w=1.6u l=0.13u
MN1754 (n1752 n997 vss vss) n12 w=1.6u l=0.13u
MP1755 (n1751 n463 vdd vdd) p12 w=2.4u l=0.13u
MP1756 (n1751 n997 vdd vdd) p12 w=2.4u l=0.13u
MN1758 (n1757 n1751 vss vss) n12 w=0.8u l=0.13u
MP1759 (n1757 n1751 vdd vdd) p12 w=2.4u l=0.13u
MN1761 (n1760 n1748 vss vss) n12 w=0.8u l=0.13u
MP1762 (n1760 n1748 vdd vdd) p12 w=2.4u l=0.13u
MN1764 (n1763 n1757 vss vss) n12 w=0.8u l=0.13u
MP1765 (n1763 n1757 vdd vdd) p12 w=2.4u l=0.13u
MN1770 (n1589 n1748 storage1769 vss) n12 w=1.2u l=0.13u
MP1771 (n1589 n1760 storage1769 vdd) p12 w=3.6u l=0.13u
MN1772 (qm1766 n1757 storage1769 vss) n12 w=1.2u l=0.13u
MP1773 (qm1766 n1763 storage1769 vdd) p12 w=3.6u l=0.13u
MN1774 (qmb1767 storage1769 vss vss) n12 w=0.5u l=0.13u
MP1775 (qmb1767 storage1769 vdd vdd) p12 w=1.5u l=0.13u
MN1776 (qm1766 qmb1767 vss vss) n12 w=0.5u l=0.13u
MP1777 (qm1766 qmb1767 vdd vdd) p12 w=1.5u l=0.13u
MN1778 (storage1769 reference_count_rst vss vss) n12 w=2u l=0.13u
MN1780 (qm1766 n1757 storage1779 vss) n12 w=1.2u l=0.13u
MP1781 (qm1766 n1763 storage1779 vdd) p12 w=3.6u l=0.13u
MN1782 (lag_g0 n1748 storage1779 vss) n12 w=1.2u l=0.13u
MP1783 (lag_g0 n1760 storage1779 vdd) p12 w=3.6u l=0.13u
MN1784 (qb1768 storage1779 vss vss) n12 w=0.5u l=0.13u
MP1785 (qb1768 storage1779 vdd vdd) p12 w=1.5u l=0.13u
MN1786 (lag_g0 qb1768 vss vss) n12 w=0.5u l=0.13u
MP1787 (lag_g0 qb1768 vdd vdd) p12 w=1.5u l=0.13u
MN1788 (storage1779 reference_count_rst vss vss) n12 w=2u l=0.13u
MN1793 (n1613 n1748 storage1792 vss) n12 w=1.2u l=0.13u
MP1794 (n1613 n1760 storage1792 vdd) p12 w=3.6u l=0.13u
MN1795 (qm1789 n1757 storage1792 vss) n12 w=1.2u l=0.13u
MP1796 (qm1789 n1763 storage1792 vdd) p12 w=3.6u l=0.13u
MN1797 (qmb1790 storage1792 vss vss) n12 w=0.5u l=0.13u
MP1798 (qmb1790 storage1792 vdd vdd) p12 w=1.5u l=0.13u
MN1799 (qm1789 qmb1790 vss vss) n12 w=0.5u l=0.13u
MP1800 (qm1789 qmb1790 vdd vdd) p12 w=1.5u l=0.13u
MN1801 (storage1792 reference_count_rst vss vss) n12 w=2u l=0.13u
MN1803 (qm1789 n1757 storage1802 vss) n12 w=1.2u l=0.13u
MP1804 (qm1789 n1763 storage1802 vdd) p12 w=3.6u l=0.13u
MN1805 (lag_g1 n1748 storage1802 vss) n12 w=1.2u l=0.13u
MP1806 (lag_g1 n1760 storage1802 vdd) p12 w=3.6u l=0.13u
MN1807 (qb1791 storage1802 vss vss) n12 w=0.5u l=0.13u
MP1808 (qb1791 storage1802 vdd vdd) p12 w=1.5u l=0.13u
MN1809 (lag_g1 qb1791 vss vss) n12 w=0.5u l=0.13u
MP1810 (lag_g1 qb1791 vdd vdd) p12 w=1.5u l=0.13u
MN1811 (storage1802 reference_count_rst vss vss) n12 w=2u l=0.13u
MN1816 (n1637 n1748 storage1815 vss) n12 w=1.2u l=0.13u
MP1817 (n1637 n1760 storage1815 vdd) p12 w=3.6u l=0.13u
MN1818 (qm1812 n1757 storage1815 vss) n12 w=1.2u l=0.13u
MP1819 (qm1812 n1763 storage1815 vdd) p12 w=3.6u l=0.13u
MN1820 (qmb1813 storage1815 vss vss) n12 w=0.5u l=0.13u
MP1821 (qmb1813 storage1815 vdd vdd) p12 w=1.5u l=0.13u
MN1822 (qm1812 qmb1813 vss vss) n12 w=0.5u l=0.13u
MP1823 (qm1812 qmb1813 vdd vdd) p12 w=1.5u l=0.13u
MN1824 (storage1815 reference_count_rst vss vss) n12 w=2u l=0.13u
MN1826 (qm1812 n1757 storage1825 vss) n12 w=1.2u l=0.13u
MP1827 (qm1812 n1763 storage1825 vdd) p12 w=3.6u l=0.13u
MN1828 (lag_g2 n1748 storage1825 vss) n12 w=1.2u l=0.13u
MP1829 (lag_g2 n1760 storage1825 vdd) p12 w=3.6u l=0.13u
MN1830 (qb1814 storage1825 vss vss) n12 w=0.5u l=0.13u
MP1831 (qb1814 storage1825 vdd vdd) p12 w=1.5u l=0.13u
MN1832 (lag_g2 qb1814 vss vss) n12 w=0.5u l=0.13u
MP1833 (lag_g2 qb1814 vdd vdd) p12 w=1.5u l=0.13u
MN1834 (storage1825 reference_count_rst vss vss) n12 w=2u l=0.13u
MN1839 (n1661 n1748 storage1838 vss) n12 w=1.2u l=0.13u
MP1840 (n1661 n1760 storage1838 vdd) p12 w=3.6u l=0.13u
MN1841 (qm1835 n1757 storage1838 vss) n12 w=1.2u l=0.13u
MP1842 (qm1835 n1763 storage1838 vdd) p12 w=3.6u l=0.13u
MN1843 (qmb1836 storage1838 vss vss) n12 w=0.5u l=0.13u
MP1844 (qmb1836 storage1838 vdd vdd) p12 w=1.5u l=0.13u
MN1845 (qm1835 qmb1836 vss vss) n12 w=0.5u l=0.13u
MP1846 (qm1835 qmb1836 vdd vdd) p12 w=1.5u l=0.13u
MN1847 (storage1838 reference_count_rst vss vss) n12 w=2u l=0.13u
MN1849 (qm1835 n1757 storage1848 vss) n12 w=1.2u l=0.13u
MP1850 (qm1835 n1763 storage1848 vdd) p12 w=3.6u l=0.13u
MN1851 (lag_g3 n1748 storage1848 vss) n12 w=1.2u l=0.13u
MP1852 (lag_g3 n1760 storage1848 vdd) p12 w=3.6u l=0.13u
MN1853 (qb1837 storage1848 vss vss) n12 w=0.5u l=0.13u
MP1854 (qb1837 storage1848 vdd vdd) p12 w=1.5u l=0.13u
MN1855 (lag_g3 qb1837 vss vss) n12 w=0.5u l=0.13u
MP1856 (lag_g3 qb1837 vdd vdd) p12 w=1.5u l=0.13u
MN1857 (storage1848 reference_count_rst vss vss) n12 w=2u l=0.13u
MN1862 (n1685 n1748 storage1861 vss) n12 w=1.2u l=0.13u
MP1863 (n1685 n1760 storage1861 vdd) p12 w=3.6u l=0.13u
MN1864 (qm1858 n1757 storage1861 vss) n12 w=1.2u l=0.13u
MP1865 (qm1858 n1763 storage1861 vdd) p12 w=3.6u l=0.13u
MN1866 (qmb1859 storage1861 vss vss) n12 w=0.5u l=0.13u
MP1867 (qmb1859 storage1861 vdd vdd) p12 w=1.5u l=0.13u
MN1868 (qm1858 qmb1859 vss vss) n12 w=0.5u l=0.13u
MP1869 (qm1858 qmb1859 vdd vdd) p12 w=1.5u l=0.13u
MN1870 (storage1861 reference_count_rst vss vss) n12 w=2u l=0.13u
MN1872 (qm1858 n1757 storage1871 vss) n12 w=1.2u l=0.13u
MP1873 (qm1858 n1763 storage1871 vdd) p12 w=3.6u l=0.13u
MN1874 (lag_g4 n1748 storage1871 vss) n12 w=1.2u l=0.13u
MP1875 (lag_g4 n1760 storage1871 vdd) p12 w=3.6u l=0.13u
MN1876 (qb1860 storage1871 vss vss) n12 w=0.5u l=0.13u
MP1877 (qb1860 storage1871 vdd vdd) p12 w=1.5u l=0.13u
MN1878 (lag_g4 qb1860 vss vss) n12 w=0.5u l=0.13u
MP1879 (lag_g4 qb1860 vdd vdd) p12 w=1.5u l=0.13u
MN1880 (storage1871 reference_count_rst vss vss) n12 w=2u l=0.13u
MN1885 (n1709 n1748 storage1884 vss) n12 w=1.2u l=0.13u
MP1886 (n1709 n1760 storage1884 vdd) p12 w=3.6u l=0.13u
MN1887 (qm1881 n1757 storage1884 vss) n12 w=1.2u l=0.13u
MP1888 (qm1881 n1763 storage1884 vdd) p12 w=3.6u l=0.13u
MN1889 (qmb1882 storage1884 vss vss) n12 w=0.5u l=0.13u
MP1890 (qmb1882 storage1884 vdd vdd) p12 w=1.5u l=0.13u
MN1891 (qm1881 qmb1882 vss vss) n12 w=0.5u l=0.13u
MP1892 (qm1881 qmb1882 vdd vdd) p12 w=1.5u l=0.13u
MN1893 (storage1884 reference_count_rst vss vss) n12 w=2u l=0.13u
MN1895 (qm1881 n1757 storage1894 vss) n12 w=1.2u l=0.13u
MP1896 (qm1881 n1763 storage1894 vdd) p12 w=3.6u l=0.13u
MN1897 (lag_g5 n1748 storage1894 vss) n12 w=1.2u l=0.13u
MP1898 (lag_g5 n1760 storage1894 vdd) p12 w=3.6u l=0.13u
MN1899 (qb1883 storage1894 vss vss) n12 w=0.5u l=0.13u
MP1900 (qb1883 storage1894 vdd vdd) p12 w=1.5u l=0.13u
MN1901 (lag_g5 qb1883 vss vss) n12 w=0.5u l=0.13u
MP1902 (lag_g5 qb1883 vdd vdd) p12 w=1.5u l=0.13u
MN1903 (storage1894 reference_count_rst vss vss) n12 w=2u l=0.13u
MN1908 (n1733 n1748 storage1907 vss) n12 w=1.2u l=0.13u
MP1909 (n1733 n1760 storage1907 vdd) p12 w=3.6u l=0.13u
MN1910 (qm1904 n1757 storage1907 vss) n12 w=1.2u l=0.13u
MP1911 (qm1904 n1763 storage1907 vdd) p12 w=3.6u l=0.13u
MN1912 (qmb1905 storage1907 vss vss) n12 w=0.5u l=0.13u
MP1913 (qmb1905 storage1907 vdd vdd) p12 w=1.5u l=0.13u
MN1914 (qm1904 qmb1905 vss vss) n12 w=0.5u l=0.13u
MP1915 (qm1904 qmb1905 vdd vdd) p12 w=1.5u l=0.13u
MN1916 (storage1907 reference_count_rst vss vss) n12 w=2u l=0.13u
MN1918 (qm1904 n1757 storage1917 vss) n12 w=1.2u l=0.13u
MP1919 (qm1904 n1763 storage1917 vdd) p12 w=3.6u l=0.13u
MN1920 (lag_g6 n1748 storage1917 vss) n12 w=1.2u l=0.13u
MP1921 (lag_g6 n1760 storage1917 vdd) p12 w=3.6u l=0.13u
MN1922 (qb1906 storage1917 vss vss) n12 w=0.5u l=0.13u
MP1923 (qb1906 storage1917 vdd vdd) p12 w=1.5u l=0.13u
MN1924 (lag_g6 qb1906 vss vss) n12 w=0.5u l=0.13u
MP1925 (lag_g6 qb1906 vdd vdd) p12 w=1.5u l=0.13u
MN1926 (storage1917 reference_count_rst vss vss) n12 w=2u l=0.13u
MN1931 (n1562 n1748 storage1930 vss) n12 w=1.2u l=0.13u
MP1932 (n1562 n1760 storage1930 vdd) p12 w=3.6u l=0.13u
MN1933 (qm1927 n1757 storage1930 vss) n12 w=1.2u l=0.13u
MP1934 (qm1927 n1763 storage1930 vdd) p12 w=3.6u l=0.13u
MN1935 (qmb1928 storage1930 vss vss) n12 w=0.5u l=0.13u
MP1936 (qmb1928 storage1930 vdd vdd) p12 w=1.5u l=0.13u
MN1937 (qm1927 qmb1928 vss vss) n12 w=0.5u l=0.13u
MP1938 (qm1927 qmb1928 vdd vdd) p12 w=1.5u l=0.13u
MN1939 (storage1930 reference_count_rst vss vss) n12 w=2u l=0.13u
MN1941 (qm1927 n1757 storage1940 vss) n12 w=1.2u l=0.13u
MP1942 (qm1927 n1763 storage1940 vdd) p12 w=3.6u l=0.13u
MN1943 (lag_g7 n1748 storage1940 vss) n12 w=1.2u l=0.13u
MP1944 (lag_g7 n1760 storage1940 vdd) p12 w=3.6u l=0.13u
MN1945 (qb1929 storage1940 vss vss) n12 w=0.5u l=0.13u
MP1946 (qb1929 storage1940 vdd vdd) p12 w=1.5u l=0.13u
MN1947 (lag_g7 qb1929 vss vss) n12 w=0.5u l=0.13u
MP1948 (lag_g7 qb1929 vdd vdd) p12 w=1.5u l=0.13u
MN1949 (storage1940 reference_count_rst vss vss) n12 w=2u l=0.13u
MN1952 (n1950 div_g6 n1951 vss) n12 w=1.6u l=0.13u
MN1953 (n1951 div_g7 vss vss) n12 w=1.6u l=0.13u
MP1954 (n1950 div_g6 vdd vdd) p12 w=2.4u l=0.13u
MP1955 (n1950 div_g7 vdd vdd) p12 w=2.4u l=0.13u
MN1958 (n1956 div_g6 n1957 vss) n12 w=1.6u l=0.13u
MN1959 (n1957 n1950 vss vss) n12 w=1.6u l=0.13u
MP1960 (n1956 div_g6 vdd vdd) p12 w=2.4u l=0.13u
MP1961 (n1956 n1950 vdd vdd) p12 w=2.4u l=0.13u
MN1964 (n1962 div_g7 n1963 vss) n12 w=1.6u l=0.13u
MN1965 (n1963 n1950 vss vss) n12 w=1.6u l=0.13u
MP1966 (n1962 div_g7 vdd vdd) p12 w=2.4u l=0.13u
MP1967 (n1962 n1950 vdd vdd) p12 w=2.4u l=0.13u
MN1970 (n1968 n1956 n1969 vss) n12 w=1.6u l=0.13u
MN1971 (n1969 n1962 vss vss) n12 w=1.6u l=0.13u
MP1972 (n1968 n1956 vdd vdd) p12 w=2.4u l=0.13u
MP1973 (n1968 n1962 vdd vdd) p12 w=2.4u l=0.13u
MN1976 (n1974 div_g5 n1975 vss) n12 w=1.6u l=0.13u
MN1977 (n1975 n1968 vss vss) n12 w=1.6u l=0.13u
MP1978 (n1974 div_g5 vdd vdd) p12 w=2.4u l=0.13u
MP1979 (n1974 n1968 vdd vdd) p12 w=2.4u l=0.13u
MN1982 (n1980 div_g5 n1981 vss) n12 w=1.6u l=0.13u
MN1983 (n1981 n1974 vss vss) n12 w=1.6u l=0.13u
MP1984 (n1980 div_g5 vdd vdd) p12 w=2.4u l=0.13u
MP1985 (n1980 n1974 vdd vdd) p12 w=2.4u l=0.13u
MN1988 (n1986 n1968 n1987 vss) n12 w=1.6u l=0.13u
MN1989 (n1987 n1974 vss vss) n12 w=1.6u l=0.13u
MP1990 (n1986 n1968 vdd vdd) p12 w=2.4u l=0.13u
MP1991 (n1986 n1974 vdd vdd) p12 w=2.4u l=0.13u
MN1994 (n1992 n1980 n1993 vss) n12 w=1.6u l=0.13u
MN1995 (n1993 n1986 vss vss) n12 w=1.6u l=0.13u
MP1996 (n1992 n1980 vdd vdd) p12 w=2.4u l=0.13u
MP1997 (n1992 n1986 vdd vdd) p12 w=2.4u l=0.13u
MN2000 (n1998 div_g4 n1999 vss) n12 w=1.6u l=0.13u
MN2001 (n1999 n1992 vss vss) n12 w=1.6u l=0.13u
MP2002 (n1998 div_g4 vdd vdd) p12 w=2.4u l=0.13u
MP2003 (n1998 n1992 vdd vdd) p12 w=2.4u l=0.13u
MN2006 (n2004 div_g4 n2005 vss) n12 w=1.6u l=0.13u
MN2007 (n2005 n1998 vss vss) n12 w=1.6u l=0.13u
MP2008 (n2004 div_g4 vdd vdd) p12 w=2.4u l=0.13u
MP2009 (n2004 n1998 vdd vdd) p12 w=2.4u l=0.13u
MN2012 (n2010 n1992 n2011 vss) n12 w=1.6u l=0.13u
MN2013 (n2011 n1998 vss vss) n12 w=1.6u l=0.13u
MP2014 (n2010 n1992 vdd vdd) p12 w=2.4u l=0.13u
MP2015 (n2010 n1998 vdd vdd) p12 w=2.4u l=0.13u
MN2018 (n2016 n2004 n2017 vss) n12 w=1.6u l=0.13u
MN2019 (n2017 n2010 vss vss) n12 w=1.6u l=0.13u
MP2020 (n2016 n2004 vdd vdd) p12 w=2.4u l=0.13u
MP2021 (n2016 n2010 vdd vdd) p12 w=2.4u l=0.13u
MN2024 (n2022 div_g3 n2023 vss) n12 w=1.6u l=0.13u
MN2025 (n2023 n2016 vss vss) n12 w=1.6u l=0.13u
MP2026 (n2022 div_g3 vdd vdd) p12 w=2.4u l=0.13u
MP2027 (n2022 n2016 vdd vdd) p12 w=2.4u l=0.13u
MN2030 (n2028 div_g3 n2029 vss) n12 w=1.6u l=0.13u
MN2031 (n2029 n2022 vss vss) n12 w=1.6u l=0.13u
MP2032 (n2028 div_g3 vdd vdd) p12 w=2.4u l=0.13u
MP2033 (n2028 n2022 vdd vdd) p12 w=2.4u l=0.13u
MN2036 (n2034 n2016 n2035 vss) n12 w=1.6u l=0.13u
MN2037 (n2035 n2022 vss vss) n12 w=1.6u l=0.13u
MP2038 (n2034 n2016 vdd vdd) p12 w=2.4u l=0.13u
MP2039 (n2034 n2022 vdd vdd) p12 w=2.4u l=0.13u
MN2042 (n2040 n2028 n2041 vss) n12 w=1.6u l=0.13u
MN2043 (n2041 n2034 vss vss) n12 w=1.6u l=0.13u
MP2044 (n2040 n2028 vdd vdd) p12 w=2.4u l=0.13u
MP2045 (n2040 n2034 vdd vdd) p12 w=2.4u l=0.13u
MN2048 (n2046 div_g2 n2047 vss) n12 w=1.6u l=0.13u
MN2049 (n2047 n2040 vss vss) n12 w=1.6u l=0.13u
MP2050 (n2046 div_g2 vdd vdd) p12 w=2.4u l=0.13u
MP2051 (n2046 n2040 vdd vdd) p12 w=2.4u l=0.13u
MN2054 (n2052 div_g2 n2053 vss) n12 w=1.6u l=0.13u
MN2055 (n2053 n2046 vss vss) n12 w=1.6u l=0.13u
MP2056 (n2052 div_g2 vdd vdd) p12 w=2.4u l=0.13u
MP2057 (n2052 n2046 vdd vdd) p12 w=2.4u l=0.13u
MN2060 (n2058 n2040 n2059 vss) n12 w=1.6u l=0.13u
MN2061 (n2059 n2046 vss vss) n12 w=1.6u l=0.13u
MP2062 (n2058 n2040 vdd vdd) p12 w=2.4u l=0.13u
MP2063 (n2058 n2046 vdd vdd) p12 w=2.4u l=0.13u
MN2066 (n2064 n2052 n2065 vss) n12 w=1.6u l=0.13u
MN2067 (n2065 n2058 vss vss) n12 w=1.6u l=0.13u
MP2068 (n2064 n2052 vdd vdd) p12 w=2.4u l=0.13u
MP2069 (n2064 n2058 vdd vdd) p12 w=2.4u l=0.13u
MN2072 (n2070 div_g1 n2071 vss) n12 w=1.6u l=0.13u
MN2073 (n2071 n2064 vss vss) n12 w=1.6u l=0.13u
MP2074 (n2070 div_g1 vdd vdd) p12 w=2.4u l=0.13u
MP2075 (n2070 n2064 vdd vdd) p12 w=2.4u l=0.13u
MN2078 (n2076 div_g1 n2077 vss) n12 w=1.6u l=0.13u
MN2079 (n2077 n2070 vss vss) n12 w=1.6u l=0.13u
MP2080 (n2076 div_g1 vdd vdd) p12 w=2.4u l=0.13u
MP2081 (n2076 n2070 vdd vdd) p12 w=2.4u l=0.13u
MN2084 (n2082 n2064 n2083 vss) n12 w=1.6u l=0.13u
MN2085 (n2083 n2070 vss vss) n12 w=1.6u l=0.13u
MP2086 (n2082 n2064 vdd vdd) p12 w=2.4u l=0.13u
MP2087 (n2082 n2070 vdd vdd) p12 w=2.4u l=0.13u
MN2090 (n2088 n2076 n2089 vss) n12 w=1.6u l=0.13u
MN2091 (n2089 n2082 vss vss) n12 w=1.6u l=0.13u
MP2092 (n2088 n2076 vdd vdd) p12 w=2.4u l=0.13u
MP2093 (n2088 n2082 vdd vdd) p12 w=2.4u l=0.13u
MN2096 (n2094 div_g0 n2095 vss) n12 w=1.6u l=0.13u
MN2097 (n2095 n2088 vss vss) n12 w=1.6u l=0.13u
MP2098 (n2094 div_g0 vdd vdd) p12 w=2.4u l=0.13u
MP2099 (n2094 n2088 vdd vdd) p12 w=2.4u l=0.13u
MN2102 (n2100 div_g0 n2101 vss) n12 w=1.6u l=0.13u
MN2103 (n2101 n2094 vss vss) n12 w=1.6u l=0.13u
MP2104 (n2100 div_g0 vdd vdd) p12 w=2.4u l=0.13u
MP2105 (n2100 n2094 vdd vdd) p12 w=2.4u l=0.13u
MN2108 (n2106 n2088 n2107 vss) n12 w=1.6u l=0.13u
MN2109 (n2107 n2094 vss vss) n12 w=1.6u l=0.13u
MP2110 (n2106 n2088 vdd vdd) p12 w=2.4u l=0.13u
MP2111 (n2106 n2094 vdd vdd) p12 w=2.4u l=0.13u
MN2114 (n2112 n2100 n2113 vss) n12 w=1.6u l=0.13u
MN2115 (n2113 n2106 vss vss) n12 w=1.6u l=0.13u
MP2116 (n2112 n2100 vdd vdd) p12 w=2.4u l=0.13u
MP2117 (n2112 n2106 vdd vdd) p12 w=2.4u l=0.13u
MN2119 (n2118 n2112 vss vss) n12 w=0.8u l=0.13u
MP2120 (n2118 n2112 vdd vdd) p12 w=2.4u l=0.13u
MN2123 (n2121 n2088 n2122 vss) n12 w=1.6u l=0.13u
MN2124 (n2122 n2112 vss vss) n12 w=1.6u l=0.13u
MP2125 (n2121 n2088 vdd vdd) p12 w=2.4u l=0.13u
MP2126 (n2121 n2112 vdd vdd) p12 w=2.4u l=0.13u
MN2129 (n2127 n2088 n2128 vss) n12 w=1.6u l=0.13u
MN2130 (n2128 n2121 vss vss) n12 w=1.6u l=0.13u
MP2131 (n2127 n2088 vdd vdd) p12 w=2.4u l=0.13u
MP2132 (n2127 n2121 vdd vdd) p12 w=2.4u l=0.13u
MN2135 (n2133 n2112 n2134 vss) n12 w=1.6u l=0.13u
MN2136 (n2134 n2121 vss vss) n12 w=1.6u l=0.13u
MP2137 (n2133 n2112 vdd vdd) p12 w=2.4u l=0.13u
MP2138 (n2133 n2121 vdd vdd) p12 w=2.4u l=0.13u
MN2141 (n2139 n2127 n2140 vss) n12 w=1.6u l=0.13u
MN2142 (n2140 n2133 vss vss) n12 w=1.6u l=0.13u
MP2143 (n2139 n2127 vdd vdd) p12 w=2.4u l=0.13u
MP2144 (n2139 n2133 vdd vdd) p12 w=2.4u l=0.13u
MN2146 (n2145 n2121 vss vss) n12 w=0.8u l=0.13u
MP2147 (n2145 n2121 vdd vdd) p12 w=2.4u l=0.13u
MN2150 (n2148 n2064 n2149 vss) n12 w=1.6u l=0.13u
MN2151 (n2149 n2145 vss vss) n12 w=1.6u l=0.13u
MP2152 (n2148 n2064 vdd vdd) p12 w=2.4u l=0.13u
MP2153 (n2148 n2145 vdd vdd) p12 w=2.4u l=0.13u
MN2156 (n2154 n2064 n2155 vss) n12 w=1.6u l=0.13u
MN2157 (n2155 n2148 vss vss) n12 w=1.6u l=0.13u
MP2158 (n2154 n2064 vdd vdd) p12 w=2.4u l=0.13u
MP2159 (n2154 n2148 vdd vdd) p12 w=2.4u l=0.13u
MN2162 (n2160 n2145 n2161 vss) n12 w=1.6u l=0.13u
MN2163 (n2161 n2148 vss vss) n12 w=1.6u l=0.13u
MP2164 (n2160 n2145 vdd vdd) p12 w=2.4u l=0.13u
MP2165 (n2160 n2148 vdd vdd) p12 w=2.4u l=0.13u
MN2168 (n2166 n2154 n2167 vss) n12 w=1.6u l=0.13u
MN2169 (n2167 n2160 vss vss) n12 w=1.6u l=0.13u
MP2170 (n2166 n2154 vdd vdd) p12 w=2.4u l=0.13u
MP2171 (n2166 n2160 vdd vdd) p12 w=2.4u l=0.13u
MN2173 (n2172 n2148 vss vss) n12 w=0.8u l=0.13u
MP2174 (n2172 n2148 vdd vdd) p12 w=2.4u l=0.13u
MN2177 (n2175 n2040 n2176 vss) n12 w=1.6u l=0.13u
MN2178 (n2176 n2172 vss vss) n12 w=1.6u l=0.13u
MP2179 (n2175 n2040 vdd vdd) p12 w=2.4u l=0.13u
MP2180 (n2175 n2172 vdd vdd) p12 w=2.4u l=0.13u
MN2183 (n2181 n2040 n2182 vss) n12 w=1.6u l=0.13u
MN2184 (n2182 n2175 vss vss) n12 w=1.6u l=0.13u
MP2185 (n2181 n2040 vdd vdd) p12 w=2.4u l=0.13u
MP2186 (n2181 n2175 vdd vdd) p12 w=2.4u l=0.13u
MN2189 (n2187 n2172 n2188 vss) n12 w=1.6u l=0.13u
MN2190 (n2188 n2175 vss vss) n12 w=1.6u l=0.13u
MP2191 (n2187 n2172 vdd vdd) p12 w=2.4u l=0.13u
MP2192 (n2187 n2175 vdd vdd) p12 w=2.4u l=0.13u
MN2195 (n2193 n2181 n2194 vss) n12 w=1.6u l=0.13u
MN2196 (n2194 n2187 vss vss) n12 w=1.6u l=0.13u
MP2197 (n2193 n2181 vdd vdd) p12 w=2.4u l=0.13u
MP2198 (n2193 n2187 vdd vdd) p12 w=2.4u l=0.13u
MN2200 (n2199 n2175 vss vss) n12 w=0.8u l=0.13u
MP2201 (n2199 n2175 vdd vdd) p12 w=2.4u l=0.13u
MN2204 (n2202 n2016 n2203 vss) n12 w=1.6u l=0.13u
MN2205 (n2203 n2199 vss vss) n12 w=1.6u l=0.13u
MP2206 (n2202 n2016 vdd vdd) p12 w=2.4u l=0.13u
MP2207 (n2202 n2199 vdd vdd) p12 w=2.4u l=0.13u
MN2210 (n2208 n2016 n2209 vss) n12 w=1.6u l=0.13u
MN2211 (n2209 n2202 vss vss) n12 w=1.6u l=0.13u
MP2212 (n2208 n2016 vdd vdd) p12 w=2.4u l=0.13u
MP2213 (n2208 n2202 vdd vdd) p12 w=2.4u l=0.13u
MN2216 (n2214 n2199 n2215 vss) n12 w=1.6u l=0.13u
MN2217 (n2215 n2202 vss vss) n12 w=1.6u l=0.13u
MP2218 (n2214 n2199 vdd vdd) p12 w=2.4u l=0.13u
MP2219 (n2214 n2202 vdd vdd) p12 w=2.4u l=0.13u
MN2222 (n2220 n2208 n2221 vss) n12 w=1.6u l=0.13u
MN2223 (n2221 n2214 vss vss) n12 w=1.6u l=0.13u
MP2224 (n2220 n2208 vdd vdd) p12 w=2.4u l=0.13u
MP2225 (n2220 n2214 vdd vdd) p12 w=2.4u l=0.13u
MN2227 (n2226 n2202 vss vss) n12 w=0.8u l=0.13u
MP2228 (n2226 n2202 vdd vdd) p12 w=2.4u l=0.13u
MN2231 (n2229 n1992 n2230 vss) n12 w=1.6u l=0.13u
MN2232 (n2230 n2226 vss vss) n12 w=1.6u l=0.13u
MP2233 (n2229 n1992 vdd vdd) p12 w=2.4u l=0.13u
MP2234 (n2229 n2226 vdd vdd) p12 w=2.4u l=0.13u
MN2237 (n2235 n1992 n2236 vss) n12 w=1.6u l=0.13u
MN2238 (n2236 n2229 vss vss) n12 w=1.6u l=0.13u
MP2239 (n2235 n1992 vdd vdd) p12 w=2.4u l=0.13u
MP2240 (n2235 n2229 vdd vdd) p12 w=2.4u l=0.13u
MN2243 (n2241 n2226 n2242 vss) n12 w=1.6u l=0.13u
MN2244 (n2242 n2229 vss vss) n12 w=1.6u l=0.13u
MP2245 (n2241 n2226 vdd vdd) p12 w=2.4u l=0.13u
MP2246 (n2241 n2229 vdd vdd) p12 w=2.4u l=0.13u
MN2249 (n2247 n2235 n2248 vss) n12 w=1.6u l=0.13u
MN2250 (n2248 n2241 vss vss) n12 w=1.6u l=0.13u
MP2251 (n2247 n2235 vdd vdd) p12 w=2.4u l=0.13u
MP2252 (n2247 n2241 vdd vdd) p12 w=2.4u l=0.13u
MN2254 (n2253 n2229 vss vss) n12 w=0.8u l=0.13u
MP2255 (n2253 n2229 vdd vdd) p12 w=2.4u l=0.13u
MN2258 (n2256 n1968 n2257 vss) n12 w=1.6u l=0.13u
MN2259 (n2257 n2253 vss vss) n12 w=1.6u l=0.13u
MP2260 (n2256 n1968 vdd vdd) p12 w=2.4u l=0.13u
MP2261 (n2256 n2253 vdd vdd) p12 w=2.4u l=0.13u
MN2264 (n2262 n1968 n2263 vss) n12 w=1.6u l=0.13u
MN2265 (n2263 n2256 vss vss) n12 w=1.6u l=0.13u
MP2266 (n2262 n1968 vdd vdd) p12 w=2.4u l=0.13u
MP2267 (n2262 n2256 vdd vdd) p12 w=2.4u l=0.13u
MN2270 (n2268 n2253 n2269 vss) n12 w=1.6u l=0.13u
MN2271 (n2269 n2256 vss vss) n12 w=1.6u l=0.13u
MP2272 (n2268 n2253 vdd vdd) p12 w=2.4u l=0.13u
MP2273 (n2268 n2256 vdd vdd) p12 w=2.4u l=0.13u
MN2276 (n2274 n2262 n2275 vss) n12 w=1.6u l=0.13u
MN2277 (n2275 n2268 vss vss) n12 w=1.6u l=0.13u
MP2278 (n2274 n2262 vdd vdd) p12 w=2.4u l=0.13u
MP2279 (n2274 n2268 vdd vdd) p12 w=2.4u l=0.13u
MN2281 (n2280 n2256 vss vss) n12 w=0.8u l=0.13u
MP2282 (n2280 n2256 vdd vdd) p12 w=2.4u l=0.13u
MN2285 (n2283 div_g7 n2284 vss) n12 w=1.6u l=0.13u
MN2286 (n2284 n2280 vss vss) n12 w=1.6u l=0.13u
MP2287 (n2283 div_g7 vdd vdd) p12 w=2.4u l=0.13u
MP2288 (n2283 n2280 vdd vdd) p12 w=2.4u l=0.13u
MN2291 (n2289 div_g7 n2290 vss) n12 w=1.6u l=0.13u
MN2292 (n2290 n2283 vss vss) n12 w=1.6u l=0.13u
MP2293 (n2289 div_g7 vdd vdd) p12 w=2.4u l=0.13u
MP2294 (n2289 n2283 vdd vdd) p12 w=2.4u l=0.13u
MN2297 (n2295 n2280 n2296 vss) n12 w=1.6u l=0.13u
MN2298 (n2296 n2283 vss vss) n12 w=1.6u l=0.13u
MP2299 (n2295 n2280 vdd vdd) p12 w=2.4u l=0.13u
MP2300 (n2295 n2283 vdd vdd) p12 w=2.4u l=0.13u
MN2303 (n2301 n2289 n2302 vss) n12 w=1.6u l=0.13u
MN2304 (n2302 n2295 vss vss) n12 w=1.6u l=0.13u
MP2305 (n2301 n2289 vdd vdd) p12 w=2.4u l=0.13u
MP2306 (n2301 n2295 vdd vdd) p12 w=2.4u l=0.13u
MN2308 (n2307 n2283 vss vss) n12 w=0.8u l=0.13u
MP2309 (n2307 n2283 vdd vdd) p12 w=2.4u l=0.13u
MN2312 (n2310 n2118 n2311 vss) n12 w=1.6u l=0.13u
MN2313 (n2311 n2139 vss vss) n12 w=1.6u l=0.13u
MP2314 (n2310 n2118 vdd vdd) p12 w=2.4u l=0.13u
MP2315 (n2310 n2139 vdd vdd) p12 w=2.4u l=0.13u
MN2318 (n2316 n2118 n2317 vss) n12 w=1.6u l=0.13u
MN2319 (n2317 n2310 vss vss) n12 w=1.6u l=0.13u
MP2320 (n2316 n2118 vdd vdd) p12 w=2.4u l=0.13u
MP2321 (n2316 n2310 vdd vdd) p12 w=2.4u l=0.13u
MN2324 (n2322 n2139 n2323 vss) n12 w=1.6u l=0.13u
MN2325 (n2323 n2310 vss vss) n12 w=1.6u l=0.13u
MP2326 (n2322 n2139 vdd vdd) p12 w=2.4u l=0.13u
MP2327 (n2322 n2310 vdd vdd) p12 w=2.4u l=0.13u
MN2330 (n2328 n2316 n2329 vss) n12 w=1.6u l=0.13u
MN2331 (n2329 n2322 vss vss) n12 w=1.6u l=0.13u
MP2332 (n2328 n2316 vdd vdd) p12 w=2.4u l=0.13u
MP2333 (n2328 n2322 vdd vdd) p12 w=2.4u l=0.13u
MN2336 (n2334 n2139 n2335 vss) n12 w=1.6u l=0.13u
MN2337 (n2335 n2166 vss vss) n12 w=1.6u l=0.13u
MP2338 (n2334 n2139 vdd vdd) p12 w=2.4u l=0.13u
MP2339 (n2334 n2166 vdd vdd) p12 w=2.4u l=0.13u
MN2342 (n2340 n2139 n2341 vss) n12 w=1.6u l=0.13u
MN2343 (n2341 n2334 vss vss) n12 w=1.6u l=0.13u
MP2344 (n2340 n2139 vdd vdd) p12 w=2.4u l=0.13u
MP2345 (n2340 n2334 vdd vdd) p12 w=2.4u l=0.13u
MN2348 (n2346 n2166 n2347 vss) n12 w=1.6u l=0.13u
MN2349 (n2347 n2334 vss vss) n12 w=1.6u l=0.13u
MP2350 (n2346 n2166 vdd vdd) p12 w=2.4u l=0.13u
MP2351 (n2346 n2334 vdd vdd) p12 w=2.4u l=0.13u
MN2354 (n2352 n2340 n2353 vss) n12 w=1.6u l=0.13u
MN2355 (n2353 n2346 vss vss) n12 w=1.6u l=0.13u
MP2356 (n2352 n2340 vdd vdd) p12 w=2.4u l=0.13u
MP2357 (n2352 n2346 vdd vdd) p12 w=2.4u l=0.13u
MN2360 (n2358 n2166 n2359 vss) n12 w=1.6u l=0.13u
MN2361 (n2359 n2193 vss vss) n12 w=1.6u l=0.13u
MP2362 (n2358 n2166 vdd vdd) p12 w=2.4u l=0.13u
MP2363 (n2358 n2193 vdd vdd) p12 w=2.4u l=0.13u
MN2366 (n2364 n2166 n2365 vss) n12 w=1.6u l=0.13u
MN2367 (n2365 n2358 vss vss) n12 w=1.6u l=0.13u
MP2368 (n2364 n2166 vdd vdd) p12 w=2.4u l=0.13u
MP2369 (n2364 n2358 vdd vdd) p12 w=2.4u l=0.13u
MN2372 (n2370 n2193 n2371 vss) n12 w=1.6u l=0.13u
MN2373 (n2371 n2358 vss vss) n12 w=1.6u l=0.13u
MP2374 (n2370 n2193 vdd vdd) p12 w=2.4u l=0.13u
MP2375 (n2370 n2358 vdd vdd) p12 w=2.4u l=0.13u
MN2378 (n2376 n2364 n2377 vss) n12 w=1.6u l=0.13u
MN2379 (n2377 n2370 vss vss) n12 w=1.6u l=0.13u
MP2380 (n2376 n2364 vdd vdd) p12 w=2.4u l=0.13u
MP2381 (n2376 n2370 vdd vdd) p12 w=2.4u l=0.13u
MN2384 (n2382 n2193 n2383 vss) n12 w=1.6u l=0.13u
MN2385 (n2383 n2220 vss vss) n12 w=1.6u l=0.13u
MP2386 (n2382 n2193 vdd vdd) p12 w=2.4u l=0.13u
MP2387 (n2382 n2220 vdd vdd) p12 w=2.4u l=0.13u
MN2390 (n2388 n2193 n2389 vss) n12 w=1.6u l=0.13u
MN2391 (n2389 n2382 vss vss) n12 w=1.6u l=0.13u
MP2392 (n2388 n2193 vdd vdd) p12 w=2.4u l=0.13u
MP2393 (n2388 n2382 vdd vdd) p12 w=2.4u l=0.13u
MN2396 (n2394 n2220 n2395 vss) n12 w=1.6u l=0.13u
MN2397 (n2395 n2382 vss vss) n12 w=1.6u l=0.13u
MP2398 (n2394 n2220 vdd vdd) p12 w=2.4u l=0.13u
MP2399 (n2394 n2382 vdd vdd) p12 w=2.4u l=0.13u
MN2402 (n2400 n2388 n2401 vss) n12 w=1.6u l=0.13u
MN2403 (n2401 n2394 vss vss) n12 w=1.6u l=0.13u
MP2404 (n2400 n2388 vdd vdd) p12 w=2.4u l=0.13u
MP2405 (n2400 n2394 vdd vdd) p12 w=2.4u l=0.13u
MN2408 (n2406 n2220 n2407 vss) n12 w=1.6u l=0.13u
MN2409 (n2407 n2247 vss vss) n12 w=1.6u l=0.13u
MP2410 (n2406 n2220 vdd vdd) p12 w=2.4u l=0.13u
MP2411 (n2406 n2247 vdd vdd) p12 w=2.4u l=0.13u
MN2414 (n2412 n2220 n2413 vss) n12 w=1.6u l=0.13u
MN2415 (n2413 n2406 vss vss) n12 w=1.6u l=0.13u
MP2416 (n2412 n2220 vdd vdd) p12 w=2.4u l=0.13u
MP2417 (n2412 n2406 vdd vdd) p12 w=2.4u l=0.13u
MN2420 (n2418 n2247 n2419 vss) n12 w=1.6u l=0.13u
MN2421 (n2419 n2406 vss vss) n12 w=1.6u l=0.13u
MP2422 (n2418 n2247 vdd vdd) p12 w=2.4u l=0.13u
MP2423 (n2418 n2406 vdd vdd) p12 w=2.4u l=0.13u
MN2426 (n2424 n2412 n2425 vss) n12 w=1.6u l=0.13u
MN2427 (n2425 n2418 vss vss) n12 w=1.6u l=0.13u
MP2428 (n2424 n2412 vdd vdd) p12 w=2.4u l=0.13u
MP2429 (n2424 n2418 vdd vdd) p12 w=2.4u l=0.13u
MN2432 (n2430 n2247 n2431 vss) n12 w=1.6u l=0.13u
MN2433 (n2431 n2274 vss vss) n12 w=1.6u l=0.13u
MP2434 (n2430 n2247 vdd vdd) p12 w=2.4u l=0.13u
MP2435 (n2430 n2274 vdd vdd) p12 w=2.4u l=0.13u
MN2438 (n2436 n2247 n2437 vss) n12 w=1.6u l=0.13u
MN2439 (n2437 n2430 vss vss) n12 w=1.6u l=0.13u
MP2440 (n2436 n2247 vdd vdd) p12 w=2.4u l=0.13u
MP2441 (n2436 n2430 vdd vdd) p12 w=2.4u l=0.13u
MN2444 (n2442 n2274 n2443 vss) n12 w=1.6u l=0.13u
MN2445 (n2443 n2430 vss vss) n12 w=1.6u l=0.13u
MP2446 (n2442 n2274 vdd vdd) p12 w=2.4u l=0.13u
MP2447 (n2442 n2430 vdd vdd) p12 w=2.4u l=0.13u
MN2450 (n2448 n2436 n2449 vss) n12 w=1.6u l=0.13u
MN2451 (n2449 n2442 vss vss) n12 w=1.6u l=0.13u
MP2452 (n2448 n2436 vdd vdd) p12 w=2.4u l=0.13u
MP2453 (n2448 n2442 vdd vdd) p12 w=2.4u l=0.13u
MN2456 (n2454 n2274 n2455 vss) n12 w=1.6u l=0.13u
MN2457 (n2455 n2301 vss vss) n12 w=1.6u l=0.13u
MP2458 (n2454 n2274 vdd vdd) p12 w=2.4u l=0.13u
MP2459 (n2454 n2301 vdd vdd) p12 w=2.4u l=0.13u
MN2462 (n2460 n2274 n2461 vss) n12 w=1.6u l=0.13u
MN2463 (n2461 n2454 vss vss) n12 w=1.6u l=0.13u
MP2464 (n2460 n2274 vdd vdd) p12 w=2.4u l=0.13u
MP2465 (n2460 n2454 vdd vdd) p12 w=2.4u l=0.13u
MN2468 (n2466 n2301 n2467 vss) n12 w=1.6u l=0.13u
MN2469 (n2467 n2454 vss vss) n12 w=1.6u l=0.13u
MP2470 (n2466 n2301 vdd vdd) p12 w=2.4u l=0.13u
MP2471 (n2466 n2454 vdd vdd) p12 w=2.4u l=0.13u
MN2474 (n2472 n2460 n2473 vss) n12 w=1.6u l=0.13u
MN2475 (n2473 n2466 vss vss) n12 w=1.6u l=0.13u
MP2476 (n2472 n2460 vdd vdd) p12 w=2.4u l=0.13u
MP2477 (n2472 n2466 vdd vdd) p12 w=2.4u l=0.13u
MN2482 (n2328 n225 storage2481 vss) n12 w=1.2u l=0.13u
MP2483 (n2328 n237 storage2481 vdd) p12 w=3.6u l=0.13u
MN2484 (qm2478 n234 storage2481 vss) n12 w=1.2u l=0.13u
MP2485 (qm2478 n240 storage2481 vdd) p12 w=3.6u l=0.13u
MN2486 (qmb2479 storage2481 vss vss) n12 w=0.5u l=0.13u
MP2487 (qmb2479 storage2481 vdd vdd) p12 w=1.5u l=0.13u
MN2488 (qm2478 qmb2479 vss vss) n12 w=0.5u l=0.13u
MP2489 (qm2478 qmb2479 vdd vdd) p12 w=1.5u l=0.13u
MN2490 (storage2481 n202 vss vss) n12 w=2u l=0.13u
MN2492 (qm2478 n234 storage2491 vss) n12 w=1.2u l=0.13u
MP2493 (qm2478 n240 storage2491 vdd) p12 w=3.6u l=0.13u
MN2494 (div_g0 n225 storage2491 vss) n12 w=1.2u l=0.13u
MP2495 (div_g0 n237 storage2491 vdd) p12 w=3.6u l=0.13u
MN2496 (qb2480 storage2491 vss vss) n12 w=0.5u l=0.13u
MP2497 (qb2480 storage2491 vdd vdd) p12 w=1.5u l=0.13u
MN2498 (div_g0 qb2480 vss vss) n12 w=0.5u l=0.13u
MP2499 (div_g0 qb2480 vdd vdd) p12 w=1.5u l=0.13u
MN2500 (storage2491 n202 vss vss) n12 w=2u l=0.13u
MN2505 (n2352 n225 storage2504 vss) n12 w=1.2u l=0.13u
MP2506 (n2352 n237 storage2504 vdd) p12 w=3.6u l=0.13u
MN2507 (qm2501 n234 storage2504 vss) n12 w=1.2u l=0.13u
MP2508 (qm2501 n240 storage2504 vdd) p12 w=3.6u l=0.13u
MN2509 (qmb2502 storage2504 vss vss) n12 w=0.5u l=0.13u
MP2510 (qmb2502 storage2504 vdd vdd) p12 w=1.5u l=0.13u
MN2511 (qm2501 qmb2502 vss vss) n12 w=0.5u l=0.13u
MP2512 (qm2501 qmb2502 vdd vdd) p12 w=1.5u l=0.13u
MN2513 (storage2504 n202 vss vss) n12 w=2u l=0.13u
MN2515 (qm2501 n234 storage2514 vss) n12 w=1.2u l=0.13u
MP2516 (qm2501 n240 storage2514 vdd) p12 w=3.6u l=0.13u
MN2517 (div_g1 n225 storage2514 vss) n12 w=1.2u l=0.13u
MP2518 (div_g1 n237 storage2514 vdd) p12 w=3.6u l=0.13u
MN2519 (qb2503 storage2514 vss vss) n12 w=0.5u l=0.13u
MP2520 (qb2503 storage2514 vdd vdd) p12 w=1.5u l=0.13u
MN2521 (div_g1 qb2503 vss vss) n12 w=0.5u l=0.13u
MP2522 (div_g1 qb2503 vdd vdd) p12 w=1.5u l=0.13u
MN2523 (storage2514 n202 vss vss) n12 w=2u l=0.13u
MN2528 (n2376 n225 storage2527 vss) n12 w=1.2u l=0.13u
MP2529 (n2376 n237 storage2527 vdd) p12 w=3.6u l=0.13u
MN2530 (qm2524 n234 storage2527 vss) n12 w=1.2u l=0.13u
MP2531 (qm2524 n240 storage2527 vdd) p12 w=3.6u l=0.13u
MN2532 (qmb2525 storage2527 vss vss) n12 w=0.5u l=0.13u
MP2533 (qmb2525 storage2527 vdd vdd) p12 w=1.5u l=0.13u
MN2534 (qm2524 qmb2525 vss vss) n12 w=0.5u l=0.13u
MP2535 (qm2524 qmb2525 vdd vdd) p12 w=1.5u l=0.13u
MN2536 (storage2527 n202 vss vss) n12 w=2u l=0.13u
MN2538 (qm2524 n234 storage2537 vss) n12 w=1.2u l=0.13u
MP2539 (qm2524 n240 storage2537 vdd) p12 w=3.6u l=0.13u
MN2540 (div_g2 n225 storage2537 vss) n12 w=1.2u l=0.13u
MP2541 (div_g2 n237 storage2537 vdd) p12 w=3.6u l=0.13u
MN2542 (qb2526 storage2537 vss vss) n12 w=0.5u l=0.13u
MP2543 (qb2526 storage2537 vdd vdd) p12 w=1.5u l=0.13u
MN2544 (div_g2 qb2526 vss vss) n12 w=0.5u l=0.13u
MP2545 (div_g2 qb2526 vdd vdd) p12 w=1.5u l=0.13u
MN2546 (storage2537 n202 vss vss) n12 w=2u l=0.13u
MN2551 (n2400 n225 storage2550 vss) n12 w=1.2u l=0.13u
MP2552 (n2400 n237 storage2550 vdd) p12 w=3.6u l=0.13u
MN2553 (qm2547 n234 storage2550 vss) n12 w=1.2u l=0.13u
MP2554 (qm2547 n240 storage2550 vdd) p12 w=3.6u l=0.13u
MN2555 (qmb2548 storage2550 vss vss) n12 w=0.5u l=0.13u
MP2556 (qmb2548 storage2550 vdd vdd) p12 w=1.5u l=0.13u
MN2557 (qm2547 qmb2548 vss vss) n12 w=0.5u l=0.13u
MP2558 (qm2547 qmb2548 vdd vdd) p12 w=1.5u l=0.13u
MN2559 (storage2550 n202 vss vss) n12 w=2u l=0.13u
MN2561 (qm2547 n234 storage2560 vss) n12 w=1.2u l=0.13u
MP2562 (qm2547 n240 storage2560 vdd) p12 w=3.6u l=0.13u
MN2563 (div_g3 n225 storage2560 vss) n12 w=1.2u l=0.13u
MP2564 (div_g3 n237 storage2560 vdd) p12 w=3.6u l=0.13u
MN2565 (qb2549 storage2560 vss vss) n12 w=0.5u l=0.13u
MP2566 (qb2549 storage2560 vdd vdd) p12 w=1.5u l=0.13u
MN2567 (div_g3 qb2549 vss vss) n12 w=0.5u l=0.13u
MP2568 (div_g3 qb2549 vdd vdd) p12 w=1.5u l=0.13u
MN2569 (storage2560 n202 vss vss) n12 w=2u l=0.13u
MN2574 (n2424 n225 storage2573 vss) n12 w=1.2u l=0.13u
MP2575 (n2424 n237 storage2573 vdd) p12 w=3.6u l=0.13u
MN2576 (qm2570 n234 storage2573 vss) n12 w=1.2u l=0.13u
MP2577 (qm2570 n240 storage2573 vdd) p12 w=3.6u l=0.13u
MN2578 (qmb2571 storage2573 vss vss) n12 w=0.5u l=0.13u
MP2579 (qmb2571 storage2573 vdd vdd) p12 w=1.5u l=0.13u
MN2580 (qm2570 qmb2571 vss vss) n12 w=0.5u l=0.13u
MP2581 (qm2570 qmb2571 vdd vdd) p12 w=1.5u l=0.13u
MN2582 (storage2573 n202 vss vss) n12 w=2u l=0.13u
MN2584 (qm2570 n234 storage2583 vss) n12 w=1.2u l=0.13u
MP2585 (qm2570 n240 storage2583 vdd) p12 w=3.6u l=0.13u
MN2586 (div_g4 n225 storage2583 vss) n12 w=1.2u l=0.13u
MP2587 (div_g4 n237 storage2583 vdd) p12 w=3.6u l=0.13u
MN2588 (qb2572 storage2583 vss vss) n12 w=0.5u l=0.13u
MP2589 (qb2572 storage2583 vdd vdd) p12 w=1.5u l=0.13u
MN2590 (div_g4 qb2572 vss vss) n12 w=0.5u l=0.13u
MP2591 (div_g4 qb2572 vdd vdd) p12 w=1.5u l=0.13u
MN2592 (storage2583 n202 vss vss) n12 w=2u l=0.13u
MN2597 (n2448 n225 storage2596 vss) n12 w=1.2u l=0.13u
MP2598 (n2448 n237 storage2596 vdd) p12 w=3.6u l=0.13u
MN2599 (qm2593 n234 storage2596 vss) n12 w=1.2u l=0.13u
MP2600 (qm2593 n240 storage2596 vdd) p12 w=3.6u l=0.13u
MN2601 (qmb2594 storage2596 vss vss) n12 w=0.5u l=0.13u
MP2602 (qmb2594 storage2596 vdd vdd) p12 w=1.5u l=0.13u
MN2603 (qm2593 qmb2594 vss vss) n12 w=0.5u l=0.13u
MP2604 (qm2593 qmb2594 vdd vdd) p12 w=1.5u l=0.13u
MN2605 (storage2596 n202 vss vss) n12 w=2u l=0.13u
MN2607 (qm2593 n234 storage2606 vss) n12 w=1.2u l=0.13u
MP2608 (qm2593 n240 storage2606 vdd) p12 w=3.6u l=0.13u
MN2609 (div_g5 n225 storage2606 vss) n12 w=1.2u l=0.13u
MP2610 (div_g5 n237 storage2606 vdd) p12 w=3.6u l=0.13u
MN2611 (qb2595 storage2606 vss vss) n12 w=0.5u l=0.13u
MP2612 (qb2595 storage2606 vdd vdd) p12 w=1.5u l=0.13u
MN2613 (div_g5 qb2595 vss vss) n12 w=0.5u l=0.13u
MP2614 (div_g5 qb2595 vdd vdd) p12 w=1.5u l=0.13u
MN2615 (storage2606 n202 vss vss) n12 w=2u l=0.13u
MN2620 (n2472 n225 storage2619 vss) n12 w=1.2u l=0.13u
MP2621 (n2472 n237 storage2619 vdd) p12 w=3.6u l=0.13u
MN2622 (qm2616 n234 storage2619 vss) n12 w=1.2u l=0.13u
MP2623 (qm2616 n240 storage2619 vdd) p12 w=3.6u l=0.13u
MN2624 (qmb2617 storage2619 vss vss) n12 w=0.5u l=0.13u
MP2625 (qmb2617 storage2619 vdd vdd) p12 w=1.5u l=0.13u
MN2626 (qm2616 qmb2617 vss vss) n12 w=0.5u l=0.13u
MP2627 (qm2616 qmb2617 vdd vdd) p12 w=1.5u l=0.13u
MN2628 (storage2619 n202 vss vss) n12 w=2u l=0.13u
MN2630 (qm2616 n234 storage2629 vss) n12 w=1.2u l=0.13u
MP2631 (qm2616 n240 storage2629 vdd) p12 w=3.6u l=0.13u
MN2632 (div_g6 n225 storage2629 vss) n12 w=1.2u l=0.13u
MP2633 (div_g6 n237 storage2629 vdd) p12 w=3.6u l=0.13u
MN2634 (qb2618 storage2629 vss vss) n12 w=0.5u l=0.13u
MP2635 (qb2618 storage2629 vdd vdd) p12 w=1.5u l=0.13u
MN2636 (div_g6 qb2618 vss vss) n12 w=0.5u l=0.13u
MP2637 (div_g6 qb2618 vdd vdd) p12 w=1.5u l=0.13u
MN2638 (storage2629 n202 vss vss) n12 w=2u l=0.13u
MN2643 (n2301 n225 storage2642 vss) n12 w=1.2u l=0.13u
MP2644 (n2301 n237 storage2642 vdd) p12 w=3.6u l=0.13u
MN2645 (qm2639 n234 storage2642 vss) n12 w=1.2u l=0.13u
MP2646 (qm2639 n240 storage2642 vdd) p12 w=3.6u l=0.13u
MN2647 (qmb2640 storage2642 vss vss) n12 w=0.5u l=0.13u
MP2648 (qmb2640 storage2642 vdd vdd) p12 w=1.5u l=0.13u
MN2649 (qm2639 qmb2640 vss vss) n12 w=0.5u l=0.13u
MP2650 (qm2639 qmb2640 vdd vdd) p12 w=1.5u l=0.13u
MN2651 (storage2642 n202 vss vss) n12 w=2u l=0.13u
MN2653 (qm2639 n234 storage2652 vss) n12 w=1.2u l=0.13u
MP2654 (qm2639 n240 storage2652 vdd) p12 w=3.6u l=0.13u
MN2655 (div_g7 n225 storage2652 vss) n12 w=1.2u l=0.13u
MP2656 (div_g7 n237 storage2652 vdd) p12 w=3.6u l=0.13u
MN2657 (qb2641 storage2652 vss vss) n12 w=0.5u l=0.13u
MP2658 (qb2641 storage2652 vdd vdd) p12 w=1.5u l=0.13u
MN2659 (div_g7 qb2641 vss vss) n12 w=0.5u l=0.13u
MP2660 (div_g7 qb2641 vdd vdd) p12 w=1.5u l=0.13u
MN2661 (storage2652 n202 vss vss) n12 w=2u l=0.13u
MN2664 (n2662 n205 n2663 vss) n12 w=1.6u l=0.13u
MN2665 (n2663 n22 vss vss) n12 w=1.6u l=0.13u
MP2666 (n2662 n205 vdd vdd) p12 w=2.4u l=0.13u
MP2667 (n2662 n22 vdd vdd) p12 w=2.4u l=0.13u
MN2669 (n2668 n2662 vss vss) n12 w=0.8u l=0.13u
MP2670 (n2668 n2662 vdd vdd) p12 w=2.4u l=0.13u
MN2673 (n2671 n19 n2672 vss) n12 w=1.6u l=0.13u
MN2674 (n2672 n205 vss vss) n12 w=1.6u l=0.13u
MP2675 (n2671 n19 vdd vdd) p12 w=2.4u l=0.13u
MP2676 (n2671 n205 vdd vdd) p12 w=2.4u l=0.13u
MN2678 (n2677 n2671 vss vss) n12 w=0.8u l=0.13u
MP2679 (n2677 n2671 vdd vdd) p12 w=2.4u l=0.13u
MN2681 (n2680 n2668 vss vss) n12 w=0.8u l=0.13u
MP2682 (n2680 n2668 vdd vdd) p12 w=2.4u l=0.13u
MN2684 (n2683 n2677 vss vss) n12 w=0.8u l=0.13u
MP2685 (n2683 n2677 vdd vdd) p12 w=2.4u l=0.13u
MN2690 (lead_g0 n2668 storage2689 vss) n12 w=1.2u l=0.13u
MP2691 (lead_g0 n2680 storage2689 vdd) p12 w=3.6u l=0.13u
MN2692 (qm2686 n2677 storage2689 vss) n12 w=1.2u l=0.13u
MP2693 (qm2686 n2683 storage2689 vdd) p12 w=3.6u l=0.13u
MN2694 (qmb2687 storage2689 vss vss) n12 w=0.5u l=0.13u
MP2695 (qmb2687 storage2689 vdd vdd) p12 w=1.5u l=0.13u
MN2696 (qm2686 qmb2687 vss vss) n12 w=0.5u l=0.13u
MP2697 (qm2686 qmb2687 vdd vdd) p12 w=1.5u l=0.13u
MN2698 (storage2689 n202 vss vss) n12 w=2u l=0.13u
MN2700 (qm2686 n2677 storage2699 vss) n12 w=1.2u l=0.13u
MP2701 (qm2686 n2683 storage2699 vdd) p12 w=3.6u l=0.13u
MN2702 (lead_sync1_0 n2668 storage2699 vss) n12 w=1.2u l=0.13u
MP2703 (lead_sync1_0 n2680 storage2699 vdd) p12 w=3.6u l=0.13u
MN2704 (qb2688 storage2699 vss vss) n12 w=0.5u l=0.13u
MP2705 (qb2688 storage2699 vdd vdd) p12 w=1.5u l=0.13u
MN2706 (lead_sync1_0 qb2688 vss vss) n12 w=0.5u l=0.13u
MP2707 (lead_sync1_0 qb2688 vdd vdd) p12 w=1.5u l=0.13u
MN2708 (storage2699 n202 vss vss) n12 w=2u l=0.13u
MN2713 (lead_sync1_0 n2668 storage2712 vss) n12 w=1.2u l=0.13u
MP2714 (lead_sync1_0 n2680 storage2712 vdd) p12 w=3.6u l=0.13u
MN2715 (qm2709 n2677 storage2712 vss) n12 w=1.2u l=0.13u
MP2716 (qm2709 n2683 storage2712 vdd) p12 w=3.6u l=0.13u
MN2717 (qmb2710 storage2712 vss vss) n12 w=0.5u l=0.13u
MP2718 (qmb2710 storage2712 vdd vdd) p12 w=1.5u l=0.13u
MN2719 (qm2709 qmb2710 vss vss) n12 w=0.5u l=0.13u
MP2720 (qm2709 qmb2710 vdd vdd) p12 w=1.5u l=0.13u
MN2721 (storage2712 n202 vss vss) n12 w=2u l=0.13u
MN2723 (qm2709 n2677 storage2722 vss) n12 w=1.2u l=0.13u
MP2724 (qm2709 n2683 storage2722 vdd) p12 w=3.6u l=0.13u
MN2725 (lead_sync2_0 n2668 storage2722 vss) n12 w=1.2u l=0.13u
MP2726 (lead_sync2_0 n2680 storage2722 vdd) p12 w=3.6u l=0.13u
MN2727 (qb2711 storage2722 vss vss) n12 w=0.5u l=0.13u
MP2728 (qb2711 storage2722 vdd vdd) p12 w=1.5u l=0.13u
MN2729 (lead_sync2_0 qb2711 vss vss) n12 w=0.5u l=0.13u
MP2730 (lead_sync2_0 qb2711 vdd vdd) p12 w=1.5u l=0.13u
MN2731 (storage2722 n202 vss vss) n12 w=2u l=0.13u
MN2736 (lead_g1 n2668 storage2735 vss) n12 w=1.2u l=0.13u
MP2737 (lead_g1 n2680 storage2735 vdd) p12 w=3.6u l=0.13u
MN2738 (qm2732 n2677 storage2735 vss) n12 w=1.2u l=0.13u
MP2739 (qm2732 n2683 storage2735 vdd) p12 w=3.6u l=0.13u
MN2740 (qmb2733 storage2735 vss vss) n12 w=0.5u l=0.13u
MP2741 (qmb2733 storage2735 vdd vdd) p12 w=1.5u l=0.13u
MN2742 (qm2732 qmb2733 vss vss) n12 w=0.5u l=0.13u
MP2743 (qm2732 qmb2733 vdd vdd) p12 w=1.5u l=0.13u
MN2744 (storage2735 n202 vss vss) n12 w=2u l=0.13u
MN2746 (qm2732 n2677 storage2745 vss) n12 w=1.2u l=0.13u
MP2747 (qm2732 n2683 storage2745 vdd) p12 w=3.6u l=0.13u
MN2748 (lead_sync1_1 n2668 storage2745 vss) n12 w=1.2u l=0.13u
MP2749 (lead_sync1_1 n2680 storage2745 vdd) p12 w=3.6u l=0.13u
MN2750 (qb2734 storage2745 vss vss) n12 w=0.5u l=0.13u
MP2751 (qb2734 storage2745 vdd vdd) p12 w=1.5u l=0.13u
MN2752 (lead_sync1_1 qb2734 vss vss) n12 w=0.5u l=0.13u
MP2753 (lead_sync1_1 qb2734 vdd vdd) p12 w=1.5u l=0.13u
MN2754 (storage2745 n202 vss vss) n12 w=2u l=0.13u
MN2759 (lead_sync1_1 n2668 storage2758 vss) n12 w=1.2u l=0.13u
MP2760 (lead_sync1_1 n2680 storage2758 vdd) p12 w=3.6u l=0.13u
MN2761 (qm2755 n2677 storage2758 vss) n12 w=1.2u l=0.13u
MP2762 (qm2755 n2683 storage2758 vdd) p12 w=3.6u l=0.13u
MN2763 (qmb2756 storage2758 vss vss) n12 w=0.5u l=0.13u
MP2764 (qmb2756 storage2758 vdd vdd) p12 w=1.5u l=0.13u
MN2765 (qm2755 qmb2756 vss vss) n12 w=0.5u l=0.13u
MP2766 (qm2755 qmb2756 vdd vdd) p12 w=1.5u l=0.13u
MN2767 (storage2758 n202 vss vss) n12 w=2u l=0.13u
MN2769 (qm2755 n2677 storage2768 vss) n12 w=1.2u l=0.13u
MP2770 (qm2755 n2683 storage2768 vdd) p12 w=3.6u l=0.13u
MN2771 (lead_sync2_1 n2668 storage2768 vss) n12 w=1.2u l=0.13u
MP2772 (lead_sync2_1 n2680 storage2768 vdd) p12 w=3.6u l=0.13u
MN2773 (qb2757 storage2768 vss vss) n12 w=0.5u l=0.13u
MP2774 (qb2757 storage2768 vdd vdd) p12 w=1.5u l=0.13u
MN2775 (lead_sync2_1 qb2757 vss vss) n12 w=0.5u l=0.13u
MP2776 (lead_sync2_1 qb2757 vdd vdd) p12 w=1.5u l=0.13u
MN2777 (storage2768 n202 vss vss) n12 w=2u l=0.13u
MN2782 (lead_g2 n2668 storage2781 vss) n12 w=1.2u l=0.13u
MP2783 (lead_g2 n2680 storage2781 vdd) p12 w=3.6u l=0.13u
MN2784 (qm2778 n2677 storage2781 vss) n12 w=1.2u l=0.13u
MP2785 (qm2778 n2683 storage2781 vdd) p12 w=3.6u l=0.13u
MN2786 (qmb2779 storage2781 vss vss) n12 w=0.5u l=0.13u
MP2787 (qmb2779 storage2781 vdd vdd) p12 w=1.5u l=0.13u
MN2788 (qm2778 qmb2779 vss vss) n12 w=0.5u l=0.13u
MP2789 (qm2778 qmb2779 vdd vdd) p12 w=1.5u l=0.13u
MN2790 (storage2781 n202 vss vss) n12 w=2u l=0.13u
MN2792 (qm2778 n2677 storage2791 vss) n12 w=1.2u l=0.13u
MP2793 (qm2778 n2683 storage2791 vdd) p12 w=3.6u l=0.13u
MN2794 (lead_sync1_2 n2668 storage2791 vss) n12 w=1.2u l=0.13u
MP2795 (lead_sync1_2 n2680 storage2791 vdd) p12 w=3.6u l=0.13u
MN2796 (qb2780 storage2791 vss vss) n12 w=0.5u l=0.13u
MP2797 (qb2780 storage2791 vdd vdd) p12 w=1.5u l=0.13u
MN2798 (lead_sync1_2 qb2780 vss vss) n12 w=0.5u l=0.13u
MP2799 (lead_sync1_2 qb2780 vdd vdd) p12 w=1.5u l=0.13u
MN2800 (storage2791 n202 vss vss) n12 w=2u l=0.13u
MN2805 (lead_sync1_2 n2668 storage2804 vss) n12 w=1.2u l=0.13u
MP2806 (lead_sync1_2 n2680 storage2804 vdd) p12 w=3.6u l=0.13u
MN2807 (qm2801 n2677 storage2804 vss) n12 w=1.2u l=0.13u
MP2808 (qm2801 n2683 storage2804 vdd) p12 w=3.6u l=0.13u
MN2809 (qmb2802 storage2804 vss vss) n12 w=0.5u l=0.13u
MP2810 (qmb2802 storage2804 vdd vdd) p12 w=1.5u l=0.13u
MN2811 (qm2801 qmb2802 vss vss) n12 w=0.5u l=0.13u
MP2812 (qm2801 qmb2802 vdd vdd) p12 w=1.5u l=0.13u
MN2813 (storage2804 n202 vss vss) n12 w=2u l=0.13u
MN2815 (qm2801 n2677 storage2814 vss) n12 w=1.2u l=0.13u
MP2816 (qm2801 n2683 storage2814 vdd) p12 w=3.6u l=0.13u
MN2817 (lead_sync2_2 n2668 storage2814 vss) n12 w=1.2u l=0.13u
MP2818 (lead_sync2_2 n2680 storage2814 vdd) p12 w=3.6u l=0.13u
MN2819 (qb2803 storage2814 vss vss) n12 w=0.5u l=0.13u
MP2820 (qb2803 storage2814 vdd vdd) p12 w=1.5u l=0.13u
MN2821 (lead_sync2_2 qb2803 vss vss) n12 w=0.5u l=0.13u
MP2822 (lead_sync2_2 qb2803 vdd vdd) p12 w=1.5u l=0.13u
MN2823 (storage2814 n202 vss vss) n12 w=2u l=0.13u
MN2828 (lead_g3 n2668 storage2827 vss) n12 w=1.2u l=0.13u
MP2829 (lead_g3 n2680 storage2827 vdd) p12 w=3.6u l=0.13u
MN2830 (qm2824 n2677 storage2827 vss) n12 w=1.2u l=0.13u
MP2831 (qm2824 n2683 storage2827 vdd) p12 w=3.6u l=0.13u
MN2832 (qmb2825 storage2827 vss vss) n12 w=0.5u l=0.13u
MP2833 (qmb2825 storage2827 vdd vdd) p12 w=1.5u l=0.13u
MN2834 (qm2824 qmb2825 vss vss) n12 w=0.5u l=0.13u
MP2835 (qm2824 qmb2825 vdd vdd) p12 w=1.5u l=0.13u
MN2836 (storage2827 n202 vss vss) n12 w=2u l=0.13u
MN2838 (qm2824 n2677 storage2837 vss) n12 w=1.2u l=0.13u
MP2839 (qm2824 n2683 storage2837 vdd) p12 w=3.6u l=0.13u
MN2840 (lead_sync1_3 n2668 storage2837 vss) n12 w=1.2u l=0.13u
MP2841 (lead_sync1_3 n2680 storage2837 vdd) p12 w=3.6u l=0.13u
MN2842 (qb2826 storage2837 vss vss) n12 w=0.5u l=0.13u
MP2843 (qb2826 storage2837 vdd vdd) p12 w=1.5u l=0.13u
MN2844 (lead_sync1_3 qb2826 vss vss) n12 w=0.5u l=0.13u
MP2845 (lead_sync1_3 qb2826 vdd vdd) p12 w=1.5u l=0.13u
MN2846 (storage2837 n202 vss vss) n12 w=2u l=0.13u
MN2851 (lead_sync1_3 n2668 storage2850 vss) n12 w=1.2u l=0.13u
MP2852 (lead_sync1_3 n2680 storage2850 vdd) p12 w=3.6u l=0.13u
MN2853 (qm2847 n2677 storage2850 vss) n12 w=1.2u l=0.13u
MP2854 (qm2847 n2683 storage2850 vdd) p12 w=3.6u l=0.13u
MN2855 (qmb2848 storage2850 vss vss) n12 w=0.5u l=0.13u
MP2856 (qmb2848 storage2850 vdd vdd) p12 w=1.5u l=0.13u
MN2857 (qm2847 qmb2848 vss vss) n12 w=0.5u l=0.13u
MP2858 (qm2847 qmb2848 vdd vdd) p12 w=1.5u l=0.13u
MN2859 (storage2850 n202 vss vss) n12 w=2u l=0.13u
MN2861 (qm2847 n2677 storage2860 vss) n12 w=1.2u l=0.13u
MP2862 (qm2847 n2683 storage2860 vdd) p12 w=3.6u l=0.13u
MN2863 (lead_sync2_3 n2668 storage2860 vss) n12 w=1.2u l=0.13u
MP2864 (lead_sync2_3 n2680 storage2860 vdd) p12 w=3.6u l=0.13u
MN2865 (qb2849 storage2860 vss vss) n12 w=0.5u l=0.13u
MP2866 (qb2849 storage2860 vdd vdd) p12 w=1.5u l=0.13u
MN2867 (lead_sync2_3 qb2849 vss vss) n12 w=0.5u l=0.13u
MP2868 (lead_sync2_3 qb2849 vdd vdd) p12 w=1.5u l=0.13u
MN2869 (storage2860 n202 vss vss) n12 w=2u l=0.13u
MN2874 (lead_g4 n2668 storage2873 vss) n12 w=1.2u l=0.13u
MP2875 (lead_g4 n2680 storage2873 vdd) p12 w=3.6u l=0.13u
MN2876 (qm2870 n2677 storage2873 vss) n12 w=1.2u l=0.13u
MP2877 (qm2870 n2683 storage2873 vdd) p12 w=3.6u l=0.13u
MN2878 (qmb2871 storage2873 vss vss) n12 w=0.5u l=0.13u
MP2879 (qmb2871 storage2873 vdd vdd) p12 w=1.5u l=0.13u
MN2880 (qm2870 qmb2871 vss vss) n12 w=0.5u l=0.13u
MP2881 (qm2870 qmb2871 vdd vdd) p12 w=1.5u l=0.13u
MN2882 (storage2873 n202 vss vss) n12 w=2u l=0.13u
MN2884 (qm2870 n2677 storage2883 vss) n12 w=1.2u l=0.13u
MP2885 (qm2870 n2683 storage2883 vdd) p12 w=3.6u l=0.13u
MN2886 (lead_sync1_4 n2668 storage2883 vss) n12 w=1.2u l=0.13u
MP2887 (lead_sync1_4 n2680 storage2883 vdd) p12 w=3.6u l=0.13u
MN2888 (qb2872 storage2883 vss vss) n12 w=0.5u l=0.13u
MP2889 (qb2872 storage2883 vdd vdd) p12 w=1.5u l=0.13u
MN2890 (lead_sync1_4 qb2872 vss vss) n12 w=0.5u l=0.13u
MP2891 (lead_sync1_4 qb2872 vdd vdd) p12 w=1.5u l=0.13u
MN2892 (storage2883 n202 vss vss) n12 w=2u l=0.13u
MN2897 (lead_sync1_4 n2668 storage2896 vss) n12 w=1.2u l=0.13u
MP2898 (lead_sync1_4 n2680 storage2896 vdd) p12 w=3.6u l=0.13u
MN2899 (qm2893 n2677 storage2896 vss) n12 w=1.2u l=0.13u
MP2900 (qm2893 n2683 storage2896 vdd) p12 w=3.6u l=0.13u
MN2901 (qmb2894 storage2896 vss vss) n12 w=0.5u l=0.13u
MP2902 (qmb2894 storage2896 vdd vdd) p12 w=1.5u l=0.13u
MN2903 (qm2893 qmb2894 vss vss) n12 w=0.5u l=0.13u
MP2904 (qm2893 qmb2894 vdd vdd) p12 w=1.5u l=0.13u
MN2905 (storage2896 n202 vss vss) n12 w=2u l=0.13u
MN2907 (qm2893 n2677 storage2906 vss) n12 w=1.2u l=0.13u
MP2908 (qm2893 n2683 storage2906 vdd) p12 w=3.6u l=0.13u
MN2909 (lead_sync2_4 n2668 storage2906 vss) n12 w=1.2u l=0.13u
MP2910 (lead_sync2_4 n2680 storage2906 vdd) p12 w=3.6u l=0.13u
MN2911 (qb2895 storage2906 vss vss) n12 w=0.5u l=0.13u
MP2912 (qb2895 storage2906 vdd vdd) p12 w=1.5u l=0.13u
MN2913 (lead_sync2_4 qb2895 vss vss) n12 w=0.5u l=0.13u
MP2914 (lead_sync2_4 qb2895 vdd vdd) p12 w=1.5u l=0.13u
MN2915 (storage2906 n202 vss vss) n12 w=2u l=0.13u
MN2920 (lead_g5 n2668 storage2919 vss) n12 w=1.2u l=0.13u
MP2921 (lead_g5 n2680 storage2919 vdd) p12 w=3.6u l=0.13u
MN2922 (qm2916 n2677 storage2919 vss) n12 w=1.2u l=0.13u
MP2923 (qm2916 n2683 storage2919 vdd) p12 w=3.6u l=0.13u
MN2924 (qmb2917 storage2919 vss vss) n12 w=0.5u l=0.13u
MP2925 (qmb2917 storage2919 vdd vdd) p12 w=1.5u l=0.13u
MN2926 (qm2916 qmb2917 vss vss) n12 w=0.5u l=0.13u
MP2927 (qm2916 qmb2917 vdd vdd) p12 w=1.5u l=0.13u
MN2928 (storage2919 n202 vss vss) n12 w=2u l=0.13u
MN2930 (qm2916 n2677 storage2929 vss) n12 w=1.2u l=0.13u
MP2931 (qm2916 n2683 storage2929 vdd) p12 w=3.6u l=0.13u
MN2932 (lead_sync1_5 n2668 storage2929 vss) n12 w=1.2u l=0.13u
MP2933 (lead_sync1_5 n2680 storage2929 vdd) p12 w=3.6u l=0.13u
MN2934 (qb2918 storage2929 vss vss) n12 w=0.5u l=0.13u
MP2935 (qb2918 storage2929 vdd vdd) p12 w=1.5u l=0.13u
MN2936 (lead_sync1_5 qb2918 vss vss) n12 w=0.5u l=0.13u
MP2937 (lead_sync1_5 qb2918 vdd vdd) p12 w=1.5u l=0.13u
MN2938 (storage2929 n202 vss vss) n12 w=2u l=0.13u
MN2943 (lead_sync1_5 n2668 storage2942 vss) n12 w=1.2u l=0.13u
MP2944 (lead_sync1_5 n2680 storage2942 vdd) p12 w=3.6u l=0.13u
MN2945 (qm2939 n2677 storage2942 vss) n12 w=1.2u l=0.13u
MP2946 (qm2939 n2683 storage2942 vdd) p12 w=3.6u l=0.13u
MN2947 (qmb2940 storage2942 vss vss) n12 w=0.5u l=0.13u
MP2948 (qmb2940 storage2942 vdd vdd) p12 w=1.5u l=0.13u
MN2949 (qm2939 qmb2940 vss vss) n12 w=0.5u l=0.13u
MP2950 (qm2939 qmb2940 vdd vdd) p12 w=1.5u l=0.13u
MN2951 (storage2942 n202 vss vss) n12 w=2u l=0.13u
MN2953 (qm2939 n2677 storage2952 vss) n12 w=1.2u l=0.13u
MP2954 (qm2939 n2683 storage2952 vdd) p12 w=3.6u l=0.13u
MN2955 (lead_sync2_5 n2668 storage2952 vss) n12 w=1.2u l=0.13u
MP2956 (lead_sync2_5 n2680 storage2952 vdd) p12 w=3.6u l=0.13u
MN2957 (qb2941 storage2952 vss vss) n12 w=0.5u l=0.13u
MP2958 (qb2941 storage2952 vdd vdd) p12 w=1.5u l=0.13u
MN2959 (lead_sync2_5 qb2941 vss vss) n12 w=0.5u l=0.13u
MP2960 (lead_sync2_5 qb2941 vdd vdd) p12 w=1.5u l=0.13u
MN2961 (storage2952 n202 vss vss) n12 w=2u l=0.13u
MN2966 (lead_g6 n2668 storage2965 vss) n12 w=1.2u l=0.13u
MP2967 (lead_g6 n2680 storage2965 vdd) p12 w=3.6u l=0.13u
MN2968 (qm2962 n2677 storage2965 vss) n12 w=1.2u l=0.13u
MP2969 (qm2962 n2683 storage2965 vdd) p12 w=3.6u l=0.13u
MN2970 (qmb2963 storage2965 vss vss) n12 w=0.5u l=0.13u
MP2971 (qmb2963 storage2965 vdd vdd) p12 w=1.5u l=0.13u
MN2972 (qm2962 qmb2963 vss vss) n12 w=0.5u l=0.13u
MP2973 (qm2962 qmb2963 vdd vdd) p12 w=1.5u l=0.13u
MN2974 (storage2965 n202 vss vss) n12 w=2u l=0.13u
MN2976 (qm2962 n2677 storage2975 vss) n12 w=1.2u l=0.13u
MP2977 (qm2962 n2683 storage2975 vdd) p12 w=3.6u l=0.13u
MN2978 (lead_sync1_6 n2668 storage2975 vss) n12 w=1.2u l=0.13u
MP2979 (lead_sync1_6 n2680 storage2975 vdd) p12 w=3.6u l=0.13u
MN2980 (qb2964 storage2975 vss vss) n12 w=0.5u l=0.13u
MP2981 (qb2964 storage2975 vdd vdd) p12 w=1.5u l=0.13u
MN2982 (lead_sync1_6 qb2964 vss vss) n12 w=0.5u l=0.13u
MP2983 (lead_sync1_6 qb2964 vdd vdd) p12 w=1.5u l=0.13u
MN2984 (storage2975 n202 vss vss) n12 w=2u l=0.13u
MN2989 (lead_sync1_6 n2668 storage2988 vss) n12 w=1.2u l=0.13u
MP2990 (lead_sync1_6 n2680 storage2988 vdd) p12 w=3.6u l=0.13u
MN2991 (qm2985 n2677 storage2988 vss) n12 w=1.2u l=0.13u
MP2992 (qm2985 n2683 storage2988 vdd) p12 w=3.6u l=0.13u
MN2993 (qmb2986 storage2988 vss vss) n12 w=0.5u l=0.13u
MP2994 (qmb2986 storage2988 vdd vdd) p12 w=1.5u l=0.13u
MN2995 (qm2985 qmb2986 vss vss) n12 w=0.5u l=0.13u
MP2996 (qm2985 qmb2986 vdd vdd) p12 w=1.5u l=0.13u
MN2997 (storage2988 n202 vss vss) n12 w=2u l=0.13u
MN2999 (qm2985 n2677 storage2998 vss) n12 w=1.2u l=0.13u
MP3000 (qm2985 n2683 storage2998 vdd) p12 w=3.6u l=0.13u
MN3001 (lead_sync2_6 n2668 storage2998 vss) n12 w=1.2u l=0.13u
MP3002 (lead_sync2_6 n2680 storage2998 vdd) p12 w=3.6u l=0.13u
MN3003 (qb2987 storage2998 vss vss) n12 w=0.5u l=0.13u
MP3004 (qb2987 storage2998 vdd vdd) p12 w=1.5u l=0.13u
MN3005 (lead_sync2_6 qb2987 vss vss) n12 w=0.5u l=0.13u
MP3006 (lead_sync2_6 qb2987 vdd vdd) p12 w=1.5u l=0.13u
MN3007 (storage2998 n202 vss vss) n12 w=2u l=0.13u
MN3012 (lead_g7 n2668 storage3011 vss) n12 w=1.2u l=0.13u
MP3013 (lead_g7 n2680 storage3011 vdd) p12 w=3.6u l=0.13u
MN3014 (qm3008 n2677 storage3011 vss) n12 w=1.2u l=0.13u
MP3015 (qm3008 n2683 storage3011 vdd) p12 w=3.6u l=0.13u
MN3016 (qmb3009 storage3011 vss vss) n12 w=0.5u l=0.13u
MP3017 (qmb3009 storage3011 vdd vdd) p12 w=1.5u l=0.13u
MN3018 (qm3008 qmb3009 vss vss) n12 w=0.5u l=0.13u
MP3019 (qm3008 qmb3009 vdd vdd) p12 w=1.5u l=0.13u
MN3020 (storage3011 n202 vss vss) n12 w=2u l=0.13u
MN3022 (qm3008 n2677 storage3021 vss) n12 w=1.2u l=0.13u
MP3023 (qm3008 n2683 storage3021 vdd) p12 w=3.6u l=0.13u
MN3024 (lead_sync1_7 n2668 storage3021 vss) n12 w=1.2u l=0.13u
MP3025 (lead_sync1_7 n2680 storage3021 vdd) p12 w=3.6u l=0.13u
MN3026 (qb3010 storage3021 vss vss) n12 w=0.5u l=0.13u
MP3027 (qb3010 storage3021 vdd vdd) p12 w=1.5u l=0.13u
MN3028 (lead_sync1_7 qb3010 vss vss) n12 w=0.5u l=0.13u
MP3029 (lead_sync1_7 qb3010 vdd vdd) p12 w=1.5u l=0.13u
MN3030 (storage3021 n202 vss vss) n12 w=2u l=0.13u
MN3035 (lead_sync1_7 n2668 storage3034 vss) n12 w=1.2u l=0.13u
MP3036 (lead_sync1_7 n2680 storage3034 vdd) p12 w=3.6u l=0.13u
MN3037 (qm3031 n2677 storage3034 vss) n12 w=1.2u l=0.13u
MP3038 (qm3031 n2683 storage3034 vdd) p12 w=3.6u l=0.13u
MN3039 (qmb3032 storage3034 vss vss) n12 w=0.5u l=0.13u
MP3040 (qmb3032 storage3034 vdd vdd) p12 w=1.5u l=0.13u
MN3041 (qm3031 qmb3032 vss vss) n12 w=0.5u l=0.13u
MP3042 (qm3031 qmb3032 vdd vdd) p12 w=1.5u l=0.13u
MN3043 (storage3034 n202 vss vss) n12 w=2u l=0.13u
MN3045 (qm3031 n2677 storage3044 vss) n12 w=1.2u l=0.13u
MP3046 (qm3031 n2683 storage3044 vdd) p12 w=3.6u l=0.13u
MN3047 (lead_sync2_7 n2668 storage3044 vss) n12 w=1.2u l=0.13u
MP3048 (lead_sync2_7 n2680 storage3044 vdd) p12 w=3.6u l=0.13u
MN3049 (qb3033 storage3044 vss vss) n12 w=0.5u l=0.13u
MP3050 (qb3033 storage3044 vdd vdd) p12 w=1.5u l=0.13u
MN3051 (lead_sync2_7 qb3033 vss vss) n12 w=0.5u l=0.13u
MP3052 (lead_sync2_7 qb3033 vdd vdd) p12 w=1.5u l=0.13u
MN3053 (storage3044 n202 vss vss) n12 w=2u l=0.13u
MN3058 (lag_g0 n2668 storage3057 vss) n12 w=1.2u l=0.13u
MP3059 (lag_g0 n2680 storage3057 vdd) p12 w=3.6u l=0.13u
MN3060 (qm3054 n2677 storage3057 vss) n12 w=1.2u l=0.13u
MP3061 (qm3054 n2683 storage3057 vdd) p12 w=3.6u l=0.13u
MN3062 (qmb3055 storage3057 vss vss) n12 w=0.5u l=0.13u
MP3063 (qmb3055 storage3057 vdd vdd) p12 w=1.5u l=0.13u
MN3064 (qm3054 qmb3055 vss vss) n12 w=0.5u l=0.13u
MP3065 (qm3054 qmb3055 vdd vdd) p12 w=1.5u l=0.13u
MN3066 (storage3057 n202 vss vss) n12 w=2u l=0.13u
MN3068 (qm3054 n2677 storage3067 vss) n12 w=1.2u l=0.13u
MP3069 (qm3054 n2683 storage3067 vdd) p12 w=3.6u l=0.13u
MN3070 (lag_sync1_0 n2668 storage3067 vss) n12 w=1.2u l=0.13u
MP3071 (lag_sync1_0 n2680 storage3067 vdd) p12 w=3.6u l=0.13u
MN3072 (qb3056 storage3067 vss vss) n12 w=0.5u l=0.13u
MP3073 (qb3056 storage3067 vdd vdd) p12 w=1.5u l=0.13u
MN3074 (lag_sync1_0 qb3056 vss vss) n12 w=0.5u l=0.13u
MP3075 (lag_sync1_0 qb3056 vdd vdd) p12 w=1.5u l=0.13u
MN3076 (storage3067 n202 vss vss) n12 w=2u l=0.13u
MN3081 (lag_sync1_0 n2668 storage3080 vss) n12 w=1.2u l=0.13u
MP3082 (lag_sync1_0 n2680 storage3080 vdd) p12 w=3.6u l=0.13u
MN3083 (qm3077 n2677 storage3080 vss) n12 w=1.2u l=0.13u
MP3084 (qm3077 n2683 storage3080 vdd) p12 w=3.6u l=0.13u
MN3085 (qmb3078 storage3080 vss vss) n12 w=0.5u l=0.13u
MP3086 (qmb3078 storage3080 vdd vdd) p12 w=1.5u l=0.13u
MN3087 (qm3077 qmb3078 vss vss) n12 w=0.5u l=0.13u
MP3088 (qm3077 qmb3078 vdd vdd) p12 w=1.5u l=0.13u
MN3089 (storage3080 n202 vss vss) n12 w=2u l=0.13u
MN3091 (qm3077 n2677 storage3090 vss) n12 w=1.2u l=0.13u
MP3092 (qm3077 n2683 storage3090 vdd) p12 w=3.6u l=0.13u
MN3093 (lag_sync2_0 n2668 storage3090 vss) n12 w=1.2u l=0.13u
MP3094 (lag_sync2_0 n2680 storage3090 vdd) p12 w=3.6u l=0.13u
MN3095 (qb3079 storage3090 vss vss) n12 w=0.5u l=0.13u
MP3096 (qb3079 storage3090 vdd vdd) p12 w=1.5u l=0.13u
MN3097 (lag_sync2_0 qb3079 vss vss) n12 w=0.5u l=0.13u
MP3098 (lag_sync2_0 qb3079 vdd vdd) p12 w=1.5u l=0.13u
MN3099 (storage3090 n202 vss vss) n12 w=2u l=0.13u
MN3104 (lag_g1 n2668 storage3103 vss) n12 w=1.2u l=0.13u
MP3105 (lag_g1 n2680 storage3103 vdd) p12 w=3.6u l=0.13u
MN3106 (qm3100 n2677 storage3103 vss) n12 w=1.2u l=0.13u
MP3107 (qm3100 n2683 storage3103 vdd) p12 w=3.6u l=0.13u
MN3108 (qmb3101 storage3103 vss vss) n12 w=0.5u l=0.13u
MP3109 (qmb3101 storage3103 vdd vdd) p12 w=1.5u l=0.13u
MN3110 (qm3100 qmb3101 vss vss) n12 w=0.5u l=0.13u
MP3111 (qm3100 qmb3101 vdd vdd) p12 w=1.5u l=0.13u
MN3112 (storage3103 n202 vss vss) n12 w=2u l=0.13u
MN3114 (qm3100 n2677 storage3113 vss) n12 w=1.2u l=0.13u
MP3115 (qm3100 n2683 storage3113 vdd) p12 w=3.6u l=0.13u
MN3116 (lag_sync1_1 n2668 storage3113 vss) n12 w=1.2u l=0.13u
MP3117 (lag_sync1_1 n2680 storage3113 vdd) p12 w=3.6u l=0.13u
MN3118 (qb3102 storage3113 vss vss) n12 w=0.5u l=0.13u
MP3119 (qb3102 storage3113 vdd vdd) p12 w=1.5u l=0.13u
MN3120 (lag_sync1_1 qb3102 vss vss) n12 w=0.5u l=0.13u
MP3121 (lag_sync1_1 qb3102 vdd vdd) p12 w=1.5u l=0.13u
MN3122 (storage3113 n202 vss vss) n12 w=2u l=0.13u
MN3127 (lag_sync1_1 n2668 storage3126 vss) n12 w=1.2u l=0.13u
MP3128 (lag_sync1_1 n2680 storage3126 vdd) p12 w=3.6u l=0.13u
MN3129 (qm3123 n2677 storage3126 vss) n12 w=1.2u l=0.13u
MP3130 (qm3123 n2683 storage3126 vdd) p12 w=3.6u l=0.13u
MN3131 (qmb3124 storage3126 vss vss) n12 w=0.5u l=0.13u
MP3132 (qmb3124 storage3126 vdd vdd) p12 w=1.5u l=0.13u
MN3133 (qm3123 qmb3124 vss vss) n12 w=0.5u l=0.13u
MP3134 (qm3123 qmb3124 vdd vdd) p12 w=1.5u l=0.13u
MN3135 (storage3126 n202 vss vss) n12 w=2u l=0.13u
MN3137 (qm3123 n2677 storage3136 vss) n12 w=1.2u l=0.13u
MP3138 (qm3123 n2683 storage3136 vdd) p12 w=3.6u l=0.13u
MN3139 (lag_sync2_1 n2668 storage3136 vss) n12 w=1.2u l=0.13u
MP3140 (lag_sync2_1 n2680 storage3136 vdd) p12 w=3.6u l=0.13u
MN3141 (qb3125 storage3136 vss vss) n12 w=0.5u l=0.13u
MP3142 (qb3125 storage3136 vdd vdd) p12 w=1.5u l=0.13u
MN3143 (lag_sync2_1 qb3125 vss vss) n12 w=0.5u l=0.13u
MP3144 (lag_sync2_1 qb3125 vdd vdd) p12 w=1.5u l=0.13u
MN3145 (storage3136 n202 vss vss) n12 w=2u l=0.13u
MN3150 (lag_g2 n2668 storage3149 vss) n12 w=1.2u l=0.13u
MP3151 (lag_g2 n2680 storage3149 vdd) p12 w=3.6u l=0.13u
MN3152 (qm3146 n2677 storage3149 vss) n12 w=1.2u l=0.13u
MP3153 (qm3146 n2683 storage3149 vdd) p12 w=3.6u l=0.13u
MN3154 (qmb3147 storage3149 vss vss) n12 w=0.5u l=0.13u
MP3155 (qmb3147 storage3149 vdd vdd) p12 w=1.5u l=0.13u
MN3156 (qm3146 qmb3147 vss vss) n12 w=0.5u l=0.13u
MP3157 (qm3146 qmb3147 vdd vdd) p12 w=1.5u l=0.13u
MN3158 (storage3149 n202 vss vss) n12 w=2u l=0.13u
MN3160 (qm3146 n2677 storage3159 vss) n12 w=1.2u l=0.13u
MP3161 (qm3146 n2683 storage3159 vdd) p12 w=3.6u l=0.13u
MN3162 (lag_sync1_2 n2668 storage3159 vss) n12 w=1.2u l=0.13u
MP3163 (lag_sync1_2 n2680 storage3159 vdd) p12 w=3.6u l=0.13u
MN3164 (qb3148 storage3159 vss vss) n12 w=0.5u l=0.13u
MP3165 (qb3148 storage3159 vdd vdd) p12 w=1.5u l=0.13u
MN3166 (lag_sync1_2 qb3148 vss vss) n12 w=0.5u l=0.13u
MP3167 (lag_sync1_2 qb3148 vdd vdd) p12 w=1.5u l=0.13u
MN3168 (storage3159 n202 vss vss) n12 w=2u l=0.13u
MN3173 (lag_sync1_2 n2668 storage3172 vss) n12 w=1.2u l=0.13u
MP3174 (lag_sync1_2 n2680 storage3172 vdd) p12 w=3.6u l=0.13u
MN3175 (qm3169 n2677 storage3172 vss) n12 w=1.2u l=0.13u
MP3176 (qm3169 n2683 storage3172 vdd) p12 w=3.6u l=0.13u
MN3177 (qmb3170 storage3172 vss vss) n12 w=0.5u l=0.13u
MP3178 (qmb3170 storage3172 vdd vdd) p12 w=1.5u l=0.13u
MN3179 (qm3169 qmb3170 vss vss) n12 w=0.5u l=0.13u
MP3180 (qm3169 qmb3170 vdd vdd) p12 w=1.5u l=0.13u
MN3181 (storage3172 n202 vss vss) n12 w=2u l=0.13u
MN3183 (qm3169 n2677 storage3182 vss) n12 w=1.2u l=0.13u
MP3184 (qm3169 n2683 storage3182 vdd) p12 w=3.6u l=0.13u
MN3185 (lag_sync2_2 n2668 storage3182 vss) n12 w=1.2u l=0.13u
MP3186 (lag_sync2_2 n2680 storage3182 vdd) p12 w=3.6u l=0.13u
MN3187 (qb3171 storage3182 vss vss) n12 w=0.5u l=0.13u
MP3188 (qb3171 storage3182 vdd vdd) p12 w=1.5u l=0.13u
MN3189 (lag_sync2_2 qb3171 vss vss) n12 w=0.5u l=0.13u
MP3190 (lag_sync2_2 qb3171 vdd vdd) p12 w=1.5u l=0.13u
MN3191 (storage3182 n202 vss vss) n12 w=2u l=0.13u
MN3196 (lag_g3 n2668 storage3195 vss) n12 w=1.2u l=0.13u
MP3197 (lag_g3 n2680 storage3195 vdd) p12 w=3.6u l=0.13u
MN3198 (qm3192 n2677 storage3195 vss) n12 w=1.2u l=0.13u
MP3199 (qm3192 n2683 storage3195 vdd) p12 w=3.6u l=0.13u
MN3200 (qmb3193 storage3195 vss vss) n12 w=0.5u l=0.13u
MP3201 (qmb3193 storage3195 vdd vdd) p12 w=1.5u l=0.13u
MN3202 (qm3192 qmb3193 vss vss) n12 w=0.5u l=0.13u
MP3203 (qm3192 qmb3193 vdd vdd) p12 w=1.5u l=0.13u
MN3204 (storage3195 n202 vss vss) n12 w=2u l=0.13u
MN3206 (qm3192 n2677 storage3205 vss) n12 w=1.2u l=0.13u
MP3207 (qm3192 n2683 storage3205 vdd) p12 w=3.6u l=0.13u
MN3208 (lag_sync1_3 n2668 storage3205 vss) n12 w=1.2u l=0.13u
MP3209 (lag_sync1_3 n2680 storage3205 vdd) p12 w=3.6u l=0.13u
MN3210 (qb3194 storage3205 vss vss) n12 w=0.5u l=0.13u
MP3211 (qb3194 storage3205 vdd vdd) p12 w=1.5u l=0.13u
MN3212 (lag_sync1_3 qb3194 vss vss) n12 w=0.5u l=0.13u
MP3213 (lag_sync1_3 qb3194 vdd vdd) p12 w=1.5u l=0.13u
MN3214 (storage3205 n202 vss vss) n12 w=2u l=0.13u
MN3219 (lag_sync1_3 n2668 storage3218 vss) n12 w=1.2u l=0.13u
MP3220 (lag_sync1_3 n2680 storage3218 vdd) p12 w=3.6u l=0.13u
MN3221 (qm3215 n2677 storage3218 vss) n12 w=1.2u l=0.13u
MP3222 (qm3215 n2683 storage3218 vdd) p12 w=3.6u l=0.13u
MN3223 (qmb3216 storage3218 vss vss) n12 w=0.5u l=0.13u
MP3224 (qmb3216 storage3218 vdd vdd) p12 w=1.5u l=0.13u
MN3225 (qm3215 qmb3216 vss vss) n12 w=0.5u l=0.13u
MP3226 (qm3215 qmb3216 vdd vdd) p12 w=1.5u l=0.13u
MN3227 (storage3218 n202 vss vss) n12 w=2u l=0.13u
MN3229 (qm3215 n2677 storage3228 vss) n12 w=1.2u l=0.13u
MP3230 (qm3215 n2683 storage3228 vdd) p12 w=3.6u l=0.13u
MN3231 (lag_sync2_3 n2668 storage3228 vss) n12 w=1.2u l=0.13u
MP3232 (lag_sync2_3 n2680 storage3228 vdd) p12 w=3.6u l=0.13u
MN3233 (qb3217 storage3228 vss vss) n12 w=0.5u l=0.13u
MP3234 (qb3217 storage3228 vdd vdd) p12 w=1.5u l=0.13u
MN3235 (lag_sync2_3 qb3217 vss vss) n12 w=0.5u l=0.13u
MP3236 (lag_sync2_3 qb3217 vdd vdd) p12 w=1.5u l=0.13u
MN3237 (storage3228 n202 vss vss) n12 w=2u l=0.13u
MN3242 (lag_g4 n2668 storage3241 vss) n12 w=1.2u l=0.13u
MP3243 (lag_g4 n2680 storage3241 vdd) p12 w=3.6u l=0.13u
MN3244 (qm3238 n2677 storage3241 vss) n12 w=1.2u l=0.13u
MP3245 (qm3238 n2683 storage3241 vdd) p12 w=3.6u l=0.13u
MN3246 (qmb3239 storage3241 vss vss) n12 w=0.5u l=0.13u
MP3247 (qmb3239 storage3241 vdd vdd) p12 w=1.5u l=0.13u
MN3248 (qm3238 qmb3239 vss vss) n12 w=0.5u l=0.13u
MP3249 (qm3238 qmb3239 vdd vdd) p12 w=1.5u l=0.13u
MN3250 (storage3241 n202 vss vss) n12 w=2u l=0.13u
MN3252 (qm3238 n2677 storage3251 vss) n12 w=1.2u l=0.13u
MP3253 (qm3238 n2683 storage3251 vdd) p12 w=3.6u l=0.13u
MN3254 (lag_sync1_4 n2668 storage3251 vss) n12 w=1.2u l=0.13u
MP3255 (lag_sync1_4 n2680 storage3251 vdd) p12 w=3.6u l=0.13u
MN3256 (qb3240 storage3251 vss vss) n12 w=0.5u l=0.13u
MP3257 (qb3240 storage3251 vdd vdd) p12 w=1.5u l=0.13u
MN3258 (lag_sync1_4 qb3240 vss vss) n12 w=0.5u l=0.13u
MP3259 (lag_sync1_4 qb3240 vdd vdd) p12 w=1.5u l=0.13u
MN3260 (storage3251 n202 vss vss) n12 w=2u l=0.13u
MN3265 (lag_sync1_4 n2668 storage3264 vss) n12 w=1.2u l=0.13u
MP3266 (lag_sync1_4 n2680 storage3264 vdd) p12 w=3.6u l=0.13u
MN3267 (qm3261 n2677 storage3264 vss) n12 w=1.2u l=0.13u
MP3268 (qm3261 n2683 storage3264 vdd) p12 w=3.6u l=0.13u
MN3269 (qmb3262 storage3264 vss vss) n12 w=0.5u l=0.13u
MP3270 (qmb3262 storage3264 vdd vdd) p12 w=1.5u l=0.13u
MN3271 (qm3261 qmb3262 vss vss) n12 w=0.5u l=0.13u
MP3272 (qm3261 qmb3262 vdd vdd) p12 w=1.5u l=0.13u
MN3273 (storage3264 n202 vss vss) n12 w=2u l=0.13u
MN3275 (qm3261 n2677 storage3274 vss) n12 w=1.2u l=0.13u
MP3276 (qm3261 n2683 storage3274 vdd) p12 w=3.6u l=0.13u
MN3277 (lag_sync2_4 n2668 storage3274 vss) n12 w=1.2u l=0.13u
MP3278 (lag_sync2_4 n2680 storage3274 vdd) p12 w=3.6u l=0.13u
MN3279 (qb3263 storage3274 vss vss) n12 w=0.5u l=0.13u
MP3280 (qb3263 storage3274 vdd vdd) p12 w=1.5u l=0.13u
MN3281 (lag_sync2_4 qb3263 vss vss) n12 w=0.5u l=0.13u
MP3282 (lag_sync2_4 qb3263 vdd vdd) p12 w=1.5u l=0.13u
MN3283 (storage3274 n202 vss vss) n12 w=2u l=0.13u
MN3288 (lag_g5 n2668 storage3287 vss) n12 w=1.2u l=0.13u
MP3289 (lag_g5 n2680 storage3287 vdd) p12 w=3.6u l=0.13u
MN3290 (qm3284 n2677 storage3287 vss) n12 w=1.2u l=0.13u
MP3291 (qm3284 n2683 storage3287 vdd) p12 w=3.6u l=0.13u
MN3292 (qmb3285 storage3287 vss vss) n12 w=0.5u l=0.13u
MP3293 (qmb3285 storage3287 vdd vdd) p12 w=1.5u l=0.13u
MN3294 (qm3284 qmb3285 vss vss) n12 w=0.5u l=0.13u
MP3295 (qm3284 qmb3285 vdd vdd) p12 w=1.5u l=0.13u
MN3296 (storage3287 n202 vss vss) n12 w=2u l=0.13u
MN3298 (qm3284 n2677 storage3297 vss) n12 w=1.2u l=0.13u
MP3299 (qm3284 n2683 storage3297 vdd) p12 w=3.6u l=0.13u
MN3300 (lag_sync1_5 n2668 storage3297 vss) n12 w=1.2u l=0.13u
MP3301 (lag_sync1_5 n2680 storage3297 vdd) p12 w=3.6u l=0.13u
MN3302 (qb3286 storage3297 vss vss) n12 w=0.5u l=0.13u
MP3303 (qb3286 storage3297 vdd vdd) p12 w=1.5u l=0.13u
MN3304 (lag_sync1_5 qb3286 vss vss) n12 w=0.5u l=0.13u
MP3305 (lag_sync1_5 qb3286 vdd vdd) p12 w=1.5u l=0.13u
MN3306 (storage3297 n202 vss vss) n12 w=2u l=0.13u
MN3311 (lag_sync1_5 n2668 storage3310 vss) n12 w=1.2u l=0.13u
MP3312 (lag_sync1_5 n2680 storage3310 vdd) p12 w=3.6u l=0.13u
MN3313 (qm3307 n2677 storage3310 vss) n12 w=1.2u l=0.13u
MP3314 (qm3307 n2683 storage3310 vdd) p12 w=3.6u l=0.13u
MN3315 (qmb3308 storage3310 vss vss) n12 w=0.5u l=0.13u
MP3316 (qmb3308 storage3310 vdd vdd) p12 w=1.5u l=0.13u
MN3317 (qm3307 qmb3308 vss vss) n12 w=0.5u l=0.13u
MP3318 (qm3307 qmb3308 vdd vdd) p12 w=1.5u l=0.13u
MN3319 (storage3310 n202 vss vss) n12 w=2u l=0.13u
MN3321 (qm3307 n2677 storage3320 vss) n12 w=1.2u l=0.13u
MP3322 (qm3307 n2683 storage3320 vdd) p12 w=3.6u l=0.13u
MN3323 (lag_sync2_5 n2668 storage3320 vss) n12 w=1.2u l=0.13u
MP3324 (lag_sync2_5 n2680 storage3320 vdd) p12 w=3.6u l=0.13u
MN3325 (qb3309 storage3320 vss vss) n12 w=0.5u l=0.13u
MP3326 (qb3309 storage3320 vdd vdd) p12 w=1.5u l=0.13u
MN3327 (lag_sync2_5 qb3309 vss vss) n12 w=0.5u l=0.13u
MP3328 (lag_sync2_5 qb3309 vdd vdd) p12 w=1.5u l=0.13u
MN3329 (storage3320 n202 vss vss) n12 w=2u l=0.13u
MN3334 (lag_g6 n2668 storage3333 vss) n12 w=1.2u l=0.13u
MP3335 (lag_g6 n2680 storage3333 vdd) p12 w=3.6u l=0.13u
MN3336 (qm3330 n2677 storage3333 vss) n12 w=1.2u l=0.13u
MP3337 (qm3330 n2683 storage3333 vdd) p12 w=3.6u l=0.13u
MN3338 (qmb3331 storage3333 vss vss) n12 w=0.5u l=0.13u
MP3339 (qmb3331 storage3333 vdd vdd) p12 w=1.5u l=0.13u
MN3340 (qm3330 qmb3331 vss vss) n12 w=0.5u l=0.13u
MP3341 (qm3330 qmb3331 vdd vdd) p12 w=1.5u l=0.13u
MN3342 (storage3333 n202 vss vss) n12 w=2u l=0.13u
MN3344 (qm3330 n2677 storage3343 vss) n12 w=1.2u l=0.13u
MP3345 (qm3330 n2683 storage3343 vdd) p12 w=3.6u l=0.13u
MN3346 (lag_sync1_6 n2668 storage3343 vss) n12 w=1.2u l=0.13u
MP3347 (lag_sync1_6 n2680 storage3343 vdd) p12 w=3.6u l=0.13u
MN3348 (qb3332 storage3343 vss vss) n12 w=0.5u l=0.13u
MP3349 (qb3332 storage3343 vdd vdd) p12 w=1.5u l=0.13u
MN3350 (lag_sync1_6 qb3332 vss vss) n12 w=0.5u l=0.13u
MP3351 (lag_sync1_6 qb3332 vdd vdd) p12 w=1.5u l=0.13u
MN3352 (storage3343 n202 vss vss) n12 w=2u l=0.13u
MN3357 (lag_sync1_6 n2668 storage3356 vss) n12 w=1.2u l=0.13u
MP3358 (lag_sync1_6 n2680 storage3356 vdd) p12 w=3.6u l=0.13u
MN3359 (qm3353 n2677 storage3356 vss) n12 w=1.2u l=0.13u
MP3360 (qm3353 n2683 storage3356 vdd) p12 w=3.6u l=0.13u
MN3361 (qmb3354 storage3356 vss vss) n12 w=0.5u l=0.13u
MP3362 (qmb3354 storage3356 vdd vdd) p12 w=1.5u l=0.13u
MN3363 (qm3353 qmb3354 vss vss) n12 w=0.5u l=0.13u
MP3364 (qm3353 qmb3354 vdd vdd) p12 w=1.5u l=0.13u
MN3365 (storage3356 n202 vss vss) n12 w=2u l=0.13u
MN3367 (qm3353 n2677 storage3366 vss) n12 w=1.2u l=0.13u
MP3368 (qm3353 n2683 storage3366 vdd) p12 w=3.6u l=0.13u
MN3369 (lag_sync2_6 n2668 storage3366 vss) n12 w=1.2u l=0.13u
MP3370 (lag_sync2_6 n2680 storage3366 vdd) p12 w=3.6u l=0.13u
MN3371 (qb3355 storage3366 vss vss) n12 w=0.5u l=0.13u
MP3372 (qb3355 storage3366 vdd vdd) p12 w=1.5u l=0.13u
MN3373 (lag_sync2_6 qb3355 vss vss) n12 w=0.5u l=0.13u
MP3374 (lag_sync2_6 qb3355 vdd vdd) p12 w=1.5u l=0.13u
MN3375 (storage3366 n202 vss vss) n12 w=2u l=0.13u
MN3380 (lag_g7 n2668 storage3379 vss) n12 w=1.2u l=0.13u
MP3381 (lag_g7 n2680 storage3379 vdd) p12 w=3.6u l=0.13u
MN3382 (qm3376 n2677 storage3379 vss) n12 w=1.2u l=0.13u
MP3383 (qm3376 n2683 storage3379 vdd) p12 w=3.6u l=0.13u
MN3384 (qmb3377 storage3379 vss vss) n12 w=0.5u l=0.13u
MP3385 (qmb3377 storage3379 vdd vdd) p12 w=1.5u l=0.13u
MN3386 (qm3376 qmb3377 vss vss) n12 w=0.5u l=0.13u
MP3387 (qm3376 qmb3377 vdd vdd) p12 w=1.5u l=0.13u
MN3388 (storage3379 n202 vss vss) n12 w=2u l=0.13u
MN3390 (qm3376 n2677 storage3389 vss) n12 w=1.2u l=0.13u
MP3391 (qm3376 n2683 storage3389 vdd) p12 w=3.6u l=0.13u
MN3392 (lag_sync1_7 n2668 storage3389 vss) n12 w=1.2u l=0.13u
MP3393 (lag_sync1_7 n2680 storage3389 vdd) p12 w=3.6u l=0.13u
MN3394 (qb3378 storage3389 vss vss) n12 w=0.5u l=0.13u
MP3395 (qb3378 storage3389 vdd vdd) p12 w=1.5u l=0.13u
MN3396 (lag_sync1_7 qb3378 vss vss) n12 w=0.5u l=0.13u
MP3397 (lag_sync1_7 qb3378 vdd vdd) p12 w=1.5u l=0.13u
MN3398 (storage3389 n202 vss vss) n12 w=2u l=0.13u
MN3403 (lag_sync1_7 n2668 storage3402 vss) n12 w=1.2u l=0.13u
MP3404 (lag_sync1_7 n2680 storage3402 vdd) p12 w=3.6u l=0.13u
MN3405 (qm3399 n2677 storage3402 vss) n12 w=1.2u l=0.13u
MP3406 (qm3399 n2683 storage3402 vdd) p12 w=3.6u l=0.13u
MN3407 (qmb3400 storage3402 vss vss) n12 w=0.5u l=0.13u
MP3408 (qmb3400 storage3402 vdd vdd) p12 w=1.5u l=0.13u
MN3409 (qm3399 qmb3400 vss vss) n12 w=0.5u l=0.13u
MP3410 (qm3399 qmb3400 vdd vdd) p12 w=1.5u l=0.13u
MN3411 (storage3402 n202 vss vss) n12 w=2u l=0.13u
MN3413 (qm3399 n2677 storage3412 vss) n12 w=1.2u l=0.13u
MP3414 (qm3399 n2683 storage3412 vdd) p12 w=3.6u l=0.13u
MN3415 (lag_sync2_7 n2668 storage3412 vss) n12 w=1.2u l=0.13u
MP3416 (lag_sync2_7 n2680 storage3412 vdd) p12 w=3.6u l=0.13u
MN3417 (qb3401 storage3412 vss vss) n12 w=0.5u l=0.13u
MP3418 (qb3401 storage3412 vdd vdd) p12 w=1.5u l=0.13u
MN3419 (lag_sync2_7 qb3401 vss vss) n12 w=0.5u l=0.13u
MP3420 (lag_sync2_7 qb3401 vdd vdd) p12 w=1.5u l=0.13u
MN3421 (storage3412 n202 vss vss) n12 w=2u l=0.13u
MN3426 (div_g0 n2668 storage3425 vss) n12 w=1.2u l=0.13u
MP3427 (div_g0 n2680 storage3425 vdd) p12 w=3.6u l=0.13u
MN3428 (qm3422 n2677 storage3425 vss) n12 w=1.2u l=0.13u
MP3429 (qm3422 n2683 storage3425 vdd) p12 w=3.6u l=0.13u
MN3430 (qmb3423 storage3425 vss vss) n12 w=0.5u l=0.13u
MP3431 (qmb3423 storage3425 vdd vdd) p12 w=1.5u l=0.13u
MN3432 (qm3422 qmb3423 vss vss) n12 w=0.5u l=0.13u
MP3433 (qm3422 qmb3423 vdd vdd) p12 w=1.5u l=0.13u
MN3434 (storage3425 n202 vss vss) n12 w=2u l=0.13u
MN3436 (qm3422 n2677 storage3435 vss) n12 w=1.2u l=0.13u
MP3437 (qm3422 n2683 storage3435 vdd) p12 w=3.6u l=0.13u
MN3438 (div_sync1_0 n2668 storage3435 vss) n12 w=1.2u l=0.13u
MP3439 (div_sync1_0 n2680 storage3435 vdd) p12 w=3.6u l=0.13u
MN3440 (qb3424 storage3435 vss vss) n12 w=0.5u l=0.13u
MP3441 (qb3424 storage3435 vdd vdd) p12 w=1.5u l=0.13u
MN3442 (div_sync1_0 qb3424 vss vss) n12 w=0.5u l=0.13u
MP3443 (div_sync1_0 qb3424 vdd vdd) p12 w=1.5u l=0.13u
MN3444 (storage3435 n202 vss vss) n12 w=2u l=0.13u
MN3449 (div_sync1_0 n2668 storage3448 vss) n12 w=1.2u l=0.13u
MP3450 (div_sync1_0 n2680 storage3448 vdd) p12 w=3.6u l=0.13u
MN3451 (qm3445 n2677 storage3448 vss) n12 w=1.2u l=0.13u
MP3452 (qm3445 n2683 storage3448 vdd) p12 w=3.6u l=0.13u
MN3453 (qmb3446 storage3448 vss vss) n12 w=0.5u l=0.13u
MP3454 (qmb3446 storage3448 vdd vdd) p12 w=1.5u l=0.13u
MN3455 (qm3445 qmb3446 vss vss) n12 w=0.5u l=0.13u
MP3456 (qm3445 qmb3446 vdd vdd) p12 w=1.5u l=0.13u
MN3457 (storage3448 n202 vss vss) n12 w=2u l=0.13u
MN3459 (qm3445 n2677 storage3458 vss) n12 w=1.2u l=0.13u
MP3460 (qm3445 n2683 storage3458 vdd) p12 w=3.6u l=0.13u
MN3461 (div_sync2_0 n2668 storage3458 vss) n12 w=1.2u l=0.13u
MP3462 (div_sync2_0 n2680 storage3458 vdd) p12 w=3.6u l=0.13u
MN3463 (qb3447 storage3458 vss vss) n12 w=0.5u l=0.13u
MP3464 (qb3447 storage3458 vdd vdd) p12 w=1.5u l=0.13u
MN3465 (div_sync2_0 qb3447 vss vss) n12 w=0.5u l=0.13u
MP3466 (div_sync2_0 qb3447 vdd vdd) p12 w=1.5u l=0.13u
MN3467 (storage3458 n202 vss vss) n12 w=2u l=0.13u
MN3472 (div_g1 n2668 storage3471 vss) n12 w=1.2u l=0.13u
MP3473 (div_g1 n2680 storage3471 vdd) p12 w=3.6u l=0.13u
MN3474 (qm3468 n2677 storage3471 vss) n12 w=1.2u l=0.13u
MP3475 (qm3468 n2683 storage3471 vdd) p12 w=3.6u l=0.13u
MN3476 (qmb3469 storage3471 vss vss) n12 w=0.5u l=0.13u
MP3477 (qmb3469 storage3471 vdd vdd) p12 w=1.5u l=0.13u
MN3478 (qm3468 qmb3469 vss vss) n12 w=0.5u l=0.13u
MP3479 (qm3468 qmb3469 vdd vdd) p12 w=1.5u l=0.13u
MN3480 (storage3471 n202 vss vss) n12 w=2u l=0.13u
MN3482 (qm3468 n2677 storage3481 vss) n12 w=1.2u l=0.13u
MP3483 (qm3468 n2683 storage3481 vdd) p12 w=3.6u l=0.13u
MN3484 (div_sync1_1 n2668 storage3481 vss) n12 w=1.2u l=0.13u
MP3485 (div_sync1_1 n2680 storage3481 vdd) p12 w=3.6u l=0.13u
MN3486 (qb3470 storage3481 vss vss) n12 w=0.5u l=0.13u
MP3487 (qb3470 storage3481 vdd vdd) p12 w=1.5u l=0.13u
MN3488 (div_sync1_1 qb3470 vss vss) n12 w=0.5u l=0.13u
MP3489 (div_sync1_1 qb3470 vdd vdd) p12 w=1.5u l=0.13u
MN3490 (storage3481 n202 vss vss) n12 w=2u l=0.13u
MN3495 (div_sync1_1 n2668 storage3494 vss) n12 w=1.2u l=0.13u
MP3496 (div_sync1_1 n2680 storage3494 vdd) p12 w=3.6u l=0.13u
MN3497 (qm3491 n2677 storage3494 vss) n12 w=1.2u l=0.13u
MP3498 (qm3491 n2683 storage3494 vdd) p12 w=3.6u l=0.13u
MN3499 (qmb3492 storage3494 vss vss) n12 w=0.5u l=0.13u
MP3500 (qmb3492 storage3494 vdd vdd) p12 w=1.5u l=0.13u
MN3501 (qm3491 qmb3492 vss vss) n12 w=0.5u l=0.13u
MP3502 (qm3491 qmb3492 vdd vdd) p12 w=1.5u l=0.13u
MN3503 (storage3494 n202 vss vss) n12 w=2u l=0.13u
MN3505 (qm3491 n2677 storage3504 vss) n12 w=1.2u l=0.13u
MP3506 (qm3491 n2683 storage3504 vdd) p12 w=3.6u l=0.13u
MN3507 (div_sync2_1 n2668 storage3504 vss) n12 w=1.2u l=0.13u
MP3508 (div_sync2_1 n2680 storage3504 vdd) p12 w=3.6u l=0.13u
MN3509 (qb3493 storage3504 vss vss) n12 w=0.5u l=0.13u
MP3510 (qb3493 storage3504 vdd vdd) p12 w=1.5u l=0.13u
MN3511 (div_sync2_1 qb3493 vss vss) n12 w=0.5u l=0.13u
MP3512 (div_sync2_1 qb3493 vdd vdd) p12 w=1.5u l=0.13u
MN3513 (storage3504 n202 vss vss) n12 w=2u l=0.13u
MN3518 (div_g2 n2668 storage3517 vss) n12 w=1.2u l=0.13u
MP3519 (div_g2 n2680 storage3517 vdd) p12 w=3.6u l=0.13u
MN3520 (qm3514 n2677 storage3517 vss) n12 w=1.2u l=0.13u
MP3521 (qm3514 n2683 storage3517 vdd) p12 w=3.6u l=0.13u
MN3522 (qmb3515 storage3517 vss vss) n12 w=0.5u l=0.13u
MP3523 (qmb3515 storage3517 vdd vdd) p12 w=1.5u l=0.13u
MN3524 (qm3514 qmb3515 vss vss) n12 w=0.5u l=0.13u
MP3525 (qm3514 qmb3515 vdd vdd) p12 w=1.5u l=0.13u
MN3526 (storage3517 n202 vss vss) n12 w=2u l=0.13u
MN3528 (qm3514 n2677 storage3527 vss) n12 w=1.2u l=0.13u
MP3529 (qm3514 n2683 storage3527 vdd) p12 w=3.6u l=0.13u
MN3530 (div_sync1_2 n2668 storage3527 vss) n12 w=1.2u l=0.13u
MP3531 (div_sync1_2 n2680 storage3527 vdd) p12 w=3.6u l=0.13u
MN3532 (qb3516 storage3527 vss vss) n12 w=0.5u l=0.13u
MP3533 (qb3516 storage3527 vdd vdd) p12 w=1.5u l=0.13u
MN3534 (div_sync1_2 qb3516 vss vss) n12 w=0.5u l=0.13u
MP3535 (div_sync1_2 qb3516 vdd vdd) p12 w=1.5u l=0.13u
MN3536 (storage3527 n202 vss vss) n12 w=2u l=0.13u
MN3541 (div_sync1_2 n2668 storage3540 vss) n12 w=1.2u l=0.13u
MP3542 (div_sync1_2 n2680 storage3540 vdd) p12 w=3.6u l=0.13u
MN3543 (qm3537 n2677 storage3540 vss) n12 w=1.2u l=0.13u
MP3544 (qm3537 n2683 storage3540 vdd) p12 w=3.6u l=0.13u
MN3545 (qmb3538 storage3540 vss vss) n12 w=0.5u l=0.13u
MP3546 (qmb3538 storage3540 vdd vdd) p12 w=1.5u l=0.13u
MN3547 (qm3537 qmb3538 vss vss) n12 w=0.5u l=0.13u
MP3548 (qm3537 qmb3538 vdd vdd) p12 w=1.5u l=0.13u
MN3549 (storage3540 n202 vss vss) n12 w=2u l=0.13u
MN3551 (qm3537 n2677 storage3550 vss) n12 w=1.2u l=0.13u
MP3552 (qm3537 n2683 storage3550 vdd) p12 w=3.6u l=0.13u
MN3553 (div_sync2_2 n2668 storage3550 vss) n12 w=1.2u l=0.13u
MP3554 (div_sync2_2 n2680 storage3550 vdd) p12 w=3.6u l=0.13u
MN3555 (qb3539 storage3550 vss vss) n12 w=0.5u l=0.13u
MP3556 (qb3539 storage3550 vdd vdd) p12 w=1.5u l=0.13u
MN3557 (div_sync2_2 qb3539 vss vss) n12 w=0.5u l=0.13u
MP3558 (div_sync2_2 qb3539 vdd vdd) p12 w=1.5u l=0.13u
MN3559 (storage3550 n202 vss vss) n12 w=2u l=0.13u
MN3564 (div_g3 n2668 storage3563 vss) n12 w=1.2u l=0.13u
MP3565 (div_g3 n2680 storage3563 vdd) p12 w=3.6u l=0.13u
MN3566 (qm3560 n2677 storage3563 vss) n12 w=1.2u l=0.13u
MP3567 (qm3560 n2683 storage3563 vdd) p12 w=3.6u l=0.13u
MN3568 (qmb3561 storage3563 vss vss) n12 w=0.5u l=0.13u
MP3569 (qmb3561 storage3563 vdd vdd) p12 w=1.5u l=0.13u
MN3570 (qm3560 qmb3561 vss vss) n12 w=0.5u l=0.13u
MP3571 (qm3560 qmb3561 vdd vdd) p12 w=1.5u l=0.13u
MN3572 (storage3563 n202 vss vss) n12 w=2u l=0.13u
MN3574 (qm3560 n2677 storage3573 vss) n12 w=1.2u l=0.13u
MP3575 (qm3560 n2683 storage3573 vdd) p12 w=3.6u l=0.13u
MN3576 (div_sync1_3 n2668 storage3573 vss) n12 w=1.2u l=0.13u
MP3577 (div_sync1_3 n2680 storage3573 vdd) p12 w=3.6u l=0.13u
MN3578 (qb3562 storage3573 vss vss) n12 w=0.5u l=0.13u
MP3579 (qb3562 storage3573 vdd vdd) p12 w=1.5u l=0.13u
MN3580 (div_sync1_3 qb3562 vss vss) n12 w=0.5u l=0.13u
MP3581 (div_sync1_3 qb3562 vdd vdd) p12 w=1.5u l=0.13u
MN3582 (storage3573 n202 vss vss) n12 w=2u l=0.13u
MN3587 (div_sync1_3 n2668 storage3586 vss) n12 w=1.2u l=0.13u
MP3588 (div_sync1_3 n2680 storage3586 vdd) p12 w=3.6u l=0.13u
MN3589 (qm3583 n2677 storage3586 vss) n12 w=1.2u l=0.13u
MP3590 (qm3583 n2683 storage3586 vdd) p12 w=3.6u l=0.13u
MN3591 (qmb3584 storage3586 vss vss) n12 w=0.5u l=0.13u
MP3592 (qmb3584 storage3586 vdd vdd) p12 w=1.5u l=0.13u
MN3593 (qm3583 qmb3584 vss vss) n12 w=0.5u l=0.13u
MP3594 (qm3583 qmb3584 vdd vdd) p12 w=1.5u l=0.13u
MN3595 (storage3586 n202 vss vss) n12 w=2u l=0.13u
MN3597 (qm3583 n2677 storage3596 vss) n12 w=1.2u l=0.13u
MP3598 (qm3583 n2683 storage3596 vdd) p12 w=3.6u l=0.13u
MN3599 (div_sync2_3 n2668 storage3596 vss) n12 w=1.2u l=0.13u
MP3600 (div_sync2_3 n2680 storage3596 vdd) p12 w=3.6u l=0.13u
MN3601 (qb3585 storage3596 vss vss) n12 w=0.5u l=0.13u
MP3602 (qb3585 storage3596 vdd vdd) p12 w=1.5u l=0.13u
MN3603 (div_sync2_3 qb3585 vss vss) n12 w=0.5u l=0.13u
MP3604 (div_sync2_3 qb3585 vdd vdd) p12 w=1.5u l=0.13u
MN3605 (storage3596 n202 vss vss) n12 w=2u l=0.13u
MN3610 (div_g4 n2668 storage3609 vss) n12 w=1.2u l=0.13u
MP3611 (div_g4 n2680 storage3609 vdd) p12 w=3.6u l=0.13u
MN3612 (qm3606 n2677 storage3609 vss) n12 w=1.2u l=0.13u
MP3613 (qm3606 n2683 storage3609 vdd) p12 w=3.6u l=0.13u
MN3614 (qmb3607 storage3609 vss vss) n12 w=0.5u l=0.13u
MP3615 (qmb3607 storage3609 vdd vdd) p12 w=1.5u l=0.13u
MN3616 (qm3606 qmb3607 vss vss) n12 w=0.5u l=0.13u
MP3617 (qm3606 qmb3607 vdd vdd) p12 w=1.5u l=0.13u
MN3618 (storage3609 n202 vss vss) n12 w=2u l=0.13u
MN3620 (qm3606 n2677 storage3619 vss) n12 w=1.2u l=0.13u
MP3621 (qm3606 n2683 storage3619 vdd) p12 w=3.6u l=0.13u
MN3622 (div_sync1_4 n2668 storage3619 vss) n12 w=1.2u l=0.13u
MP3623 (div_sync1_4 n2680 storage3619 vdd) p12 w=3.6u l=0.13u
MN3624 (qb3608 storage3619 vss vss) n12 w=0.5u l=0.13u
MP3625 (qb3608 storage3619 vdd vdd) p12 w=1.5u l=0.13u
MN3626 (div_sync1_4 qb3608 vss vss) n12 w=0.5u l=0.13u
MP3627 (div_sync1_4 qb3608 vdd vdd) p12 w=1.5u l=0.13u
MN3628 (storage3619 n202 vss vss) n12 w=2u l=0.13u
MN3633 (div_sync1_4 n2668 storage3632 vss) n12 w=1.2u l=0.13u
MP3634 (div_sync1_4 n2680 storage3632 vdd) p12 w=3.6u l=0.13u
MN3635 (qm3629 n2677 storage3632 vss) n12 w=1.2u l=0.13u
MP3636 (qm3629 n2683 storage3632 vdd) p12 w=3.6u l=0.13u
MN3637 (qmb3630 storage3632 vss vss) n12 w=0.5u l=0.13u
MP3638 (qmb3630 storage3632 vdd vdd) p12 w=1.5u l=0.13u
MN3639 (qm3629 qmb3630 vss vss) n12 w=0.5u l=0.13u
MP3640 (qm3629 qmb3630 vdd vdd) p12 w=1.5u l=0.13u
MN3641 (storage3632 n202 vss vss) n12 w=2u l=0.13u
MN3643 (qm3629 n2677 storage3642 vss) n12 w=1.2u l=0.13u
MP3644 (qm3629 n2683 storage3642 vdd) p12 w=3.6u l=0.13u
MN3645 (div_sync2_4 n2668 storage3642 vss) n12 w=1.2u l=0.13u
MP3646 (div_sync2_4 n2680 storage3642 vdd) p12 w=3.6u l=0.13u
MN3647 (qb3631 storage3642 vss vss) n12 w=0.5u l=0.13u
MP3648 (qb3631 storage3642 vdd vdd) p12 w=1.5u l=0.13u
MN3649 (div_sync2_4 qb3631 vss vss) n12 w=0.5u l=0.13u
MP3650 (div_sync2_4 qb3631 vdd vdd) p12 w=1.5u l=0.13u
MN3651 (storage3642 n202 vss vss) n12 w=2u l=0.13u
MN3656 (div_g5 n2668 storage3655 vss) n12 w=1.2u l=0.13u
MP3657 (div_g5 n2680 storage3655 vdd) p12 w=3.6u l=0.13u
MN3658 (qm3652 n2677 storage3655 vss) n12 w=1.2u l=0.13u
MP3659 (qm3652 n2683 storage3655 vdd) p12 w=3.6u l=0.13u
MN3660 (qmb3653 storage3655 vss vss) n12 w=0.5u l=0.13u
MP3661 (qmb3653 storage3655 vdd vdd) p12 w=1.5u l=0.13u
MN3662 (qm3652 qmb3653 vss vss) n12 w=0.5u l=0.13u
MP3663 (qm3652 qmb3653 vdd vdd) p12 w=1.5u l=0.13u
MN3664 (storage3655 n202 vss vss) n12 w=2u l=0.13u
MN3666 (qm3652 n2677 storage3665 vss) n12 w=1.2u l=0.13u
MP3667 (qm3652 n2683 storage3665 vdd) p12 w=3.6u l=0.13u
MN3668 (div_sync1_5 n2668 storage3665 vss) n12 w=1.2u l=0.13u
MP3669 (div_sync1_5 n2680 storage3665 vdd) p12 w=3.6u l=0.13u
MN3670 (qb3654 storage3665 vss vss) n12 w=0.5u l=0.13u
MP3671 (qb3654 storage3665 vdd vdd) p12 w=1.5u l=0.13u
MN3672 (div_sync1_5 qb3654 vss vss) n12 w=0.5u l=0.13u
MP3673 (div_sync1_5 qb3654 vdd vdd) p12 w=1.5u l=0.13u
MN3674 (storage3665 n202 vss vss) n12 w=2u l=0.13u
MN3679 (div_sync1_5 n2668 storage3678 vss) n12 w=1.2u l=0.13u
MP3680 (div_sync1_5 n2680 storage3678 vdd) p12 w=3.6u l=0.13u
MN3681 (qm3675 n2677 storage3678 vss) n12 w=1.2u l=0.13u
MP3682 (qm3675 n2683 storage3678 vdd) p12 w=3.6u l=0.13u
MN3683 (qmb3676 storage3678 vss vss) n12 w=0.5u l=0.13u
MP3684 (qmb3676 storage3678 vdd vdd) p12 w=1.5u l=0.13u
MN3685 (qm3675 qmb3676 vss vss) n12 w=0.5u l=0.13u
MP3686 (qm3675 qmb3676 vdd vdd) p12 w=1.5u l=0.13u
MN3687 (storage3678 n202 vss vss) n12 w=2u l=0.13u
MN3689 (qm3675 n2677 storage3688 vss) n12 w=1.2u l=0.13u
MP3690 (qm3675 n2683 storage3688 vdd) p12 w=3.6u l=0.13u
MN3691 (div_sync2_5 n2668 storage3688 vss) n12 w=1.2u l=0.13u
MP3692 (div_sync2_5 n2680 storage3688 vdd) p12 w=3.6u l=0.13u
MN3693 (qb3677 storage3688 vss vss) n12 w=0.5u l=0.13u
MP3694 (qb3677 storage3688 vdd vdd) p12 w=1.5u l=0.13u
MN3695 (div_sync2_5 qb3677 vss vss) n12 w=0.5u l=0.13u
MP3696 (div_sync2_5 qb3677 vdd vdd) p12 w=1.5u l=0.13u
MN3697 (storage3688 n202 vss vss) n12 w=2u l=0.13u
MN3702 (div_g6 n2668 storage3701 vss) n12 w=1.2u l=0.13u
MP3703 (div_g6 n2680 storage3701 vdd) p12 w=3.6u l=0.13u
MN3704 (qm3698 n2677 storage3701 vss) n12 w=1.2u l=0.13u
MP3705 (qm3698 n2683 storage3701 vdd) p12 w=3.6u l=0.13u
MN3706 (qmb3699 storage3701 vss vss) n12 w=0.5u l=0.13u
MP3707 (qmb3699 storage3701 vdd vdd) p12 w=1.5u l=0.13u
MN3708 (qm3698 qmb3699 vss vss) n12 w=0.5u l=0.13u
MP3709 (qm3698 qmb3699 vdd vdd) p12 w=1.5u l=0.13u
MN3710 (storage3701 n202 vss vss) n12 w=2u l=0.13u
MN3712 (qm3698 n2677 storage3711 vss) n12 w=1.2u l=0.13u
MP3713 (qm3698 n2683 storage3711 vdd) p12 w=3.6u l=0.13u
MN3714 (div_sync1_6 n2668 storage3711 vss) n12 w=1.2u l=0.13u
MP3715 (div_sync1_6 n2680 storage3711 vdd) p12 w=3.6u l=0.13u
MN3716 (qb3700 storage3711 vss vss) n12 w=0.5u l=0.13u
MP3717 (qb3700 storage3711 vdd vdd) p12 w=1.5u l=0.13u
MN3718 (div_sync1_6 qb3700 vss vss) n12 w=0.5u l=0.13u
MP3719 (div_sync1_6 qb3700 vdd vdd) p12 w=1.5u l=0.13u
MN3720 (storage3711 n202 vss vss) n12 w=2u l=0.13u
MN3725 (div_sync1_6 n2668 storage3724 vss) n12 w=1.2u l=0.13u
MP3726 (div_sync1_6 n2680 storage3724 vdd) p12 w=3.6u l=0.13u
MN3727 (qm3721 n2677 storage3724 vss) n12 w=1.2u l=0.13u
MP3728 (qm3721 n2683 storage3724 vdd) p12 w=3.6u l=0.13u
MN3729 (qmb3722 storage3724 vss vss) n12 w=0.5u l=0.13u
MP3730 (qmb3722 storage3724 vdd vdd) p12 w=1.5u l=0.13u
MN3731 (qm3721 qmb3722 vss vss) n12 w=0.5u l=0.13u
MP3732 (qm3721 qmb3722 vdd vdd) p12 w=1.5u l=0.13u
MN3733 (storage3724 n202 vss vss) n12 w=2u l=0.13u
MN3735 (qm3721 n2677 storage3734 vss) n12 w=1.2u l=0.13u
MP3736 (qm3721 n2683 storage3734 vdd) p12 w=3.6u l=0.13u
MN3737 (div_sync2_6 n2668 storage3734 vss) n12 w=1.2u l=0.13u
MP3738 (div_sync2_6 n2680 storage3734 vdd) p12 w=3.6u l=0.13u
MN3739 (qb3723 storage3734 vss vss) n12 w=0.5u l=0.13u
MP3740 (qb3723 storage3734 vdd vdd) p12 w=1.5u l=0.13u
MN3741 (div_sync2_6 qb3723 vss vss) n12 w=0.5u l=0.13u
MP3742 (div_sync2_6 qb3723 vdd vdd) p12 w=1.5u l=0.13u
MN3743 (storage3734 n202 vss vss) n12 w=2u l=0.13u
MN3748 (div_g7 n2668 storage3747 vss) n12 w=1.2u l=0.13u
MP3749 (div_g7 n2680 storage3747 vdd) p12 w=3.6u l=0.13u
MN3750 (qm3744 n2677 storage3747 vss) n12 w=1.2u l=0.13u
MP3751 (qm3744 n2683 storage3747 vdd) p12 w=3.6u l=0.13u
MN3752 (qmb3745 storage3747 vss vss) n12 w=0.5u l=0.13u
MP3753 (qmb3745 storage3747 vdd vdd) p12 w=1.5u l=0.13u
MN3754 (qm3744 qmb3745 vss vss) n12 w=0.5u l=0.13u
MP3755 (qm3744 qmb3745 vdd vdd) p12 w=1.5u l=0.13u
MN3756 (storage3747 n202 vss vss) n12 w=2u l=0.13u
MN3758 (qm3744 n2677 storage3757 vss) n12 w=1.2u l=0.13u
MP3759 (qm3744 n2683 storage3757 vdd) p12 w=3.6u l=0.13u
MN3760 (div_sync1_7 n2668 storage3757 vss) n12 w=1.2u l=0.13u
MP3761 (div_sync1_7 n2680 storage3757 vdd) p12 w=3.6u l=0.13u
MN3762 (qb3746 storage3757 vss vss) n12 w=0.5u l=0.13u
MP3763 (qb3746 storage3757 vdd vdd) p12 w=1.5u l=0.13u
MN3764 (div_sync1_7 qb3746 vss vss) n12 w=0.5u l=0.13u
MP3765 (div_sync1_7 qb3746 vdd vdd) p12 w=1.5u l=0.13u
MN3766 (storage3757 n202 vss vss) n12 w=2u l=0.13u
MN3771 (div_sync1_7 n2668 storage3770 vss) n12 w=1.2u l=0.13u
MP3772 (div_sync1_7 n2680 storage3770 vdd) p12 w=3.6u l=0.13u
MN3773 (qm3767 n2677 storage3770 vss) n12 w=1.2u l=0.13u
MP3774 (qm3767 n2683 storage3770 vdd) p12 w=3.6u l=0.13u
MN3775 (qmb3768 storage3770 vss vss) n12 w=0.5u l=0.13u
MP3776 (qmb3768 storage3770 vdd vdd) p12 w=1.5u l=0.13u
MN3777 (qm3767 qmb3768 vss vss) n12 w=0.5u l=0.13u
MP3778 (qm3767 qmb3768 vdd vdd) p12 w=1.5u l=0.13u
MN3779 (storage3770 n202 vss vss) n12 w=2u l=0.13u
MN3781 (qm3767 n2677 storage3780 vss) n12 w=1.2u l=0.13u
MP3782 (qm3767 n2683 storage3780 vdd) p12 w=3.6u l=0.13u
MN3783 (div_sync2_7 n2668 storage3780 vss) n12 w=1.2u l=0.13u
MP3784 (div_sync2_7 n2680 storage3780 vdd) p12 w=3.6u l=0.13u
MN3785 (qb3769 storage3780 vss vss) n12 w=0.5u l=0.13u
MP3786 (qb3769 storage3780 vdd vdd) p12 w=1.5u l=0.13u
MN3787 (div_sync2_7 qb3769 vss vss) n12 w=0.5u l=0.13u
MP3788 (div_sync2_7 qb3769 vdd vdd) p12 w=1.5u l=0.13u
MN3789 (storage3780 n202 vss vss) n12 w=2u l=0.13u
MN3792 (n3790 lead_sync2_6 n3791 vss) n12 w=1.6u l=0.13u
MN3793 (n3791 lead_sync2_7 vss vss) n12 w=1.6u l=0.13u
MP3794 (n3790 lead_sync2_6 vdd vdd) p12 w=2.4u l=0.13u
MP3795 (n3790 lead_sync2_7 vdd vdd) p12 w=2.4u l=0.13u
MN3798 (n3796 lead_sync2_6 n3797 vss) n12 w=1.6u l=0.13u
MN3799 (n3797 n3790 vss vss) n12 w=1.6u l=0.13u
MP3800 (n3796 lead_sync2_6 vdd vdd) p12 w=2.4u l=0.13u
MP3801 (n3796 n3790 vdd vdd) p12 w=2.4u l=0.13u
MN3804 (n3802 lead_sync2_7 n3803 vss) n12 w=1.6u l=0.13u
MN3805 (n3803 n3790 vss vss) n12 w=1.6u l=0.13u
MP3806 (n3802 lead_sync2_7 vdd vdd) p12 w=2.4u l=0.13u
MP3807 (n3802 n3790 vdd vdd) p12 w=2.4u l=0.13u
MN3810 (n3808 n3796 n3809 vss) n12 w=1.6u l=0.13u
MN3811 (n3809 n3802 vss vss) n12 w=1.6u l=0.13u
MP3812 (n3808 n3796 vdd vdd) p12 w=2.4u l=0.13u
MP3813 (n3808 n3802 vdd vdd) p12 w=2.4u l=0.13u
MN3816 (n3814 lead_sync2_5 n3815 vss) n12 w=1.6u l=0.13u
MN3817 (n3815 n3808 vss vss) n12 w=1.6u l=0.13u
MP3818 (n3814 lead_sync2_5 vdd vdd) p12 w=2.4u l=0.13u
MP3819 (n3814 n3808 vdd vdd) p12 w=2.4u l=0.13u
MN3822 (n3820 lead_sync2_5 n3821 vss) n12 w=1.6u l=0.13u
MN3823 (n3821 n3814 vss vss) n12 w=1.6u l=0.13u
MP3824 (n3820 lead_sync2_5 vdd vdd) p12 w=2.4u l=0.13u
MP3825 (n3820 n3814 vdd vdd) p12 w=2.4u l=0.13u
MN3828 (n3826 n3808 n3827 vss) n12 w=1.6u l=0.13u
MN3829 (n3827 n3814 vss vss) n12 w=1.6u l=0.13u
MP3830 (n3826 n3808 vdd vdd) p12 w=2.4u l=0.13u
MP3831 (n3826 n3814 vdd vdd) p12 w=2.4u l=0.13u
MN3834 (n3832 n3820 n3833 vss) n12 w=1.6u l=0.13u
MN3835 (n3833 n3826 vss vss) n12 w=1.6u l=0.13u
MP3836 (n3832 n3820 vdd vdd) p12 w=2.4u l=0.13u
MP3837 (n3832 n3826 vdd vdd) p12 w=2.4u l=0.13u
MN3840 (n3838 lead_sync2_4 n3839 vss) n12 w=1.6u l=0.13u
MN3841 (n3839 n3832 vss vss) n12 w=1.6u l=0.13u
MP3842 (n3838 lead_sync2_4 vdd vdd) p12 w=2.4u l=0.13u
MP3843 (n3838 n3832 vdd vdd) p12 w=2.4u l=0.13u
MN3846 (n3844 lead_sync2_4 n3845 vss) n12 w=1.6u l=0.13u
MN3847 (n3845 n3838 vss vss) n12 w=1.6u l=0.13u
MP3848 (n3844 lead_sync2_4 vdd vdd) p12 w=2.4u l=0.13u
MP3849 (n3844 n3838 vdd vdd) p12 w=2.4u l=0.13u
MN3852 (n3850 n3832 n3851 vss) n12 w=1.6u l=0.13u
MN3853 (n3851 n3838 vss vss) n12 w=1.6u l=0.13u
MP3854 (n3850 n3832 vdd vdd) p12 w=2.4u l=0.13u
MP3855 (n3850 n3838 vdd vdd) p12 w=2.4u l=0.13u
MN3858 (n3856 n3844 n3857 vss) n12 w=1.6u l=0.13u
MN3859 (n3857 n3850 vss vss) n12 w=1.6u l=0.13u
MP3860 (n3856 n3844 vdd vdd) p12 w=2.4u l=0.13u
MP3861 (n3856 n3850 vdd vdd) p12 w=2.4u l=0.13u
MN3864 (n3862 lead_sync2_3 n3863 vss) n12 w=1.6u l=0.13u
MN3865 (n3863 n3856 vss vss) n12 w=1.6u l=0.13u
MP3866 (n3862 lead_sync2_3 vdd vdd) p12 w=2.4u l=0.13u
MP3867 (n3862 n3856 vdd vdd) p12 w=2.4u l=0.13u
MN3870 (n3868 lead_sync2_3 n3869 vss) n12 w=1.6u l=0.13u
MN3871 (n3869 n3862 vss vss) n12 w=1.6u l=0.13u
MP3872 (n3868 lead_sync2_3 vdd vdd) p12 w=2.4u l=0.13u
MP3873 (n3868 n3862 vdd vdd) p12 w=2.4u l=0.13u
MN3876 (n3874 n3856 n3875 vss) n12 w=1.6u l=0.13u
MN3877 (n3875 n3862 vss vss) n12 w=1.6u l=0.13u
MP3878 (n3874 n3856 vdd vdd) p12 w=2.4u l=0.13u
MP3879 (n3874 n3862 vdd vdd) p12 w=2.4u l=0.13u
MN3882 (n3880 n3868 n3881 vss) n12 w=1.6u l=0.13u
MN3883 (n3881 n3874 vss vss) n12 w=1.6u l=0.13u
MP3884 (n3880 n3868 vdd vdd) p12 w=2.4u l=0.13u
MP3885 (n3880 n3874 vdd vdd) p12 w=2.4u l=0.13u
MN3888 (n3886 lead_sync2_2 n3887 vss) n12 w=1.6u l=0.13u
MN3889 (n3887 n3880 vss vss) n12 w=1.6u l=0.13u
MP3890 (n3886 lead_sync2_2 vdd vdd) p12 w=2.4u l=0.13u
MP3891 (n3886 n3880 vdd vdd) p12 w=2.4u l=0.13u
MN3894 (n3892 lead_sync2_2 n3893 vss) n12 w=1.6u l=0.13u
MN3895 (n3893 n3886 vss vss) n12 w=1.6u l=0.13u
MP3896 (n3892 lead_sync2_2 vdd vdd) p12 w=2.4u l=0.13u
MP3897 (n3892 n3886 vdd vdd) p12 w=2.4u l=0.13u
MN3900 (n3898 n3880 n3899 vss) n12 w=1.6u l=0.13u
MN3901 (n3899 n3886 vss vss) n12 w=1.6u l=0.13u
MP3902 (n3898 n3880 vdd vdd) p12 w=2.4u l=0.13u
MP3903 (n3898 n3886 vdd vdd) p12 w=2.4u l=0.13u
MN3906 (n3904 n3892 n3905 vss) n12 w=1.6u l=0.13u
MN3907 (n3905 n3898 vss vss) n12 w=1.6u l=0.13u
MP3908 (n3904 n3892 vdd vdd) p12 w=2.4u l=0.13u
MP3909 (n3904 n3898 vdd vdd) p12 w=2.4u l=0.13u
MN3912 (n3910 lead_sync2_1 n3911 vss) n12 w=1.6u l=0.13u
MN3913 (n3911 n3904 vss vss) n12 w=1.6u l=0.13u
MP3914 (n3910 lead_sync2_1 vdd vdd) p12 w=2.4u l=0.13u
MP3915 (n3910 n3904 vdd vdd) p12 w=2.4u l=0.13u
MN3918 (n3916 lead_sync2_1 n3917 vss) n12 w=1.6u l=0.13u
MN3919 (n3917 n3910 vss vss) n12 w=1.6u l=0.13u
MP3920 (n3916 lead_sync2_1 vdd vdd) p12 w=2.4u l=0.13u
MP3921 (n3916 n3910 vdd vdd) p12 w=2.4u l=0.13u
MN3924 (n3922 n3904 n3923 vss) n12 w=1.6u l=0.13u
MN3925 (n3923 n3910 vss vss) n12 w=1.6u l=0.13u
MP3926 (n3922 n3904 vdd vdd) p12 w=2.4u l=0.13u
MP3927 (n3922 n3910 vdd vdd) p12 w=2.4u l=0.13u
MN3930 (n3928 n3916 n3929 vss) n12 w=1.6u l=0.13u
MN3931 (n3929 n3922 vss vss) n12 w=1.6u l=0.13u
MP3932 (n3928 n3916 vdd vdd) p12 w=2.4u l=0.13u
MP3933 (n3928 n3922 vdd vdd) p12 w=2.4u l=0.13u
MN3936 (n3934 lead_sync2_0 n3935 vss) n12 w=1.6u l=0.13u
MN3937 (n3935 n3928 vss vss) n12 w=1.6u l=0.13u
MP3938 (n3934 lead_sync2_0 vdd vdd) p12 w=2.4u l=0.13u
MP3939 (n3934 n3928 vdd vdd) p12 w=2.4u l=0.13u
MN3942 (n3940 lead_sync2_0 n3941 vss) n12 w=1.6u l=0.13u
MN3943 (n3941 n3934 vss vss) n12 w=1.6u l=0.13u
MP3944 (n3940 lead_sync2_0 vdd vdd) p12 w=2.4u l=0.13u
MP3945 (n3940 n3934 vdd vdd) p12 w=2.4u l=0.13u
MN3948 (n3946 n3928 n3947 vss) n12 w=1.6u l=0.13u
MN3949 (n3947 n3934 vss vss) n12 w=1.6u l=0.13u
MP3950 (n3946 n3928 vdd vdd) p12 w=2.4u l=0.13u
MP3951 (n3946 n3934 vdd vdd) p12 w=2.4u l=0.13u
MN3954 (n3952 n3940 n3953 vss) n12 w=1.6u l=0.13u
MN3955 (n3953 n3946 vss vss) n12 w=1.6u l=0.13u
MP3956 (n3952 n3940 vdd vdd) p12 w=2.4u l=0.13u
MP3957 (n3952 n3946 vdd vdd) p12 w=2.4u l=0.13u
MN3959 (n3958 n3952 vss vss) n12 w=0.8u l=0.13u
MP3960 (n3958 n3952 vdd vdd) p12 w=2.4u l=0.13u
MN3962 (n3961 n3958 vss vss) n12 w=0.8u l=0.13u
MP3963 (n3961 n3958 vdd vdd) p12 w=2.4u l=0.13u
MN3965 (n3964 n3961 vss vss) n12 w=0.8u l=0.13u
MP3966 (n3964 n3961 vdd vdd) p12 w=2.4u l=0.13u
MN3967 (cl0 n3964 vss vss) n12 w=0.8u l=0.13u
MP3968 (cl0 n3964 vdd vdd) p12 w=2.4u l=0.13u
MN3970 (n3969 n3928 vss vss) n12 w=0.8u l=0.13u
MP3971 (n3969 n3928 vdd vdd) p12 w=2.4u l=0.13u
MN3973 (n3972 n3969 vss vss) n12 w=0.8u l=0.13u
MP3974 (n3972 n3969 vdd vdd) p12 w=2.4u l=0.13u
MN3976 (n3975 n3972 vss vss) n12 w=0.8u l=0.13u
MP3977 (n3975 n3972 vdd vdd) p12 w=2.4u l=0.13u
MN3978 (cl1 n3975 vss vss) n12 w=0.8u l=0.13u
MP3979 (cl1 n3975 vdd vdd) p12 w=2.4u l=0.13u
MN3981 (n3980 n3904 vss vss) n12 w=0.8u l=0.13u
MP3982 (n3980 n3904 vdd vdd) p12 w=2.4u l=0.13u
MN3984 (n3983 n3980 vss vss) n12 w=0.8u l=0.13u
MP3985 (n3983 n3980 vdd vdd) p12 w=2.4u l=0.13u
MN3987 (n3986 n3983 vss vss) n12 w=0.8u l=0.13u
MP3988 (n3986 n3983 vdd vdd) p12 w=2.4u l=0.13u
MN3989 (cl2 n3986 vss vss) n12 w=0.8u l=0.13u
MP3990 (cl2 n3986 vdd vdd) p12 w=2.4u l=0.13u
MN3992 (n3991 n3880 vss vss) n12 w=0.8u l=0.13u
MP3993 (n3991 n3880 vdd vdd) p12 w=2.4u l=0.13u
MN3995 (n3994 n3991 vss vss) n12 w=0.8u l=0.13u
MP3996 (n3994 n3991 vdd vdd) p12 w=2.4u l=0.13u
MN3998 (n3997 n3994 vss vss) n12 w=0.8u l=0.13u
MP3999 (n3997 n3994 vdd vdd) p12 w=2.4u l=0.13u
MN4000 (cl3 n3997 vss vss) n12 w=0.8u l=0.13u
MP4001 (cl3 n3997 vdd vdd) p12 w=2.4u l=0.13u
MN4003 (n4002 n3856 vss vss) n12 w=0.8u l=0.13u
MP4004 (n4002 n3856 vdd vdd) p12 w=2.4u l=0.13u
MN4006 (n4005 n4002 vss vss) n12 w=0.8u l=0.13u
MP4007 (n4005 n4002 vdd vdd) p12 w=2.4u l=0.13u
MN4009 (n4008 n4005 vss vss) n12 w=0.8u l=0.13u
MP4010 (n4008 n4005 vdd vdd) p12 w=2.4u l=0.13u
MN4011 (cl4 n4008 vss vss) n12 w=0.8u l=0.13u
MP4012 (cl4 n4008 vdd vdd) p12 w=2.4u l=0.13u
MN4014 (n4013 n3832 vss vss) n12 w=0.8u l=0.13u
MP4015 (n4013 n3832 vdd vdd) p12 w=2.4u l=0.13u
MN4017 (n4016 n4013 vss vss) n12 w=0.8u l=0.13u
MP4018 (n4016 n4013 vdd vdd) p12 w=2.4u l=0.13u
MN4020 (n4019 n4016 vss vss) n12 w=0.8u l=0.13u
MP4021 (n4019 n4016 vdd vdd) p12 w=2.4u l=0.13u
MN4022 (cl5 n4019 vss vss) n12 w=0.8u l=0.13u
MP4023 (cl5 n4019 vdd vdd) p12 w=2.4u l=0.13u
MN4025 (n4024 n3808 vss vss) n12 w=0.8u l=0.13u
MP4026 (n4024 n3808 vdd vdd) p12 w=2.4u l=0.13u
MN4028 (n4027 n4024 vss vss) n12 w=0.8u l=0.13u
MP4029 (n4027 n4024 vdd vdd) p12 w=2.4u l=0.13u
MN4031 (n4030 n4027 vss vss) n12 w=0.8u l=0.13u
MP4032 (n4030 n4027 vdd vdd) p12 w=2.4u l=0.13u
MN4033 (cl6 n4030 vss vss) n12 w=0.8u l=0.13u
MP4034 (cl6 n4030 vdd vdd) p12 w=2.4u l=0.13u
MN4036 (n4035 lead_sync2_7 vss vss) n12 w=0.8u l=0.13u
MP4037 (n4035 lead_sync2_7 vdd vdd) p12 w=2.4u l=0.13u
MN4039 (n4038 n4035 vss vss) n12 w=0.8u l=0.13u
MP4040 (n4038 n4035 vdd vdd) p12 w=2.4u l=0.13u
MN4042 (n4041 n4038 vss vss) n12 w=0.8u l=0.13u
MP4043 (n4041 n4038 vdd vdd) p12 w=2.4u l=0.13u
MN4044 (cl7 n4041 vss vss) n12 w=0.8u l=0.13u
MP4045 (cl7 n4041 vdd vdd) p12 w=2.4u l=0.13u
MN4048 (n4046 lag_sync2_6 n4047 vss) n12 w=1.6u l=0.13u
MN4049 (n4047 lag_sync2_7 vss vss) n12 w=1.6u l=0.13u
MP4050 (n4046 lag_sync2_6 vdd vdd) p12 w=2.4u l=0.13u
MP4051 (n4046 lag_sync2_7 vdd vdd) p12 w=2.4u l=0.13u
MN4054 (n4052 lag_sync2_6 n4053 vss) n12 w=1.6u l=0.13u
MN4055 (n4053 n4046 vss vss) n12 w=1.6u l=0.13u
MP4056 (n4052 lag_sync2_6 vdd vdd) p12 w=2.4u l=0.13u
MP4057 (n4052 n4046 vdd vdd) p12 w=2.4u l=0.13u
MN4060 (n4058 lag_sync2_7 n4059 vss) n12 w=1.6u l=0.13u
MN4061 (n4059 n4046 vss vss) n12 w=1.6u l=0.13u
MP4062 (n4058 lag_sync2_7 vdd vdd) p12 w=2.4u l=0.13u
MP4063 (n4058 n4046 vdd vdd) p12 w=2.4u l=0.13u
MN4066 (n4064 n4052 n4065 vss) n12 w=1.6u l=0.13u
MN4067 (n4065 n4058 vss vss) n12 w=1.6u l=0.13u
MP4068 (n4064 n4052 vdd vdd) p12 w=2.4u l=0.13u
MP4069 (n4064 n4058 vdd vdd) p12 w=2.4u l=0.13u
MN4072 (n4070 lag_sync2_5 n4071 vss) n12 w=1.6u l=0.13u
MN4073 (n4071 n4064 vss vss) n12 w=1.6u l=0.13u
MP4074 (n4070 lag_sync2_5 vdd vdd) p12 w=2.4u l=0.13u
MP4075 (n4070 n4064 vdd vdd) p12 w=2.4u l=0.13u
MN4078 (n4076 lag_sync2_5 n4077 vss) n12 w=1.6u l=0.13u
MN4079 (n4077 n4070 vss vss) n12 w=1.6u l=0.13u
MP4080 (n4076 lag_sync2_5 vdd vdd) p12 w=2.4u l=0.13u
MP4081 (n4076 n4070 vdd vdd) p12 w=2.4u l=0.13u
MN4084 (n4082 n4064 n4083 vss) n12 w=1.6u l=0.13u
MN4085 (n4083 n4070 vss vss) n12 w=1.6u l=0.13u
MP4086 (n4082 n4064 vdd vdd) p12 w=2.4u l=0.13u
MP4087 (n4082 n4070 vdd vdd) p12 w=2.4u l=0.13u
MN4090 (n4088 n4076 n4089 vss) n12 w=1.6u l=0.13u
MN4091 (n4089 n4082 vss vss) n12 w=1.6u l=0.13u
MP4092 (n4088 n4076 vdd vdd) p12 w=2.4u l=0.13u
MP4093 (n4088 n4082 vdd vdd) p12 w=2.4u l=0.13u
MN4096 (n4094 lag_sync2_4 n4095 vss) n12 w=1.6u l=0.13u
MN4097 (n4095 n4088 vss vss) n12 w=1.6u l=0.13u
MP4098 (n4094 lag_sync2_4 vdd vdd) p12 w=2.4u l=0.13u
MP4099 (n4094 n4088 vdd vdd) p12 w=2.4u l=0.13u
MN4102 (n4100 lag_sync2_4 n4101 vss) n12 w=1.6u l=0.13u
MN4103 (n4101 n4094 vss vss) n12 w=1.6u l=0.13u
MP4104 (n4100 lag_sync2_4 vdd vdd) p12 w=2.4u l=0.13u
MP4105 (n4100 n4094 vdd vdd) p12 w=2.4u l=0.13u
MN4108 (n4106 n4088 n4107 vss) n12 w=1.6u l=0.13u
MN4109 (n4107 n4094 vss vss) n12 w=1.6u l=0.13u
MP4110 (n4106 n4088 vdd vdd) p12 w=2.4u l=0.13u
MP4111 (n4106 n4094 vdd vdd) p12 w=2.4u l=0.13u
MN4114 (n4112 n4100 n4113 vss) n12 w=1.6u l=0.13u
MN4115 (n4113 n4106 vss vss) n12 w=1.6u l=0.13u
MP4116 (n4112 n4100 vdd vdd) p12 w=2.4u l=0.13u
MP4117 (n4112 n4106 vdd vdd) p12 w=2.4u l=0.13u
MN4120 (n4118 lag_sync2_3 n4119 vss) n12 w=1.6u l=0.13u
MN4121 (n4119 n4112 vss vss) n12 w=1.6u l=0.13u
MP4122 (n4118 lag_sync2_3 vdd vdd) p12 w=2.4u l=0.13u
MP4123 (n4118 n4112 vdd vdd) p12 w=2.4u l=0.13u
MN4126 (n4124 lag_sync2_3 n4125 vss) n12 w=1.6u l=0.13u
MN4127 (n4125 n4118 vss vss) n12 w=1.6u l=0.13u
MP4128 (n4124 lag_sync2_3 vdd vdd) p12 w=2.4u l=0.13u
MP4129 (n4124 n4118 vdd vdd) p12 w=2.4u l=0.13u
MN4132 (n4130 n4112 n4131 vss) n12 w=1.6u l=0.13u
MN4133 (n4131 n4118 vss vss) n12 w=1.6u l=0.13u
MP4134 (n4130 n4112 vdd vdd) p12 w=2.4u l=0.13u
MP4135 (n4130 n4118 vdd vdd) p12 w=2.4u l=0.13u
MN4138 (n4136 n4124 n4137 vss) n12 w=1.6u l=0.13u
MN4139 (n4137 n4130 vss vss) n12 w=1.6u l=0.13u
MP4140 (n4136 n4124 vdd vdd) p12 w=2.4u l=0.13u
MP4141 (n4136 n4130 vdd vdd) p12 w=2.4u l=0.13u
MN4144 (n4142 lag_sync2_2 n4143 vss) n12 w=1.6u l=0.13u
MN4145 (n4143 n4136 vss vss) n12 w=1.6u l=0.13u
MP4146 (n4142 lag_sync2_2 vdd vdd) p12 w=2.4u l=0.13u
MP4147 (n4142 n4136 vdd vdd) p12 w=2.4u l=0.13u
MN4150 (n4148 lag_sync2_2 n4149 vss) n12 w=1.6u l=0.13u
MN4151 (n4149 n4142 vss vss) n12 w=1.6u l=0.13u
MP4152 (n4148 lag_sync2_2 vdd vdd) p12 w=2.4u l=0.13u
MP4153 (n4148 n4142 vdd vdd) p12 w=2.4u l=0.13u
MN4156 (n4154 n4136 n4155 vss) n12 w=1.6u l=0.13u
MN4157 (n4155 n4142 vss vss) n12 w=1.6u l=0.13u
MP4158 (n4154 n4136 vdd vdd) p12 w=2.4u l=0.13u
MP4159 (n4154 n4142 vdd vdd) p12 w=2.4u l=0.13u
MN4162 (n4160 n4148 n4161 vss) n12 w=1.6u l=0.13u
MN4163 (n4161 n4154 vss vss) n12 w=1.6u l=0.13u
MP4164 (n4160 n4148 vdd vdd) p12 w=2.4u l=0.13u
MP4165 (n4160 n4154 vdd vdd) p12 w=2.4u l=0.13u
MN4168 (n4166 lag_sync2_1 n4167 vss) n12 w=1.6u l=0.13u
MN4169 (n4167 n4160 vss vss) n12 w=1.6u l=0.13u
MP4170 (n4166 lag_sync2_1 vdd vdd) p12 w=2.4u l=0.13u
MP4171 (n4166 n4160 vdd vdd) p12 w=2.4u l=0.13u
MN4174 (n4172 lag_sync2_1 n4173 vss) n12 w=1.6u l=0.13u
MN4175 (n4173 n4166 vss vss) n12 w=1.6u l=0.13u
MP4176 (n4172 lag_sync2_1 vdd vdd) p12 w=2.4u l=0.13u
MP4177 (n4172 n4166 vdd vdd) p12 w=2.4u l=0.13u
MN4180 (n4178 n4160 n4179 vss) n12 w=1.6u l=0.13u
MN4181 (n4179 n4166 vss vss) n12 w=1.6u l=0.13u
MP4182 (n4178 n4160 vdd vdd) p12 w=2.4u l=0.13u
MP4183 (n4178 n4166 vdd vdd) p12 w=2.4u l=0.13u
MN4186 (n4184 n4172 n4185 vss) n12 w=1.6u l=0.13u
MN4187 (n4185 n4178 vss vss) n12 w=1.6u l=0.13u
MP4188 (n4184 n4172 vdd vdd) p12 w=2.4u l=0.13u
MP4189 (n4184 n4178 vdd vdd) p12 w=2.4u l=0.13u
MN4192 (n4190 lag_sync2_0 n4191 vss) n12 w=1.6u l=0.13u
MN4193 (n4191 n4184 vss vss) n12 w=1.6u l=0.13u
MP4194 (n4190 lag_sync2_0 vdd vdd) p12 w=2.4u l=0.13u
MP4195 (n4190 n4184 vdd vdd) p12 w=2.4u l=0.13u
MN4198 (n4196 lag_sync2_0 n4197 vss) n12 w=1.6u l=0.13u
MN4199 (n4197 n4190 vss vss) n12 w=1.6u l=0.13u
MP4200 (n4196 lag_sync2_0 vdd vdd) p12 w=2.4u l=0.13u
MP4201 (n4196 n4190 vdd vdd) p12 w=2.4u l=0.13u
MN4204 (n4202 n4184 n4203 vss) n12 w=1.6u l=0.13u
MN4205 (n4203 n4190 vss vss) n12 w=1.6u l=0.13u
MP4206 (n4202 n4184 vdd vdd) p12 w=2.4u l=0.13u
MP4207 (n4202 n4190 vdd vdd) p12 w=2.4u l=0.13u
MN4210 (n4208 n4196 n4209 vss) n12 w=1.6u l=0.13u
MN4211 (n4209 n4202 vss vss) n12 w=1.6u l=0.13u
MP4212 (n4208 n4196 vdd vdd) p12 w=2.4u l=0.13u
MP4213 (n4208 n4202 vdd vdd) p12 w=2.4u l=0.13u
MN4215 (n4214 n4208 vss vss) n12 w=0.8u l=0.13u
MP4216 (n4214 n4208 vdd vdd) p12 w=2.4u l=0.13u
MN4218 (n4217 n4214 vss vss) n12 w=0.8u l=0.13u
MP4219 (n4217 n4214 vdd vdd) p12 w=2.4u l=0.13u
MN4221 (n4220 n4217 vss vss) n12 w=0.8u l=0.13u
MP4222 (n4220 n4217 vdd vdd) p12 w=2.4u l=0.13u
MN4223 (cg0 n4220 vss vss) n12 w=0.8u l=0.13u
MP4224 (cg0 n4220 vdd vdd) p12 w=2.4u l=0.13u
MN4226 (n4225 n4184 vss vss) n12 w=0.8u l=0.13u
MP4227 (n4225 n4184 vdd vdd) p12 w=2.4u l=0.13u
MN4229 (n4228 n4225 vss vss) n12 w=0.8u l=0.13u
MP4230 (n4228 n4225 vdd vdd) p12 w=2.4u l=0.13u
MN4232 (n4231 n4228 vss vss) n12 w=0.8u l=0.13u
MP4233 (n4231 n4228 vdd vdd) p12 w=2.4u l=0.13u
MN4234 (cg1 n4231 vss vss) n12 w=0.8u l=0.13u
MP4235 (cg1 n4231 vdd vdd) p12 w=2.4u l=0.13u
MN4237 (n4236 n4160 vss vss) n12 w=0.8u l=0.13u
MP4238 (n4236 n4160 vdd vdd) p12 w=2.4u l=0.13u
MN4240 (n4239 n4236 vss vss) n12 w=0.8u l=0.13u
MP4241 (n4239 n4236 vdd vdd) p12 w=2.4u l=0.13u
MN4243 (n4242 n4239 vss vss) n12 w=0.8u l=0.13u
MP4244 (n4242 n4239 vdd vdd) p12 w=2.4u l=0.13u
MN4245 (cg2 n4242 vss vss) n12 w=0.8u l=0.13u
MP4246 (cg2 n4242 vdd vdd) p12 w=2.4u l=0.13u
MN4248 (n4247 n4136 vss vss) n12 w=0.8u l=0.13u
MP4249 (n4247 n4136 vdd vdd) p12 w=2.4u l=0.13u
MN4251 (n4250 n4247 vss vss) n12 w=0.8u l=0.13u
MP4252 (n4250 n4247 vdd vdd) p12 w=2.4u l=0.13u
MN4254 (n4253 n4250 vss vss) n12 w=0.8u l=0.13u
MP4255 (n4253 n4250 vdd vdd) p12 w=2.4u l=0.13u
MN4256 (cg3 n4253 vss vss) n12 w=0.8u l=0.13u
MP4257 (cg3 n4253 vdd vdd) p12 w=2.4u l=0.13u
MN4259 (n4258 n4112 vss vss) n12 w=0.8u l=0.13u
MP4260 (n4258 n4112 vdd vdd) p12 w=2.4u l=0.13u
MN4262 (n4261 n4258 vss vss) n12 w=0.8u l=0.13u
MP4263 (n4261 n4258 vdd vdd) p12 w=2.4u l=0.13u
MN4265 (n4264 n4261 vss vss) n12 w=0.8u l=0.13u
MP4266 (n4264 n4261 vdd vdd) p12 w=2.4u l=0.13u
MN4267 (cg4 n4264 vss vss) n12 w=0.8u l=0.13u
MP4268 (cg4 n4264 vdd vdd) p12 w=2.4u l=0.13u
MN4270 (n4269 n4088 vss vss) n12 w=0.8u l=0.13u
MP4271 (n4269 n4088 vdd vdd) p12 w=2.4u l=0.13u
MN4273 (n4272 n4269 vss vss) n12 w=0.8u l=0.13u
MP4274 (n4272 n4269 vdd vdd) p12 w=2.4u l=0.13u
MN4276 (n4275 n4272 vss vss) n12 w=0.8u l=0.13u
MP4277 (n4275 n4272 vdd vdd) p12 w=2.4u l=0.13u
MN4278 (cg5 n4275 vss vss) n12 w=0.8u l=0.13u
MP4279 (cg5 n4275 vdd vdd) p12 w=2.4u l=0.13u
MN4281 (n4280 n4064 vss vss) n12 w=0.8u l=0.13u
MP4282 (n4280 n4064 vdd vdd) p12 w=2.4u l=0.13u
MN4284 (n4283 n4280 vss vss) n12 w=0.8u l=0.13u
MP4285 (n4283 n4280 vdd vdd) p12 w=2.4u l=0.13u
MN4287 (n4286 n4283 vss vss) n12 w=0.8u l=0.13u
MP4288 (n4286 n4283 vdd vdd) p12 w=2.4u l=0.13u
MN4289 (cg6 n4286 vss vss) n12 w=0.8u l=0.13u
MP4290 (cg6 n4286 vdd vdd) p12 w=2.4u l=0.13u
MN4292 (n4291 lag_sync2_7 vss vss) n12 w=0.8u l=0.13u
MP4293 (n4291 lag_sync2_7 vdd vdd) p12 w=2.4u l=0.13u
MN4295 (n4294 n4291 vss vss) n12 w=0.8u l=0.13u
MP4296 (n4294 n4291 vdd vdd) p12 w=2.4u l=0.13u
MN4298 (n4297 n4294 vss vss) n12 w=0.8u l=0.13u
MP4299 (n4297 n4294 vdd vdd) p12 w=2.4u l=0.13u
MN4300 (cg7 n4297 vss vss) n12 w=0.8u l=0.13u
MP4301 (cg7 n4297 vdd vdd) p12 w=2.4u l=0.13u
MN4304 (n4302 div_sync2_6 n4303 vss) n12 w=1.6u l=0.13u
MN4305 (n4303 div_sync2_7 vss vss) n12 w=1.6u l=0.13u
MP4306 (n4302 div_sync2_6 vdd vdd) p12 w=2.4u l=0.13u
MP4307 (n4302 div_sync2_7 vdd vdd) p12 w=2.4u l=0.13u
MN4310 (n4308 div_sync2_6 n4309 vss) n12 w=1.6u l=0.13u
MN4311 (n4309 n4302 vss vss) n12 w=1.6u l=0.13u
MP4312 (n4308 div_sync2_6 vdd vdd) p12 w=2.4u l=0.13u
MP4313 (n4308 n4302 vdd vdd) p12 w=2.4u l=0.13u
MN4316 (n4314 div_sync2_7 n4315 vss) n12 w=1.6u l=0.13u
MN4317 (n4315 n4302 vss vss) n12 w=1.6u l=0.13u
MP4318 (n4314 div_sync2_7 vdd vdd) p12 w=2.4u l=0.13u
MP4319 (n4314 n4302 vdd vdd) p12 w=2.4u l=0.13u
MN4322 (n4320 n4308 n4321 vss) n12 w=1.6u l=0.13u
MN4323 (n4321 n4314 vss vss) n12 w=1.6u l=0.13u
MP4324 (n4320 n4308 vdd vdd) p12 w=2.4u l=0.13u
MP4325 (n4320 n4314 vdd vdd) p12 w=2.4u l=0.13u
MN4328 (n4326 div_sync2_5 n4327 vss) n12 w=1.6u l=0.13u
MN4329 (n4327 n4320 vss vss) n12 w=1.6u l=0.13u
MP4330 (n4326 div_sync2_5 vdd vdd) p12 w=2.4u l=0.13u
MP4331 (n4326 n4320 vdd vdd) p12 w=2.4u l=0.13u
MN4334 (n4332 div_sync2_5 n4333 vss) n12 w=1.6u l=0.13u
MN4335 (n4333 n4326 vss vss) n12 w=1.6u l=0.13u
MP4336 (n4332 div_sync2_5 vdd vdd) p12 w=2.4u l=0.13u
MP4337 (n4332 n4326 vdd vdd) p12 w=2.4u l=0.13u
MN4340 (n4338 n4320 n4339 vss) n12 w=1.6u l=0.13u
MN4341 (n4339 n4326 vss vss) n12 w=1.6u l=0.13u
MP4342 (n4338 n4320 vdd vdd) p12 w=2.4u l=0.13u
MP4343 (n4338 n4326 vdd vdd) p12 w=2.4u l=0.13u
MN4346 (n4344 n4332 n4345 vss) n12 w=1.6u l=0.13u
MN4347 (n4345 n4338 vss vss) n12 w=1.6u l=0.13u
MP4348 (n4344 n4332 vdd vdd) p12 w=2.4u l=0.13u
MP4349 (n4344 n4338 vdd vdd) p12 w=2.4u l=0.13u
MN4352 (n4350 div_sync2_4 n4351 vss) n12 w=1.6u l=0.13u
MN4353 (n4351 n4344 vss vss) n12 w=1.6u l=0.13u
MP4354 (n4350 div_sync2_4 vdd vdd) p12 w=2.4u l=0.13u
MP4355 (n4350 n4344 vdd vdd) p12 w=2.4u l=0.13u
MN4358 (n4356 div_sync2_4 n4357 vss) n12 w=1.6u l=0.13u
MN4359 (n4357 n4350 vss vss) n12 w=1.6u l=0.13u
MP4360 (n4356 div_sync2_4 vdd vdd) p12 w=2.4u l=0.13u
MP4361 (n4356 n4350 vdd vdd) p12 w=2.4u l=0.13u
MN4364 (n4362 n4344 n4363 vss) n12 w=1.6u l=0.13u
MN4365 (n4363 n4350 vss vss) n12 w=1.6u l=0.13u
MP4366 (n4362 n4344 vdd vdd) p12 w=2.4u l=0.13u
MP4367 (n4362 n4350 vdd vdd) p12 w=2.4u l=0.13u
MN4370 (n4368 n4356 n4369 vss) n12 w=1.6u l=0.13u
MN4371 (n4369 n4362 vss vss) n12 w=1.6u l=0.13u
MP4372 (n4368 n4356 vdd vdd) p12 w=2.4u l=0.13u
MP4373 (n4368 n4362 vdd vdd) p12 w=2.4u l=0.13u
MN4376 (n4374 div_sync2_3 n4375 vss) n12 w=1.6u l=0.13u
MN4377 (n4375 n4368 vss vss) n12 w=1.6u l=0.13u
MP4378 (n4374 div_sync2_3 vdd vdd) p12 w=2.4u l=0.13u
MP4379 (n4374 n4368 vdd vdd) p12 w=2.4u l=0.13u
MN4382 (n4380 div_sync2_3 n4381 vss) n12 w=1.6u l=0.13u
MN4383 (n4381 n4374 vss vss) n12 w=1.6u l=0.13u
MP4384 (n4380 div_sync2_3 vdd vdd) p12 w=2.4u l=0.13u
MP4385 (n4380 n4374 vdd vdd) p12 w=2.4u l=0.13u
MN4388 (n4386 n4368 n4387 vss) n12 w=1.6u l=0.13u
MN4389 (n4387 n4374 vss vss) n12 w=1.6u l=0.13u
MP4390 (n4386 n4368 vdd vdd) p12 w=2.4u l=0.13u
MP4391 (n4386 n4374 vdd vdd) p12 w=2.4u l=0.13u
MN4394 (n4392 n4380 n4393 vss) n12 w=1.6u l=0.13u
MN4395 (n4393 n4386 vss vss) n12 w=1.6u l=0.13u
MP4396 (n4392 n4380 vdd vdd) p12 w=2.4u l=0.13u
MP4397 (n4392 n4386 vdd vdd) p12 w=2.4u l=0.13u
MN4400 (n4398 div_sync2_2 n4399 vss) n12 w=1.6u l=0.13u
MN4401 (n4399 n4392 vss vss) n12 w=1.6u l=0.13u
MP4402 (n4398 div_sync2_2 vdd vdd) p12 w=2.4u l=0.13u
MP4403 (n4398 n4392 vdd vdd) p12 w=2.4u l=0.13u
MN4406 (n4404 div_sync2_2 n4405 vss) n12 w=1.6u l=0.13u
MN4407 (n4405 n4398 vss vss) n12 w=1.6u l=0.13u
MP4408 (n4404 div_sync2_2 vdd vdd) p12 w=2.4u l=0.13u
MP4409 (n4404 n4398 vdd vdd) p12 w=2.4u l=0.13u
MN4412 (n4410 n4392 n4411 vss) n12 w=1.6u l=0.13u
MN4413 (n4411 n4398 vss vss) n12 w=1.6u l=0.13u
MP4414 (n4410 n4392 vdd vdd) p12 w=2.4u l=0.13u
MP4415 (n4410 n4398 vdd vdd) p12 w=2.4u l=0.13u
MN4418 (n4416 n4404 n4417 vss) n12 w=1.6u l=0.13u
MN4419 (n4417 n4410 vss vss) n12 w=1.6u l=0.13u
MP4420 (n4416 n4404 vdd vdd) p12 w=2.4u l=0.13u
MP4421 (n4416 n4410 vdd vdd) p12 w=2.4u l=0.13u
MN4424 (n4422 div_sync2_1 n4423 vss) n12 w=1.6u l=0.13u
MN4425 (n4423 n4416 vss vss) n12 w=1.6u l=0.13u
MP4426 (n4422 div_sync2_1 vdd vdd) p12 w=2.4u l=0.13u
MP4427 (n4422 n4416 vdd vdd) p12 w=2.4u l=0.13u
MN4430 (n4428 div_sync2_1 n4429 vss) n12 w=1.6u l=0.13u
MN4431 (n4429 n4422 vss vss) n12 w=1.6u l=0.13u
MP4432 (n4428 div_sync2_1 vdd vdd) p12 w=2.4u l=0.13u
MP4433 (n4428 n4422 vdd vdd) p12 w=2.4u l=0.13u
MN4436 (n4434 n4416 n4435 vss) n12 w=1.6u l=0.13u
MN4437 (n4435 n4422 vss vss) n12 w=1.6u l=0.13u
MP4438 (n4434 n4416 vdd vdd) p12 w=2.4u l=0.13u
MP4439 (n4434 n4422 vdd vdd) p12 w=2.4u l=0.13u
MN4442 (n4440 n4428 n4441 vss) n12 w=1.6u l=0.13u
MN4443 (n4441 n4434 vss vss) n12 w=1.6u l=0.13u
MP4444 (n4440 n4428 vdd vdd) p12 w=2.4u l=0.13u
MP4445 (n4440 n4434 vdd vdd) p12 w=2.4u l=0.13u
MN4448 (n4446 div_sync2_0 n4447 vss) n12 w=1.6u l=0.13u
MN4449 (n4447 n4440 vss vss) n12 w=1.6u l=0.13u
MP4450 (n4446 div_sync2_0 vdd vdd) p12 w=2.4u l=0.13u
MP4451 (n4446 n4440 vdd vdd) p12 w=2.4u l=0.13u
MN4454 (n4452 div_sync2_0 n4453 vss) n12 w=1.6u l=0.13u
MN4455 (n4453 n4446 vss vss) n12 w=1.6u l=0.13u
MP4456 (n4452 div_sync2_0 vdd vdd) p12 w=2.4u l=0.13u
MP4457 (n4452 n4446 vdd vdd) p12 w=2.4u l=0.13u
MN4460 (n4458 n4440 n4459 vss) n12 w=1.6u l=0.13u
MN4461 (n4459 n4446 vss vss) n12 w=1.6u l=0.13u
MP4462 (n4458 n4440 vdd vdd) p12 w=2.4u l=0.13u
MP4463 (n4458 n4446 vdd vdd) p12 w=2.4u l=0.13u
MN4466 (n4464 n4452 n4465 vss) n12 w=1.6u l=0.13u
MN4467 (n4465 n4458 vss vss) n12 w=1.6u l=0.13u
MP4468 (n4464 n4452 vdd vdd) p12 w=2.4u l=0.13u
MP4469 (n4464 n4458 vdd vdd) p12 w=2.4u l=0.13u
MN4471 (n4470 n4464 vss vss) n12 w=0.8u l=0.13u
MP4472 (n4470 n4464 vdd vdd) p12 w=2.4u l=0.13u
MN4474 (n4473 n4470 vss vss) n12 w=0.8u l=0.13u
MP4475 (n4473 n4470 vdd vdd) p12 w=2.4u l=0.13u
MN4477 (n4476 n4473 vss vss) n12 w=0.8u l=0.13u
MP4478 (n4476 n4473 vdd vdd) p12 w=2.4u l=0.13u
MN4479 (cd0 n4476 vss vss) n12 w=0.8u l=0.13u
MP4480 (cd0 n4476 vdd vdd) p12 w=2.4u l=0.13u
MN4482 (n4481 n4440 vss vss) n12 w=0.8u l=0.13u
MP4483 (n4481 n4440 vdd vdd) p12 w=2.4u l=0.13u
MN4485 (n4484 n4481 vss vss) n12 w=0.8u l=0.13u
MP4486 (n4484 n4481 vdd vdd) p12 w=2.4u l=0.13u
MN4488 (n4487 n4484 vss vss) n12 w=0.8u l=0.13u
MP4489 (n4487 n4484 vdd vdd) p12 w=2.4u l=0.13u
MN4490 (cd1 n4487 vss vss) n12 w=0.8u l=0.13u
MP4491 (cd1 n4487 vdd vdd) p12 w=2.4u l=0.13u
MN4493 (n4492 n4416 vss vss) n12 w=0.8u l=0.13u
MP4494 (n4492 n4416 vdd vdd) p12 w=2.4u l=0.13u
MN4496 (n4495 n4492 vss vss) n12 w=0.8u l=0.13u
MP4497 (n4495 n4492 vdd vdd) p12 w=2.4u l=0.13u
MN4499 (n4498 n4495 vss vss) n12 w=0.8u l=0.13u
MP4500 (n4498 n4495 vdd vdd) p12 w=2.4u l=0.13u
MN4501 (cd2 n4498 vss vss) n12 w=0.8u l=0.13u
MP4502 (cd2 n4498 vdd vdd) p12 w=2.4u l=0.13u
MN4504 (n4503 n4392 vss vss) n12 w=0.8u l=0.13u
MP4505 (n4503 n4392 vdd vdd) p12 w=2.4u l=0.13u
MN4507 (n4506 n4503 vss vss) n12 w=0.8u l=0.13u
MP4508 (n4506 n4503 vdd vdd) p12 w=2.4u l=0.13u
MN4510 (n4509 n4506 vss vss) n12 w=0.8u l=0.13u
MP4511 (n4509 n4506 vdd vdd) p12 w=2.4u l=0.13u
MN4512 (cd3 n4509 vss vss) n12 w=0.8u l=0.13u
MP4513 (cd3 n4509 vdd vdd) p12 w=2.4u l=0.13u
MN4515 (n4514 n4368 vss vss) n12 w=0.8u l=0.13u
MP4516 (n4514 n4368 vdd vdd) p12 w=2.4u l=0.13u
MN4518 (n4517 n4514 vss vss) n12 w=0.8u l=0.13u
MP4519 (n4517 n4514 vdd vdd) p12 w=2.4u l=0.13u
MN4521 (n4520 n4517 vss vss) n12 w=0.8u l=0.13u
MP4522 (n4520 n4517 vdd vdd) p12 w=2.4u l=0.13u
MN4523 (cd4 n4520 vss vss) n12 w=0.8u l=0.13u
MP4524 (cd4 n4520 vdd vdd) p12 w=2.4u l=0.13u
MN4526 (n4525 n4344 vss vss) n12 w=0.8u l=0.13u
MP4527 (n4525 n4344 vdd vdd) p12 w=2.4u l=0.13u
MN4529 (n4528 n4525 vss vss) n12 w=0.8u l=0.13u
MP4530 (n4528 n4525 vdd vdd) p12 w=2.4u l=0.13u
MN4532 (n4531 n4528 vss vss) n12 w=0.8u l=0.13u
MP4533 (n4531 n4528 vdd vdd) p12 w=2.4u l=0.13u
MN4534 (cd5 n4531 vss vss) n12 w=0.8u l=0.13u
MP4535 (cd5 n4531 vdd vdd) p12 w=2.4u l=0.13u
MN4537 (n4536 n4320 vss vss) n12 w=0.8u l=0.13u
MP4538 (n4536 n4320 vdd vdd) p12 w=2.4u l=0.13u
MN4540 (n4539 n4536 vss vss) n12 w=0.8u l=0.13u
MP4541 (n4539 n4536 vdd vdd) p12 w=2.4u l=0.13u
MN4543 (n4542 n4539 vss vss) n12 w=0.8u l=0.13u
MP4544 (n4542 n4539 vdd vdd) p12 w=2.4u l=0.13u
MN4545 (cd6 n4542 vss vss) n12 w=0.8u l=0.13u
MP4546 (cd6 n4542 vdd vdd) p12 w=2.4u l=0.13u
MN4548 (n4547 div_sync2_7 vss vss) n12 w=0.8u l=0.13u
MP4549 (n4547 div_sync2_7 vdd vdd) p12 w=2.4u l=0.13u
MN4551 (n4550 n4547 vss vss) n12 w=0.8u l=0.13u
MP4552 (n4550 n4547 vdd vdd) p12 w=2.4u l=0.13u
MN4554 (n4553 n4550 vss vss) n12 w=0.8u l=0.13u
MP4555 (n4553 n4550 vdd vdd) p12 w=2.4u l=0.13u
MN4556 (cd7 n4553 vss vss) n12 w=0.8u l=0.13u
MP4557 (cd7 n4553 vdd vdd) p12 w=2.4u l=0.13u
MN4562 (seen n2668 storage4561 vss) n12 w=1.2u l=0.13u
MP4563 (seen n2680 storage4561 vdd) p12 w=3.6u l=0.13u
MN4564 (qm4558 n2677 storage4561 vss) n12 w=1.2u l=0.13u
MP4565 (qm4558 n2683 storage4561 vdd) p12 w=3.6u l=0.13u
MN4566 (qmb4559 storage4561 vss vss) n12 w=0.5u l=0.13u
MP4567 (qmb4559 storage4561 vdd vdd) p12 w=1.5u l=0.13u
MN4568 (qm4558 qmb4559 vss vss) n12 w=0.5u l=0.13u
MP4569 (qm4558 qmb4559 vdd vdd) p12 w=1.5u l=0.13u
MN4570 (storage4561 n202 vss vss) n12 w=2u l=0.13u
MN4572 (qm4558 n2677 storage4571 vss) n12 w=1.2u l=0.13u
MP4573 (qm4558 n2683 storage4571 vdd) p12 w=3.6u l=0.13u
MN4574 (seen_sync1 n2668 storage4571 vss) n12 w=1.2u l=0.13u
MP4575 (seen_sync1 n2680 storage4571 vdd) p12 w=3.6u l=0.13u
MN4576 (qb4560 storage4571 vss vss) n12 w=0.5u l=0.13u
MP4577 (qb4560 storage4571 vdd vdd) p12 w=1.5u l=0.13u
MN4578 (seen_sync1 qb4560 vss vss) n12 w=0.5u l=0.13u
MP4579 (seen_sync1 qb4560 vdd vdd) p12 w=1.5u l=0.13u
MN4580 (storage4571 n202 vss vss) n12 w=2u l=0.13u
MN4585 (seen_sync1 n2668 storage4584 vss) n12 w=1.2u l=0.13u
MP4586 (seen_sync1 n2680 storage4584 vdd) p12 w=3.6u l=0.13u
MN4587 (qm4581 n2677 storage4584 vss) n12 w=1.2u l=0.13u
MP4588 (qm4581 n2683 storage4584 vdd) p12 w=3.6u l=0.13u
MN4589 (qmb4582 storage4584 vss vss) n12 w=0.5u l=0.13u
MP4590 (qmb4582 storage4584 vdd vdd) p12 w=1.5u l=0.13u
MN4591 (qm4581 qmb4582 vss vss) n12 w=0.5u l=0.13u
MP4592 (qm4581 qmb4582 vdd vdd) p12 w=1.5u l=0.13u
MN4593 (storage4584 n202 vss vss) n12 w=2u l=0.13u
MN4595 (qm4581 n2677 storage4594 vss) n12 w=1.2u l=0.13u
MP4596 (qm4581 n2683 storage4594 vdd) p12 w=3.6u l=0.13u
MN4597 (seen_sync2 n2668 storage4594 vss) n12 w=1.2u l=0.13u
MP4598 (seen_sync2 n2680 storage4594 vdd) p12 w=3.6u l=0.13u
MN4599 (qb4583 storage4594 vss vss) n12 w=0.5u l=0.13u
MP4600 (qb4583 storage4594 vdd vdd) p12 w=1.5u l=0.13u
MN4601 (seen_sync2 qb4583 vss vss) n12 w=0.5u l=0.13u
MP4602 (seen_sync2 qb4583 vdd vdd) p12 w=1.5u l=0.13u
MN4603 (storage4594 n202 vss vss) n12 w=2u l=0.13u
MN4608 (seen_sync2 n2668 storage4607 vss) n12 w=1.2u l=0.13u
MP4609 (seen_sync2 n2680 storage4607 vdd) p12 w=3.6u l=0.13u
MN4610 (qm4604 n2677 storage4607 vss) n12 w=1.2u l=0.13u
MP4611 (qm4604 n2683 storage4607 vdd) p12 w=3.6u l=0.13u
MN4612 (qmb4605 storage4607 vss vss) n12 w=0.5u l=0.13u
MP4613 (qmb4605 storage4607 vdd vdd) p12 w=1.5u l=0.13u
MN4614 (qm4604 qmb4605 vss vss) n12 w=0.5u l=0.13u
MP4615 (qm4604 qmb4605 vdd vdd) p12 w=1.5u l=0.13u
MN4616 (storage4607 n202 vss vss) n12 w=2u l=0.13u
MN4618 (qm4604 n2677 storage4617 vss) n12 w=1.2u l=0.13u
MP4619 (qm4604 n2683 storage4617 vdd) p12 w=3.6u l=0.13u
MN4620 (epoch_valid1 n2668 storage4617 vss) n12 w=1.2u l=0.13u
MP4621 (epoch_valid1 n2680 storage4617 vdd) p12 w=3.6u l=0.13u
MN4622 (qb4606 storage4617 vss vss) n12 w=0.5u l=0.13u
MP4623 (qb4606 storage4617 vdd vdd) p12 w=1.5u l=0.13u
MN4624 (epoch_valid1 qb4606 vss vss) n12 w=0.5u l=0.13u
MP4625 (epoch_valid1 qb4606 vdd vdd) p12 w=1.5u l=0.13u
MN4626 (storage4617 n202 vss vss) n12 w=2u l=0.13u
MN4631 (epoch_valid1 n2668 storage4630 vss) n12 w=1.2u l=0.13u
MP4632 (epoch_valid1 n2680 storage4630 vdd) p12 w=3.6u l=0.13u
MN4633 (qm4627 n2677 storage4630 vss) n12 w=1.2u l=0.13u
MP4634 (qm4627 n2683 storage4630 vdd) p12 w=3.6u l=0.13u
MN4635 (qmb4628 storage4630 vss vss) n12 w=0.5u l=0.13u
MP4636 (qmb4628 storage4630 vdd vdd) p12 w=1.5u l=0.13u
MN4637 (qm4627 qmb4628 vss vss) n12 w=0.5u l=0.13u
MP4638 (qm4627 qmb4628 vdd vdd) p12 w=1.5u l=0.13u
MN4639 (storage4630 n202 vss vss) n12 w=2u l=0.13u
MN4641 (qm4627 n2677 storage4640 vss) n12 w=1.2u l=0.13u
MP4642 (qm4627 n2683 storage4640 vdd) p12 w=3.6u l=0.13u
MN4643 (epoch_valid n2668 storage4640 vss) n12 w=1.2u l=0.13u
MP4644 (epoch_valid n2680 storage4640 vdd) p12 w=3.6u l=0.13u
MN4645 (qb4629 storage4640 vss vss) n12 w=0.5u l=0.13u
MP4646 (qb4629 storage4640 vdd vdd) p12 w=1.5u l=0.13u
MN4647 (epoch_valid qb4629 vss vss) n12 w=0.5u l=0.13u
MP4648 (epoch_valid qb4629 vdd vdd) p12 w=1.5u l=0.13u
MN4649 (storage4640 n202 vss vss) n12 w=2u l=0.13u
MN4651 (n4650 cd0 vss vss) n12 w=0.8u l=0.13u
MP4652 (n4650 cd0 vdd vdd) p12 w=2.4u l=0.13u
MN4655 (n4653 cg0 n4654 vss) n12 w=1.6u l=0.13u
MN4656 (n4654 n4650 vss vss) n12 w=1.6u l=0.13u
MP4657 (n4653 cg0 vdd vdd) p12 w=2.4u l=0.13u
MP4658 (n4653 n4650 vdd vdd) p12 w=2.4u l=0.13u
MN4661 (n4659 cg0 n4660 vss) n12 w=1.6u l=0.13u
MN4662 (n4660 n4653 vss vss) n12 w=1.6u l=0.13u
MP4663 (n4659 cg0 vdd vdd) p12 w=2.4u l=0.13u
MP4664 (n4659 n4653 vdd vdd) p12 w=2.4u l=0.13u
MN4667 (n4665 n4650 n4666 vss) n12 w=1.6u l=0.13u
MN4668 (n4666 n4653 vss vss) n12 w=1.6u l=0.13u
MP4669 (n4665 n4650 vdd vdd) p12 w=2.4u l=0.13u
MP4670 (n4665 n4653 vdd vdd) p12 w=2.4u l=0.13u
MN4673 (n4671 n4659 n4672 vss) n12 w=1.6u l=0.13u
MN4674 (n4672 n4665 vss vss) n12 w=1.6u l=0.13u
MP4675 (n4671 n4659 vdd vdd) p12 w=2.4u l=0.13u
MP4676 (n4671 n4665 vdd vdd) p12 w=2.4u l=0.13u
MN4678 (n4677 n4671 vss vss) n12 w=0.8u l=0.13u
MP4679 (n4677 n4671 vdd vdd) p12 w=2.4u l=0.13u
MN4681 (n4680 n4653 vss vss) n12 w=0.8u l=0.13u
MP4682 (n4680 n4653 vdd vdd) p12 w=2.4u l=0.13u
MN4685 (n4683 n4671 vss vss) n12 w=0.8u l=0.13u
MN4686 (n4683 n4680 vss vss) n12 w=0.8u l=0.13u
MP4687 (n4683 n4671 n4684 vdd) p12 w=4.8u l=0.13u
MP4688 (n4684 n4680 vdd vdd) p12 w=4.8u l=0.13u
MN4690 (n4689 n4683 vss vss) n12 w=0.8u l=0.13u
MP4691 (n4689 n4683 vdd vdd) p12 w=2.4u l=0.13u
MN4693 (n4692 cd1 vss vss) n12 w=0.8u l=0.13u
MP4694 (n4692 cd1 vdd vdd) p12 w=2.4u l=0.13u
MN4697 (n4695 cg1 n4696 vss) n12 w=1.6u l=0.13u
MN4698 (n4696 n4692 vss vss) n12 w=1.6u l=0.13u
MP4699 (n4695 cg1 vdd vdd) p12 w=2.4u l=0.13u
MP4700 (n4695 n4692 vdd vdd) p12 w=2.4u l=0.13u
MN4703 (n4701 cg1 n4702 vss) n12 w=1.6u l=0.13u
MN4704 (n4702 n4695 vss vss) n12 w=1.6u l=0.13u
MP4705 (n4701 cg1 vdd vdd) p12 w=2.4u l=0.13u
MP4706 (n4701 n4695 vdd vdd) p12 w=2.4u l=0.13u
MN4709 (n4707 n4692 n4708 vss) n12 w=1.6u l=0.13u
MN4710 (n4708 n4695 vss vss) n12 w=1.6u l=0.13u
MP4711 (n4707 n4692 vdd vdd) p12 w=2.4u l=0.13u
MP4712 (n4707 n4695 vdd vdd) p12 w=2.4u l=0.13u
MN4715 (n4713 n4701 n4714 vss) n12 w=1.6u l=0.13u
MN4716 (n4714 n4707 vss vss) n12 w=1.6u l=0.13u
MP4717 (n4713 n4701 vdd vdd) p12 w=2.4u l=0.13u
MP4718 (n4713 n4707 vdd vdd) p12 w=2.4u l=0.13u
MN4721 (n4719 n4689 n4720 vss) n12 w=1.6u l=0.13u
MN4722 (n4720 n4713 vss vss) n12 w=1.6u l=0.13u
MP4723 (n4719 n4689 vdd vdd) p12 w=2.4u l=0.13u
MP4724 (n4719 n4713 vdd vdd) p12 w=2.4u l=0.13u
MN4727 (n4725 n4689 n4726 vss) n12 w=1.6u l=0.13u
MN4728 (n4726 n4719 vss vss) n12 w=1.6u l=0.13u
MP4729 (n4725 n4689 vdd vdd) p12 w=2.4u l=0.13u
MP4730 (n4725 n4719 vdd vdd) p12 w=2.4u l=0.13u
MN4733 (n4731 n4713 n4732 vss) n12 w=1.6u l=0.13u
MN4734 (n4732 n4719 vss vss) n12 w=1.6u l=0.13u
MP4735 (n4731 n4713 vdd vdd) p12 w=2.4u l=0.13u
MP4736 (n4731 n4719 vdd vdd) p12 w=2.4u l=0.13u
MN4739 (n4737 n4725 n4738 vss) n12 w=1.6u l=0.13u
MN4740 (n4738 n4731 vss vss) n12 w=1.6u l=0.13u
MP4741 (n4737 n4725 vdd vdd) p12 w=2.4u l=0.13u
MP4742 (n4737 n4731 vdd vdd) p12 w=2.4u l=0.13u
MN4744 (n4743 n4695 vss vss) n12 w=0.8u l=0.13u
MP4745 (n4743 n4695 vdd vdd) p12 w=2.4u l=0.13u
MN4747 (n4746 n4719 vss vss) n12 w=0.8u l=0.13u
MP4748 (n4746 n4719 vdd vdd) p12 w=2.4u l=0.13u
MN4751 (n4749 n4743 vss vss) n12 w=0.8u l=0.13u
MN4752 (n4749 n4746 vss vss) n12 w=0.8u l=0.13u
MP4753 (n4749 n4743 n4750 vdd) p12 w=4.8u l=0.13u
MP4754 (n4750 n4746 vdd vdd) p12 w=4.8u l=0.13u
MN4756 (n4755 n4749 vss vss) n12 w=0.8u l=0.13u
MP4757 (n4755 n4749 vdd vdd) p12 w=2.4u l=0.13u
MN4759 (n4758 cd2 vss vss) n12 w=0.8u l=0.13u
MP4760 (n4758 cd2 vdd vdd) p12 w=2.4u l=0.13u
MN4763 (n4761 cg2 n4762 vss) n12 w=1.6u l=0.13u
MN4764 (n4762 n4758 vss vss) n12 w=1.6u l=0.13u
MP4765 (n4761 cg2 vdd vdd) p12 w=2.4u l=0.13u
MP4766 (n4761 n4758 vdd vdd) p12 w=2.4u l=0.13u
MN4769 (n4767 cg2 n4768 vss) n12 w=1.6u l=0.13u
MN4770 (n4768 n4761 vss vss) n12 w=1.6u l=0.13u
MP4771 (n4767 cg2 vdd vdd) p12 w=2.4u l=0.13u
MP4772 (n4767 n4761 vdd vdd) p12 w=2.4u l=0.13u
MN4775 (n4773 n4758 n4774 vss) n12 w=1.6u l=0.13u
MN4776 (n4774 n4761 vss vss) n12 w=1.6u l=0.13u
MP4777 (n4773 n4758 vdd vdd) p12 w=2.4u l=0.13u
MP4778 (n4773 n4761 vdd vdd) p12 w=2.4u l=0.13u
MN4781 (n4779 n4767 n4780 vss) n12 w=1.6u l=0.13u
MN4782 (n4780 n4773 vss vss) n12 w=1.6u l=0.13u
MP4783 (n4779 n4767 vdd vdd) p12 w=2.4u l=0.13u
MP4784 (n4779 n4773 vdd vdd) p12 w=2.4u l=0.13u
MN4787 (n4785 n4755 n4786 vss) n12 w=1.6u l=0.13u
MN4788 (n4786 n4779 vss vss) n12 w=1.6u l=0.13u
MP4789 (n4785 n4755 vdd vdd) p12 w=2.4u l=0.13u
MP4790 (n4785 n4779 vdd vdd) p12 w=2.4u l=0.13u
MN4793 (n4791 n4755 n4792 vss) n12 w=1.6u l=0.13u
MN4794 (n4792 n4785 vss vss) n12 w=1.6u l=0.13u
MP4795 (n4791 n4755 vdd vdd) p12 w=2.4u l=0.13u
MP4796 (n4791 n4785 vdd vdd) p12 w=2.4u l=0.13u
MN4799 (n4797 n4779 n4798 vss) n12 w=1.6u l=0.13u
MN4800 (n4798 n4785 vss vss) n12 w=1.6u l=0.13u
MP4801 (n4797 n4779 vdd vdd) p12 w=2.4u l=0.13u
MP4802 (n4797 n4785 vdd vdd) p12 w=2.4u l=0.13u
MN4805 (n4803 n4791 n4804 vss) n12 w=1.6u l=0.13u
MN4806 (n4804 n4797 vss vss) n12 w=1.6u l=0.13u
MP4807 (n4803 n4791 vdd vdd) p12 w=2.4u l=0.13u
MP4808 (n4803 n4797 vdd vdd) p12 w=2.4u l=0.13u
MN4810 (n4809 n4761 vss vss) n12 w=0.8u l=0.13u
MP4811 (n4809 n4761 vdd vdd) p12 w=2.4u l=0.13u
MN4813 (n4812 n4785 vss vss) n12 w=0.8u l=0.13u
MP4814 (n4812 n4785 vdd vdd) p12 w=2.4u l=0.13u
MN4817 (n4815 n4809 vss vss) n12 w=0.8u l=0.13u
MN4818 (n4815 n4812 vss vss) n12 w=0.8u l=0.13u
MP4819 (n4815 n4809 n4816 vdd) p12 w=4.8u l=0.13u
MP4820 (n4816 n4812 vdd vdd) p12 w=4.8u l=0.13u
MN4822 (n4821 n4815 vss vss) n12 w=0.8u l=0.13u
MP4823 (n4821 n4815 vdd vdd) p12 w=2.4u l=0.13u
MN4825 (n4824 cd3 vss vss) n12 w=0.8u l=0.13u
MP4826 (n4824 cd3 vdd vdd) p12 w=2.4u l=0.13u
MN4829 (n4827 cg3 n4828 vss) n12 w=1.6u l=0.13u
MN4830 (n4828 n4824 vss vss) n12 w=1.6u l=0.13u
MP4831 (n4827 cg3 vdd vdd) p12 w=2.4u l=0.13u
MP4832 (n4827 n4824 vdd vdd) p12 w=2.4u l=0.13u
MN4835 (n4833 cg3 n4834 vss) n12 w=1.6u l=0.13u
MN4836 (n4834 n4827 vss vss) n12 w=1.6u l=0.13u
MP4837 (n4833 cg3 vdd vdd) p12 w=2.4u l=0.13u
MP4838 (n4833 n4827 vdd vdd) p12 w=2.4u l=0.13u
MN4841 (n4839 n4824 n4840 vss) n12 w=1.6u l=0.13u
MN4842 (n4840 n4827 vss vss) n12 w=1.6u l=0.13u
MP4843 (n4839 n4824 vdd vdd) p12 w=2.4u l=0.13u
MP4844 (n4839 n4827 vdd vdd) p12 w=2.4u l=0.13u
MN4847 (n4845 n4833 n4846 vss) n12 w=1.6u l=0.13u
MN4848 (n4846 n4839 vss vss) n12 w=1.6u l=0.13u
MP4849 (n4845 n4833 vdd vdd) p12 w=2.4u l=0.13u
MP4850 (n4845 n4839 vdd vdd) p12 w=2.4u l=0.13u
MN4853 (n4851 n4821 n4852 vss) n12 w=1.6u l=0.13u
MN4854 (n4852 n4845 vss vss) n12 w=1.6u l=0.13u
MP4855 (n4851 n4821 vdd vdd) p12 w=2.4u l=0.13u
MP4856 (n4851 n4845 vdd vdd) p12 w=2.4u l=0.13u
MN4859 (n4857 n4821 n4858 vss) n12 w=1.6u l=0.13u
MN4860 (n4858 n4851 vss vss) n12 w=1.6u l=0.13u
MP4861 (n4857 n4821 vdd vdd) p12 w=2.4u l=0.13u
MP4862 (n4857 n4851 vdd vdd) p12 w=2.4u l=0.13u
MN4865 (n4863 n4845 n4864 vss) n12 w=1.6u l=0.13u
MN4866 (n4864 n4851 vss vss) n12 w=1.6u l=0.13u
MP4867 (n4863 n4845 vdd vdd) p12 w=2.4u l=0.13u
MP4868 (n4863 n4851 vdd vdd) p12 w=2.4u l=0.13u
MN4871 (n4869 n4857 n4870 vss) n12 w=1.6u l=0.13u
MN4872 (n4870 n4863 vss vss) n12 w=1.6u l=0.13u
MP4873 (n4869 n4857 vdd vdd) p12 w=2.4u l=0.13u
MP4874 (n4869 n4863 vdd vdd) p12 w=2.4u l=0.13u
MN4876 (n4875 n4827 vss vss) n12 w=0.8u l=0.13u
MP4877 (n4875 n4827 vdd vdd) p12 w=2.4u l=0.13u
MN4879 (n4878 n4851 vss vss) n12 w=0.8u l=0.13u
MP4880 (n4878 n4851 vdd vdd) p12 w=2.4u l=0.13u
MN4883 (n4881 n4875 vss vss) n12 w=0.8u l=0.13u
MN4884 (n4881 n4878 vss vss) n12 w=0.8u l=0.13u
MP4885 (n4881 n4875 n4882 vdd) p12 w=4.8u l=0.13u
MP4886 (n4882 n4878 vdd vdd) p12 w=4.8u l=0.13u
MN4888 (n4887 n4881 vss vss) n12 w=0.8u l=0.13u
MP4889 (n4887 n4881 vdd vdd) p12 w=2.4u l=0.13u
MN4891 (n4890 cd4 vss vss) n12 w=0.8u l=0.13u
MP4892 (n4890 cd4 vdd vdd) p12 w=2.4u l=0.13u
MN4895 (n4893 cg4 n4894 vss) n12 w=1.6u l=0.13u
MN4896 (n4894 n4890 vss vss) n12 w=1.6u l=0.13u
MP4897 (n4893 cg4 vdd vdd) p12 w=2.4u l=0.13u
MP4898 (n4893 n4890 vdd vdd) p12 w=2.4u l=0.13u
MN4901 (n4899 cg4 n4900 vss) n12 w=1.6u l=0.13u
MN4902 (n4900 n4893 vss vss) n12 w=1.6u l=0.13u
MP4903 (n4899 cg4 vdd vdd) p12 w=2.4u l=0.13u
MP4904 (n4899 n4893 vdd vdd) p12 w=2.4u l=0.13u
MN4907 (n4905 n4890 n4906 vss) n12 w=1.6u l=0.13u
MN4908 (n4906 n4893 vss vss) n12 w=1.6u l=0.13u
MP4909 (n4905 n4890 vdd vdd) p12 w=2.4u l=0.13u
MP4910 (n4905 n4893 vdd vdd) p12 w=2.4u l=0.13u
MN4913 (n4911 n4899 n4912 vss) n12 w=1.6u l=0.13u
MN4914 (n4912 n4905 vss vss) n12 w=1.6u l=0.13u
MP4915 (n4911 n4899 vdd vdd) p12 w=2.4u l=0.13u
MP4916 (n4911 n4905 vdd vdd) p12 w=2.4u l=0.13u
MN4919 (n4917 n4887 n4918 vss) n12 w=1.6u l=0.13u
MN4920 (n4918 n4911 vss vss) n12 w=1.6u l=0.13u
MP4921 (n4917 n4887 vdd vdd) p12 w=2.4u l=0.13u
MP4922 (n4917 n4911 vdd vdd) p12 w=2.4u l=0.13u
MN4925 (n4923 n4887 n4924 vss) n12 w=1.6u l=0.13u
MN4926 (n4924 n4917 vss vss) n12 w=1.6u l=0.13u
MP4927 (n4923 n4887 vdd vdd) p12 w=2.4u l=0.13u
MP4928 (n4923 n4917 vdd vdd) p12 w=2.4u l=0.13u
MN4931 (n4929 n4911 n4930 vss) n12 w=1.6u l=0.13u
MN4932 (n4930 n4917 vss vss) n12 w=1.6u l=0.13u
MP4933 (n4929 n4911 vdd vdd) p12 w=2.4u l=0.13u
MP4934 (n4929 n4917 vdd vdd) p12 w=2.4u l=0.13u
MN4937 (n4935 n4923 n4936 vss) n12 w=1.6u l=0.13u
MN4938 (n4936 n4929 vss vss) n12 w=1.6u l=0.13u
MP4939 (n4935 n4923 vdd vdd) p12 w=2.4u l=0.13u
MP4940 (n4935 n4929 vdd vdd) p12 w=2.4u l=0.13u
MN4942 (n4941 n4893 vss vss) n12 w=0.8u l=0.13u
MP4943 (n4941 n4893 vdd vdd) p12 w=2.4u l=0.13u
MN4945 (n4944 n4917 vss vss) n12 w=0.8u l=0.13u
MP4946 (n4944 n4917 vdd vdd) p12 w=2.4u l=0.13u
MN4949 (n4947 n4941 vss vss) n12 w=0.8u l=0.13u
MN4950 (n4947 n4944 vss vss) n12 w=0.8u l=0.13u
MP4951 (n4947 n4941 n4948 vdd) p12 w=4.8u l=0.13u
MP4952 (n4948 n4944 vdd vdd) p12 w=4.8u l=0.13u
MN4954 (n4953 n4947 vss vss) n12 w=0.8u l=0.13u
MP4955 (n4953 n4947 vdd vdd) p12 w=2.4u l=0.13u
MN4957 (n4956 cd5 vss vss) n12 w=0.8u l=0.13u
MP4958 (n4956 cd5 vdd vdd) p12 w=2.4u l=0.13u
MN4961 (n4959 cg5 n4960 vss) n12 w=1.6u l=0.13u
MN4962 (n4960 n4956 vss vss) n12 w=1.6u l=0.13u
MP4963 (n4959 cg5 vdd vdd) p12 w=2.4u l=0.13u
MP4964 (n4959 n4956 vdd vdd) p12 w=2.4u l=0.13u
MN4967 (n4965 cg5 n4966 vss) n12 w=1.6u l=0.13u
MN4968 (n4966 n4959 vss vss) n12 w=1.6u l=0.13u
MP4969 (n4965 cg5 vdd vdd) p12 w=2.4u l=0.13u
MP4970 (n4965 n4959 vdd vdd) p12 w=2.4u l=0.13u
MN4973 (n4971 n4956 n4972 vss) n12 w=1.6u l=0.13u
MN4974 (n4972 n4959 vss vss) n12 w=1.6u l=0.13u
MP4975 (n4971 n4956 vdd vdd) p12 w=2.4u l=0.13u
MP4976 (n4971 n4959 vdd vdd) p12 w=2.4u l=0.13u
MN4979 (n4977 n4965 n4978 vss) n12 w=1.6u l=0.13u
MN4980 (n4978 n4971 vss vss) n12 w=1.6u l=0.13u
MP4981 (n4977 n4965 vdd vdd) p12 w=2.4u l=0.13u
MP4982 (n4977 n4971 vdd vdd) p12 w=2.4u l=0.13u
MN4985 (n4983 n4953 n4984 vss) n12 w=1.6u l=0.13u
MN4986 (n4984 n4977 vss vss) n12 w=1.6u l=0.13u
MP4987 (n4983 n4953 vdd vdd) p12 w=2.4u l=0.13u
MP4988 (n4983 n4977 vdd vdd) p12 w=2.4u l=0.13u
MN4991 (n4989 n4953 n4990 vss) n12 w=1.6u l=0.13u
MN4992 (n4990 n4983 vss vss) n12 w=1.6u l=0.13u
MP4993 (n4989 n4953 vdd vdd) p12 w=2.4u l=0.13u
MP4994 (n4989 n4983 vdd vdd) p12 w=2.4u l=0.13u
MN4997 (n4995 n4977 n4996 vss) n12 w=1.6u l=0.13u
MN4998 (n4996 n4983 vss vss) n12 w=1.6u l=0.13u
MP4999 (n4995 n4977 vdd vdd) p12 w=2.4u l=0.13u
MP5000 (n4995 n4983 vdd vdd) p12 w=2.4u l=0.13u
MN5003 (n5001 n4989 n5002 vss) n12 w=1.6u l=0.13u
MN5004 (n5002 n4995 vss vss) n12 w=1.6u l=0.13u
MP5005 (n5001 n4989 vdd vdd) p12 w=2.4u l=0.13u
MP5006 (n5001 n4995 vdd vdd) p12 w=2.4u l=0.13u
MN5008 (n5007 n4959 vss vss) n12 w=0.8u l=0.13u
MP5009 (n5007 n4959 vdd vdd) p12 w=2.4u l=0.13u
MN5011 (n5010 n4983 vss vss) n12 w=0.8u l=0.13u
MP5012 (n5010 n4983 vdd vdd) p12 w=2.4u l=0.13u
MN5015 (n5013 n5007 vss vss) n12 w=0.8u l=0.13u
MN5016 (n5013 n5010 vss vss) n12 w=0.8u l=0.13u
MP5017 (n5013 n5007 n5014 vdd) p12 w=4.8u l=0.13u
MP5018 (n5014 n5010 vdd vdd) p12 w=4.8u l=0.13u
MN5020 (n5019 n5013 vss vss) n12 w=0.8u l=0.13u
MP5021 (n5019 n5013 vdd vdd) p12 w=2.4u l=0.13u
MN5023 (n5022 cd6 vss vss) n12 w=0.8u l=0.13u
MP5024 (n5022 cd6 vdd vdd) p12 w=2.4u l=0.13u
MN5027 (n5025 cg6 n5026 vss) n12 w=1.6u l=0.13u
MN5028 (n5026 n5022 vss vss) n12 w=1.6u l=0.13u
MP5029 (n5025 cg6 vdd vdd) p12 w=2.4u l=0.13u
MP5030 (n5025 n5022 vdd vdd) p12 w=2.4u l=0.13u
MN5033 (n5031 cg6 n5032 vss) n12 w=1.6u l=0.13u
MN5034 (n5032 n5025 vss vss) n12 w=1.6u l=0.13u
MP5035 (n5031 cg6 vdd vdd) p12 w=2.4u l=0.13u
MP5036 (n5031 n5025 vdd vdd) p12 w=2.4u l=0.13u
MN5039 (n5037 n5022 n5038 vss) n12 w=1.6u l=0.13u
MN5040 (n5038 n5025 vss vss) n12 w=1.6u l=0.13u
MP5041 (n5037 n5022 vdd vdd) p12 w=2.4u l=0.13u
MP5042 (n5037 n5025 vdd vdd) p12 w=2.4u l=0.13u
MN5045 (n5043 n5031 n5044 vss) n12 w=1.6u l=0.13u
MN5046 (n5044 n5037 vss vss) n12 w=1.6u l=0.13u
MP5047 (n5043 n5031 vdd vdd) p12 w=2.4u l=0.13u
MP5048 (n5043 n5037 vdd vdd) p12 w=2.4u l=0.13u
MN5051 (n5049 n5019 n5050 vss) n12 w=1.6u l=0.13u
MN5052 (n5050 n5043 vss vss) n12 w=1.6u l=0.13u
MP5053 (n5049 n5019 vdd vdd) p12 w=2.4u l=0.13u
MP5054 (n5049 n5043 vdd vdd) p12 w=2.4u l=0.13u
MN5057 (n5055 n5019 n5056 vss) n12 w=1.6u l=0.13u
MN5058 (n5056 n5049 vss vss) n12 w=1.6u l=0.13u
MP5059 (n5055 n5019 vdd vdd) p12 w=2.4u l=0.13u
MP5060 (n5055 n5049 vdd vdd) p12 w=2.4u l=0.13u
MN5063 (n5061 n5043 n5062 vss) n12 w=1.6u l=0.13u
MN5064 (n5062 n5049 vss vss) n12 w=1.6u l=0.13u
MP5065 (n5061 n5043 vdd vdd) p12 w=2.4u l=0.13u
MP5066 (n5061 n5049 vdd vdd) p12 w=2.4u l=0.13u
MN5069 (n5067 n5055 n5068 vss) n12 w=1.6u l=0.13u
MN5070 (n5068 n5061 vss vss) n12 w=1.6u l=0.13u
MP5071 (n5067 n5055 vdd vdd) p12 w=2.4u l=0.13u
MP5072 (n5067 n5061 vdd vdd) p12 w=2.4u l=0.13u
MN5074 (n5073 n5025 vss vss) n12 w=0.8u l=0.13u
MP5075 (n5073 n5025 vdd vdd) p12 w=2.4u l=0.13u
MN5077 (n5076 n5049 vss vss) n12 w=0.8u l=0.13u
MP5078 (n5076 n5049 vdd vdd) p12 w=2.4u l=0.13u
MN5081 (n5079 n5073 vss vss) n12 w=0.8u l=0.13u
MN5082 (n5079 n5076 vss vss) n12 w=0.8u l=0.13u
MP5083 (n5079 n5073 n5080 vdd) p12 w=4.8u l=0.13u
MP5084 (n5080 n5076 vdd vdd) p12 w=4.8u l=0.13u
MN5086 (n5085 n5079 vss vss) n12 w=0.8u l=0.13u
MP5087 (n5085 n5079 vdd vdd) p12 w=2.4u l=0.13u
MN5089 (n5088 cd7 vss vss) n12 w=0.8u l=0.13u
MP5090 (n5088 cd7 vdd vdd) p12 w=2.4u l=0.13u
MN5093 (n5091 cg7 n5092 vss) n12 w=1.6u l=0.13u
MN5094 (n5092 n5088 vss vss) n12 w=1.6u l=0.13u
MP5095 (n5091 cg7 vdd vdd) p12 w=2.4u l=0.13u
MP5096 (n5091 n5088 vdd vdd) p12 w=2.4u l=0.13u
MN5099 (n5097 cg7 n5098 vss) n12 w=1.6u l=0.13u
MN5100 (n5098 n5091 vss vss) n12 w=1.6u l=0.13u
MP5101 (n5097 cg7 vdd vdd) p12 w=2.4u l=0.13u
MP5102 (n5097 n5091 vdd vdd) p12 w=2.4u l=0.13u
MN5105 (n5103 n5088 n5104 vss) n12 w=1.6u l=0.13u
MN5106 (n5104 n5091 vss vss) n12 w=1.6u l=0.13u
MP5107 (n5103 n5088 vdd vdd) p12 w=2.4u l=0.13u
MP5108 (n5103 n5091 vdd vdd) p12 w=2.4u l=0.13u
MN5111 (n5109 n5097 n5110 vss) n12 w=1.6u l=0.13u
MN5112 (n5110 n5103 vss vss) n12 w=1.6u l=0.13u
MP5113 (n5109 n5097 vdd vdd) p12 w=2.4u l=0.13u
MP5114 (n5109 n5103 vdd vdd) p12 w=2.4u l=0.13u
MN5117 (n5115 n5085 n5116 vss) n12 w=1.6u l=0.13u
MN5118 (n5116 n5109 vss vss) n12 w=1.6u l=0.13u
MP5119 (n5115 n5085 vdd vdd) p12 w=2.4u l=0.13u
MP5120 (n5115 n5109 vdd vdd) p12 w=2.4u l=0.13u
MN5123 (n5121 n5085 n5122 vss) n12 w=1.6u l=0.13u
MN5124 (n5122 n5115 vss vss) n12 w=1.6u l=0.13u
MP5125 (n5121 n5085 vdd vdd) p12 w=2.4u l=0.13u
MP5126 (n5121 n5115 vdd vdd) p12 w=2.4u l=0.13u
MN5129 (n5127 n5109 n5128 vss) n12 w=1.6u l=0.13u
MN5130 (n5128 n5115 vss vss) n12 w=1.6u l=0.13u
MP5131 (n5127 n5109 vdd vdd) p12 w=2.4u l=0.13u
MP5132 (n5127 n5115 vdd vdd) p12 w=2.4u l=0.13u
MN5135 (n5133 n5121 n5134 vss) n12 w=1.6u l=0.13u
MN5136 (n5134 n5127 vss vss) n12 w=1.6u l=0.13u
MP5137 (n5133 n5121 vdd vdd) p12 w=2.4u l=0.13u
MP5138 (n5133 n5127 vdd vdd) p12 w=2.4u l=0.13u
MN5140 (n5139 n5091 vss vss) n12 w=0.8u l=0.13u
MP5141 (n5139 n5091 vdd vdd) p12 w=2.4u l=0.13u
MN5143 (n5142 n5115 vss vss) n12 w=0.8u l=0.13u
MP5144 (n5142 n5115 vdd vdd) p12 w=2.4u l=0.13u
MN5147 (n5145 n5139 vss vss) n12 w=0.8u l=0.13u
MN5148 (n5145 n5142 vss vss) n12 w=0.8u l=0.13u
MP5149 (n5145 n5139 n5146 vdd) p12 w=4.8u l=0.13u
MP5150 (n5146 n5142 vdd vdd) p12 w=4.8u l=0.13u
MN5152 (n5151 n5145 vss vss) n12 w=0.8u l=0.13u
MP5153 (n5151 n5145 vdd vdd) p12 w=2.4u l=0.13u
MN5156 (n5154 n4737 vss vss) n12 w=0.8u l=0.13u
MN5157 (n5154 n4803 vss vss) n12 w=0.8u l=0.13u
MP5158 (n5154 n4737 n5155 vdd) p12 w=4.8u l=0.13u
MP5159 (n5155 n4803 vdd vdd) p12 w=4.8u l=0.13u
MN5161 (n5160 n5154 vss vss) n12 w=0.8u l=0.13u
MP5162 (n5160 n5154 vdd vdd) p12 w=2.4u l=0.13u
MN5165 (n5163 n4869 vss vss) n12 w=0.8u l=0.13u
MN5166 (n5163 n4935 vss vss) n12 w=0.8u l=0.13u
MP5167 (n5163 n4869 n5164 vdd) p12 w=4.8u l=0.13u
MP5168 (n5164 n4935 vdd vdd) p12 w=4.8u l=0.13u
MN5170 (n5169 n5163 vss vss) n12 w=0.8u l=0.13u
MP5171 (n5169 n5163 vdd vdd) p12 w=2.4u l=0.13u
MN5174 (n5172 n5001 vss vss) n12 w=0.8u l=0.13u
MN5175 (n5172 n5067 vss vss) n12 w=0.8u l=0.13u
MP5176 (n5172 n5001 n5173 vdd) p12 w=4.8u l=0.13u
MP5177 (n5173 n5067 vdd vdd) p12 w=4.8u l=0.13u
MN5179 (n5178 n5172 vss vss) n12 w=0.8u l=0.13u
MP5180 (n5178 n5172 vdd vdd) p12 w=2.4u l=0.13u
MN5183 (n5181 n5160 vss vss) n12 w=0.8u l=0.13u
MN5184 (n5181 n5169 vss vss) n12 w=0.8u l=0.13u
MP5185 (n5181 n5160 n5182 vdd) p12 w=4.8u l=0.13u
MP5186 (n5182 n5169 vdd vdd) p12 w=4.8u l=0.13u
MN5188 (n5187 n5181 vss vss) n12 w=0.8u l=0.13u
MP5189 (n5187 n5181 vdd vdd) p12 w=2.4u l=0.13u
MN5192 (n5190 n5133 vss vss) n12 w=0.8u l=0.13u
MN5193 (n5190 n5178 vss vss) n12 w=0.8u l=0.13u
MP5194 (n5190 n5133 n5191 vdd) p12 w=4.8u l=0.13u
MP5195 (n5191 n5178 vdd vdd) p12 w=4.8u l=0.13u
MN5197 (n5196 n5190 vss vss) n12 w=0.8u l=0.13u
MP5198 (n5196 n5190 vdd vdd) p12 w=2.4u l=0.13u
MN5201 (n5199 n5187 vss vss) n12 w=0.8u l=0.13u
MN5202 (n5199 n5196 vss vss) n12 w=0.8u l=0.13u
MP5203 (n5199 n5187 n5200 vdd) p12 w=4.8u l=0.13u
MP5204 (n5200 n5196 vdd vdd) p12 w=4.8u l=0.13u
MN5206 (n5205 n5199 vss vss) n12 w=0.8u l=0.13u
MP5207 (n5205 n5199 vdd vdd) p12 w=2.4u l=0.13u
MN5210 (n5208 n5151 n5209 vss) n12 w=1.6u l=0.13u
MN5211 (n5209 n5205 vss vss) n12 w=1.6u l=0.13u
MP5212 (n5208 n5151 vdd vdd) p12 w=2.4u l=0.13u
MP5213 (n5208 n5205 vdd vdd) p12 w=2.4u l=0.13u
MN5215 (n5214 n5208 vss vss) n12 w=0.8u l=0.13u
MP5216 (n5214 n5208 vdd vdd) p12 w=2.4u l=0.13u
MN5218 (n5217 cl0 vss vss) n12 w=0.8u l=0.13u
MP5219 (n5217 cl0 vdd vdd) p12 w=2.4u l=0.13u
MN5222 (n5220 cd0 n5221 vss) n12 w=1.6u l=0.13u
MN5223 (n5221 n5217 vss vss) n12 w=1.6u l=0.13u
MP5224 (n5220 cd0 vdd vdd) p12 w=2.4u l=0.13u
MP5225 (n5220 n5217 vdd vdd) p12 w=2.4u l=0.13u
MN5228 (n5226 cd0 n5227 vss) n12 w=1.6u l=0.13u
MN5229 (n5227 n5220 vss vss) n12 w=1.6u l=0.13u
MP5230 (n5226 cd0 vdd vdd) p12 w=2.4u l=0.13u
MP5231 (n5226 n5220 vdd vdd) p12 w=2.4u l=0.13u
MN5234 (n5232 n5217 n5233 vss) n12 w=1.6u l=0.13u
MN5235 (n5233 n5220 vss vss) n12 w=1.6u l=0.13u
MP5236 (n5232 n5217 vdd vdd) p12 w=2.4u l=0.13u
MP5237 (n5232 n5220 vdd vdd) p12 w=2.4u l=0.13u
MN5240 (n5238 n5226 n5239 vss) n12 w=1.6u l=0.13u
MN5241 (n5239 n5232 vss vss) n12 w=1.6u l=0.13u
MP5242 (n5238 n5226 vdd vdd) p12 w=2.4u l=0.13u
MP5243 (n5238 n5232 vdd vdd) p12 w=2.4u l=0.13u
MN5245 (n5244 n5238 vss vss) n12 w=0.8u l=0.13u
MP5246 (n5244 n5238 vdd vdd) p12 w=2.4u l=0.13u
MN5248 (n5247 n5220 vss vss) n12 w=0.8u l=0.13u
MP5249 (n5247 n5220 vdd vdd) p12 w=2.4u l=0.13u
MN5252 (n5250 n5238 vss vss) n12 w=0.8u l=0.13u
MN5253 (n5250 n5247 vss vss) n12 w=0.8u l=0.13u
MP5254 (n5250 n5238 n5251 vdd) p12 w=4.8u l=0.13u
MP5255 (n5251 n5247 vdd vdd) p12 w=4.8u l=0.13u
MN5257 (n5256 n5250 vss vss) n12 w=0.8u l=0.13u
MP5258 (n5256 n5250 vdd vdd) p12 w=2.4u l=0.13u
MN5260 (n5259 cl1 vss vss) n12 w=0.8u l=0.13u
MP5261 (n5259 cl1 vdd vdd) p12 w=2.4u l=0.13u
MN5264 (n5262 cd1 n5263 vss) n12 w=1.6u l=0.13u
MN5265 (n5263 n5259 vss vss) n12 w=1.6u l=0.13u
MP5266 (n5262 cd1 vdd vdd) p12 w=2.4u l=0.13u
MP5267 (n5262 n5259 vdd vdd) p12 w=2.4u l=0.13u
MN5270 (n5268 cd1 n5269 vss) n12 w=1.6u l=0.13u
MN5271 (n5269 n5262 vss vss) n12 w=1.6u l=0.13u
MP5272 (n5268 cd1 vdd vdd) p12 w=2.4u l=0.13u
MP5273 (n5268 n5262 vdd vdd) p12 w=2.4u l=0.13u
MN5276 (n5274 n5259 n5275 vss) n12 w=1.6u l=0.13u
MN5277 (n5275 n5262 vss vss) n12 w=1.6u l=0.13u
MP5278 (n5274 n5259 vdd vdd) p12 w=2.4u l=0.13u
MP5279 (n5274 n5262 vdd vdd) p12 w=2.4u l=0.13u
MN5282 (n5280 n5268 n5281 vss) n12 w=1.6u l=0.13u
MN5283 (n5281 n5274 vss vss) n12 w=1.6u l=0.13u
MP5284 (n5280 n5268 vdd vdd) p12 w=2.4u l=0.13u
MP5285 (n5280 n5274 vdd vdd) p12 w=2.4u l=0.13u
MN5288 (n5286 n5256 n5287 vss) n12 w=1.6u l=0.13u
MN5289 (n5287 n5280 vss vss) n12 w=1.6u l=0.13u
MP5290 (n5286 n5256 vdd vdd) p12 w=2.4u l=0.13u
MP5291 (n5286 n5280 vdd vdd) p12 w=2.4u l=0.13u
MN5294 (n5292 n5256 n5293 vss) n12 w=1.6u l=0.13u
MN5295 (n5293 n5286 vss vss) n12 w=1.6u l=0.13u
MP5296 (n5292 n5256 vdd vdd) p12 w=2.4u l=0.13u
MP5297 (n5292 n5286 vdd vdd) p12 w=2.4u l=0.13u
MN5300 (n5298 n5280 n5299 vss) n12 w=1.6u l=0.13u
MN5301 (n5299 n5286 vss vss) n12 w=1.6u l=0.13u
MP5302 (n5298 n5280 vdd vdd) p12 w=2.4u l=0.13u
MP5303 (n5298 n5286 vdd vdd) p12 w=2.4u l=0.13u
MN5306 (n5304 n5292 n5305 vss) n12 w=1.6u l=0.13u
MN5307 (n5305 n5298 vss vss) n12 w=1.6u l=0.13u
MP5308 (n5304 n5292 vdd vdd) p12 w=2.4u l=0.13u
MP5309 (n5304 n5298 vdd vdd) p12 w=2.4u l=0.13u
MN5311 (n5310 n5262 vss vss) n12 w=0.8u l=0.13u
MP5312 (n5310 n5262 vdd vdd) p12 w=2.4u l=0.13u
MN5314 (n5313 n5286 vss vss) n12 w=0.8u l=0.13u
MP5315 (n5313 n5286 vdd vdd) p12 w=2.4u l=0.13u
MN5318 (n5316 n5310 vss vss) n12 w=0.8u l=0.13u
MN5319 (n5316 n5313 vss vss) n12 w=0.8u l=0.13u
MP5320 (n5316 n5310 n5317 vdd) p12 w=4.8u l=0.13u
MP5321 (n5317 n5313 vdd vdd) p12 w=4.8u l=0.13u
MN5323 (n5322 n5316 vss vss) n12 w=0.8u l=0.13u
MP5324 (n5322 n5316 vdd vdd) p12 w=2.4u l=0.13u
MN5326 (n5325 cl2 vss vss) n12 w=0.8u l=0.13u
MP5327 (n5325 cl2 vdd vdd) p12 w=2.4u l=0.13u
MN5330 (n5328 cd2 n5329 vss) n12 w=1.6u l=0.13u
MN5331 (n5329 n5325 vss vss) n12 w=1.6u l=0.13u
MP5332 (n5328 cd2 vdd vdd) p12 w=2.4u l=0.13u
MP5333 (n5328 n5325 vdd vdd) p12 w=2.4u l=0.13u
MN5336 (n5334 cd2 n5335 vss) n12 w=1.6u l=0.13u
MN5337 (n5335 n5328 vss vss) n12 w=1.6u l=0.13u
MP5338 (n5334 cd2 vdd vdd) p12 w=2.4u l=0.13u
MP5339 (n5334 n5328 vdd vdd) p12 w=2.4u l=0.13u
MN5342 (n5340 n5325 n5341 vss) n12 w=1.6u l=0.13u
MN5343 (n5341 n5328 vss vss) n12 w=1.6u l=0.13u
MP5344 (n5340 n5325 vdd vdd) p12 w=2.4u l=0.13u
MP5345 (n5340 n5328 vdd vdd) p12 w=2.4u l=0.13u
MN5348 (n5346 n5334 n5347 vss) n12 w=1.6u l=0.13u
MN5349 (n5347 n5340 vss vss) n12 w=1.6u l=0.13u
MP5350 (n5346 n5334 vdd vdd) p12 w=2.4u l=0.13u
MP5351 (n5346 n5340 vdd vdd) p12 w=2.4u l=0.13u
MN5354 (n5352 n5322 n5353 vss) n12 w=1.6u l=0.13u
MN5355 (n5353 n5346 vss vss) n12 w=1.6u l=0.13u
MP5356 (n5352 n5322 vdd vdd) p12 w=2.4u l=0.13u
MP5357 (n5352 n5346 vdd vdd) p12 w=2.4u l=0.13u
MN5360 (n5358 n5322 n5359 vss) n12 w=1.6u l=0.13u
MN5361 (n5359 n5352 vss vss) n12 w=1.6u l=0.13u
MP5362 (n5358 n5322 vdd vdd) p12 w=2.4u l=0.13u
MP5363 (n5358 n5352 vdd vdd) p12 w=2.4u l=0.13u
MN5366 (n5364 n5346 n5365 vss) n12 w=1.6u l=0.13u
MN5367 (n5365 n5352 vss vss) n12 w=1.6u l=0.13u
MP5368 (n5364 n5346 vdd vdd) p12 w=2.4u l=0.13u
MP5369 (n5364 n5352 vdd vdd) p12 w=2.4u l=0.13u
MN5372 (n5370 n5358 n5371 vss) n12 w=1.6u l=0.13u
MN5373 (n5371 n5364 vss vss) n12 w=1.6u l=0.13u
MP5374 (n5370 n5358 vdd vdd) p12 w=2.4u l=0.13u
MP5375 (n5370 n5364 vdd vdd) p12 w=2.4u l=0.13u
MN5377 (n5376 n5328 vss vss) n12 w=0.8u l=0.13u
MP5378 (n5376 n5328 vdd vdd) p12 w=2.4u l=0.13u
MN5380 (n5379 n5352 vss vss) n12 w=0.8u l=0.13u
MP5381 (n5379 n5352 vdd vdd) p12 w=2.4u l=0.13u
MN5384 (n5382 n5376 vss vss) n12 w=0.8u l=0.13u
MN5385 (n5382 n5379 vss vss) n12 w=0.8u l=0.13u
MP5386 (n5382 n5376 n5383 vdd) p12 w=4.8u l=0.13u
MP5387 (n5383 n5379 vdd vdd) p12 w=4.8u l=0.13u
MN5389 (n5388 n5382 vss vss) n12 w=0.8u l=0.13u
MP5390 (n5388 n5382 vdd vdd) p12 w=2.4u l=0.13u
MN5392 (n5391 cl3 vss vss) n12 w=0.8u l=0.13u
MP5393 (n5391 cl3 vdd vdd) p12 w=2.4u l=0.13u
MN5396 (n5394 cd3 n5395 vss) n12 w=1.6u l=0.13u
MN5397 (n5395 n5391 vss vss) n12 w=1.6u l=0.13u
MP5398 (n5394 cd3 vdd vdd) p12 w=2.4u l=0.13u
MP5399 (n5394 n5391 vdd vdd) p12 w=2.4u l=0.13u
MN5402 (n5400 cd3 n5401 vss) n12 w=1.6u l=0.13u
MN5403 (n5401 n5394 vss vss) n12 w=1.6u l=0.13u
MP5404 (n5400 cd3 vdd vdd) p12 w=2.4u l=0.13u
MP5405 (n5400 n5394 vdd vdd) p12 w=2.4u l=0.13u
MN5408 (n5406 n5391 n5407 vss) n12 w=1.6u l=0.13u
MN5409 (n5407 n5394 vss vss) n12 w=1.6u l=0.13u
MP5410 (n5406 n5391 vdd vdd) p12 w=2.4u l=0.13u
MP5411 (n5406 n5394 vdd vdd) p12 w=2.4u l=0.13u
MN5414 (n5412 n5400 n5413 vss) n12 w=1.6u l=0.13u
MN5415 (n5413 n5406 vss vss) n12 w=1.6u l=0.13u
MP5416 (n5412 n5400 vdd vdd) p12 w=2.4u l=0.13u
MP5417 (n5412 n5406 vdd vdd) p12 w=2.4u l=0.13u
MN5420 (n5418 n5388 n5419 vss) n12 w=1.6u l=0.13u
MN5421 (n5419 n5412 vss vss) n12 w=1.6u l=0.13u
MP5422 (n5418 n5388 vdd vdd) p12 w=2.4u l=0.13u
MP5423 (n5418 n5412 vdd vdd) p12 w=2.4u l=0.13u
MN5426 (n5424 n5388 n5425 vss) n12 w=1.6u l=0.13u
MN5427 (n5425 n5418 vss vss) n12 w=1.6u l=0.13u
MP5428 (n5424 n5388 vdd vdd) p12 w=2.4u l=0.13u
MP5429 (n5424 n5418 vdd vdd) p12 w=2.4u l=0.13u
MN5432 (n5430 n5412 n5431 vss) n12 w=1.6u l=0.13u
MN5433 (n5431 n5418 vss vss) n12 w=1.6u l=0.13u
MP5434 (n5430 n5412 vdd vdd) p12 w=2.4u l=0.13u
MP5435 (n5430 n5418 vdd vdd) p12 w=2.4u l=0.13u
MN5438 (n5436 n5424 n5437 vss) n12 w=1.6u l=0.13u
MN5439 (n5437 n5430 vss vss) n12 w=1.6u l=0.13u
MP5440 (n5436 n5424 vdd vdd) p12 w=2.4u l=0.13u
MP5441 (n5436 n5430 vdd vdd) p12 w=2.4u l=0.13u
MN5443 (n5442 n5394 vss vss) n12 w=0.8u l=0.13u
MP5444 (n5442 n5394 vdd vdd) p12 w=2.4u l=0.13u
MN5446 (n5445 n5418 vss vss) n12 w=0.8u l=0.13u
MP5447 (n5445 n5418 vdd vdd) p12 w=2.4u l=0.13u
MN5450 (n5448 n5442 vss vss) n12 w=0.8u l=0.13u
MN5451 (n5448 n5445 vss vss) n12 w=0.8u l=0.13u
MP5452 (n5448 n5442 n5449 vdd) p12 w=4.8u l=0.13u
MP5453 (n5449 n5445 vdd vdd) p12 w=4.8u l=0.13u
MN5455 (n5454 n5448 vss vss) n12 w=0.8u l=0.13u
MP5456 (n5454 n5448 vdd vdd) p12 w=2.4u l=0.13u
MN5458 (n5457 cl4 vss vss) n12 w=0.8u l=0.13u
MP5459 (n5457 cl4 vdd vdd) p12 w=2.4u l=0.13u
MN5462 (n5460 cd4 n5461 vss) n12 w=1.6u l=0.13u
MN5463 (n5461 n5457 vss vss) n12 w=1.6u l=0.13u
MP5464 (n5460 cd4 vdd vdd) p12 w=2.4u l=0.13u
MP5465 (n5460 n5457 vdd vdd) p12 w=2.4u l=0.13u
MN5468 (n5466 cd4 n5467 vss) n12 w=1.6u l=0.13u
MN5469 (n5467 n5460 vss vss) n12 w=1.6u l=0.13u
MP5470 (n5466 cd4 vdd vdd) p12 w=2.4u l=0.13u
MP5471 (n5466 n5460 vdd vdd) p12 w=2.4u l=0.13u
MN5474 (n5472 n5457 n5473 vss) n12 w=1.6u l=0.13u
MN5475 (n5473 n5460 vss vss) n12 w=1.6u l=0.13u
MP5476 (n5472 n5457 vdd vdd) p12 w=2.4u l=0.13u
MP5477 (n5472 n5460 vdd vdd) p12 w=2.4u l=0.13u
MN5480 (n5478 n5466 n5479 vss) n12 w=1.6u l=0.13u
MN5481 (n5479 n5472 vss vss) n12 w=1.6u l=0.13u
MP5482 (n5478 n5466 vdd vdd) p12 w=2.4u l=0.13u
MP5483 (n5478 n5472 vdd vdd) p12 w=2.4u l=0.13u
MN5486 (n5484 n5454 n5485 vss) n12 w=1.6u l=0.13u
MN5487 (n5485 n5478 vss vss) n12 w=1.6u l=0.13u
MP5488 (n5484 n5454 vdd vdd) p12 w=2.4u l=0.13u
MP5489 (n5484 n5478 vdd vdd) p12 w=2.4u l=0.13u
MN5492 (n5490 n5454 n5491 vss) n12 w=1.6u l=0.13u
MN5493 (n5491 n5484 vss vss) n12 w=1.6u l=0.13u
MP5494 (n5490 n5454 vdd vdd) p12 w=2.4u l=0.13u
MP5495 (n5490 n5484 vdd vdd) p12 w=2.4u l=0.13u
MN5498 (n5496 n5478 n5497 vss) n12 w=1.6u l=0.13u
MN5499 (n5497 n5484 vss vss) n12 w=1.6u l=0.13u
MP5500 (n5496 n5478 vdd vdd) p12 w=2.4u l=0.13u
MP5501 (n5496 n5484 vdd vdd) p12 w=2.4u l=0.13u
MN5504 (n5502 n5490 n5503 vss) n12 w=1.6u l=0.13u
MN5505 (n5503 n5496 vss vss) n12 w=1.6u l=0.13u
MP5506 (n5502 n5490 vdd vdd) p12 w=2.4u l=0.13u
MP5507 (n5502 n5496 vdd vdd) p12 w=2.4u l=0.13u
MN5509 (n5508 n5460 vss vss) n12 w=0.8u l=0.13u
MP5510 (n5508 n5460 vdd vdd) p12 w=2.4u l=0.13u
MN5512 (n5511 n5484 vss vss) n12 w=0.8u l=0.13u
MP5513 (n5511 n5484 vdd vdd) p12 w=2.4u l=0.13u
MN5516 (n5514 n5508 vss vss) n12 w=0.8u l=0.13u
MN5517 (n5514 n5511 vss vss) n12 w=0.8u l=0.13u
MP5518 (n5514 n5508 n5515 vdd) p12 w=4.8u l=0.13u
MP5519 (n5515 n5511 vdd vdd) p12 w=4.8u l=0.13u
MN5521 (n5520 n5514 vss vss) n12 w=0.8u l=0.13u
MP5522 (n5520 n5514 vdd vdd) p12 w=2.4u l=0.13u
MN5524 (n5523 cl5 vss vss) n12 w=0.8u l=0.13u
MP5525 (n5523 cl5 vdd vdd) p12 w=2.4u l=0.13u
MN5528 (n5526 cd5 n5527 vss) n12 w=1.6u l=0.13u
MN5529 (n5527 n5523 vss vss) n12 w=1.6u l=0.13u
MP5530 (n5526 cd5 vdd vdd) p12 w=2.4u l=0.13u
MP5531 (n5526 n5523 vdd vdd) p12 w=2.4u l=0.13u
MN5534 (n5532 cd5 n5533 vss) n12 w=1.6u l=0.13u
MN5535 (n5533 n5526 vss vss) n12 w=1.6u l=0.13u
MP5536 (n5532 cd5 vdd vdd) p12 w=2.4u l=0.13u
MP5537 (n5532 n5526 vdd vdd) p12 w=2.4u l=0.13u
MN5540 (n5538 n5523 n5539 vss) n12 w=1.6u l=0.13u
MN5541 (n5539 n5526 vss vss) n12 w=1.6u l=0.13u
MP5542 (n5538 n5523 vdd vdd) p12 w=2.4u l=0.13u
MP5543 (n5538 n5526 vdd vdd) p12 w=2.4u l=0.13u
MN5546 (n5544 n5532 n5545 vss) n12 w=1.6u l=0.13u
MN5547 (n5545 n5538 vss vss) n12 w=1.6u l=0.13u
MP5548 (n5544 n5532 vdd vdd) p12 w=2.4u l=0.13u
MP5549 (n5544 n5538 vdd vdd) p12 w=2.4u l=0.13u
MN5552 (n5550 n5520 n5551 vss) n12 w=1.6u l=0.13u
MN5553 (n5551 n5544 vss vss) n12 w=1.6u l=0.13u
MP5554 (n5550 n5520 vdd vdd) p12 w=2.4u l=0.13u
MP5555 (n5550 n5544 vdd vdd) p12 w=2.4u l=0.13u
MN5558 (n5556 n5520 n5557 vss) n12 w=1.6u l=0.13u
MN5559 (n5557 n5550 vss vss) n12 w=1.6u l=0.13u
MP5560 (n5556 n5520 vdd vdd) p12 w=2.4u l=0.13u
MP5561 (n5556 n5550 vdd vdd) p12 w=2.4u l=0.13u
MN5564 (n5562 n5544 n5563 vss) n12 w=1.6u l=0.13u
MN5565 (n5563 n5550 vss vss) n12 w=1.6u l=0.13u
MP5566 (n5562 n5544 vdd vdd) p12 w=2.4u l=0.13u
MP5567 (n5562 n5550 vdd vdd) p12 w=2.4u l=0.13u
MN5570 (n5568 n5556 n5569 vss) n12 w=1.6u l=0.13u
MN5571 (n5569 n5562 vss vss) n12 w=1.6u l=0.13u
MP5572 (n5568 n5556 vdd vdd) p12 w=2.4u l=0.13u
MP5573 (n5568 n5562 vdd vdd) p12 w=2.4u l=0.13u
MN5575 (n5574 n5526 vss vss) n12 w=0.8u l=0.13u
MP5576 (n5574 n5526 vdd vdd) p12 w=2.4u l=0.13u
MN5578 (n5577 n5550 vss vss) n12 w=0.8u l=0.13u
MP5579 (n5577 n5550 vdd vdd) p12 w=2.4u l=0.13u
MN5582 (n5580 n5574 vss vss) n12 w=0.8u l=0.13u
MN5583 (n5580 n5577 vss vss) n12 w=0.8u l=0.13u
MP5584 (n5580 n5574 n5581 vdd) p12 w=4.8u l=0.13u
MP5585 (n5581 n5577 vdd vdd) p12 w=4.8u l=0.13u
MN5587 (n5586 n5580 vss vss) n12 w=0.8u l=0.13u
MP5588 (n5586 n5580 vdd vdd) p12 w=2.4u l=0.13u
MN5590 (n5589 cl6 vss vss) n12 w=0.8u l=0.13u
MP5591 (n5589 cl6 vdd vdd) p12 w=2.4u l=0.13u
MN5594 (n5592 cd6 n5593 vss) n12 w=1.6u l=0.13u
MN5595 (n5593 n5589 vss vss) n12 w=1.6u l=0.13u
MP5596 (n5592 cd6 vdd vdd) p12 w=2.4u l=0.13u
MP5597 (n5592 n5589 vdd vdd) p12 w=2.4u l=0.13u
MN5600 (n5598 cd6 n5599 vss) n12 w=1.6u l=0.13u
MN5601 (n5599 n5592 vss vss) n12 w=1.6u l=0.13u
MP5602 (n5598 cd6 vdd vdd) p12 w=2.4u l=0.13u
MP5603 (n5598 n5592 vdd vdd) p12 w=2.4u l=0.13u
MN5606 (n5604 n5589 n5605 vss) n12 w=1.6u l=0.13u
MN5607 (n5605 n5592 vss vss) n12 w=1.6u l=0.13u
MP5608 (n5604 n5589 vdd vdd) p12 w=2.4u l=0.13u
MP5609 (n5604 n5592 vdd vdd) p12 w=2.4u l=0.13u
MN5612 (n5610 n5598 n5611 vss) n12 w=1.6u l=0.13u
MN5613 (n5611 n5604 vss vss) n12 w=1.6u l=0.13u
MP5614 (n5610 n5598 vdd vdd) p12 w=2.4u l=0.13u
MP5615 (n5610 n5604 vdd vdd) p12 w=2.4u l=0.13u
MN5618 (n5616 n5586 n5617 vss) n12 w=1.6u l=0.13u
MN5619 (n5617 n5610 vss vss) n12 w=1.6u l=0.13u
MP5620 (n5616 n5586 vdd vdd) p12 w=2.4u l=0.13u
MP5621 (n5616 n5610 vdd vdd) p12 w=2.4u l=0.13u
MN5624 (n5622 n5586 n5623 vss) n12 w=1.6u l=0.13u
MN5625 (n5623 n5616 vss vss) n12 w=1.6u l=0.13u
MP5626 (n5622 n5586 vdd vdd) p12 w=2.4u l=0.13u
MP5627 (n5622 n5616 vdd vdd) p12 w=2.4u l=0.13u
MN5630 (n5628 n5610 n5629 vss) n12 w=1.6u l=0.13u
MN5631 (n5629 n5616 vss vss) n12 w=1.6u l=0.13u
MP5632 (n5628 n5610 vdd vdd) p12 w=2.4u l=0.13u
MP5633 (n5628 n5616 vdd vdd) p12 w=2.4u l=0.13u
MN5636 (n5634 n5622 n5635 vss) n12 w=1.6u l=0.13u
MN5637 (n5635 n5628 vss vss) n12 w=1.6u l=0.13u
MP5638 (n5634 n5622 vdd vdd) p12 w=2.4u l=0.13u
MP5639 (n5634 n5628 vdd vdd) p12 w=2.4u l=0.13u
MN5641 (n5640 n5592 vss vss) n12 w=0.8u l=0.13u
MP5642 (n5640 n5592 vdd vdd) p12 w=2.4u l=0.13u
MN5644 (n5643 n5616 vss vss) n12 w=0.8u l=0.13u
MP5645 (n5643 n5616 vdd vdd) p12 w=2.4u l=0.13u
MN5648 (n5646 n5640 vss vss) n12 w=0.8u l=0.13u
MN5649 (n5646 n5643 vss vss) n12 w=0.8u l=0.13u
MP5650 (n5646 n5640 n5647 vdd) p12 w=4.8u l=0.13u
MP5651 (n5647 n5643 vdd vdd) p12 w=4.8u l=0.13u
MN5653 (n5652 n5646 vss vss) n12 w=0.8u l=0.13u
MP5654 (n5652 n5646 vdd vdd) p12 w=2.4u l=0.13u
MN5656 (n5655 cl7 vss vss) n12 w=0.8u l=0.13u
MP5657 (n5655 cl7 vdd vdd) p12 w=2.4u l=0.13u
MN5660 (n5658 cd7 n5659 vss) n12 w=1.6u l=0.13u
MN5661 (n5659 n5655 vss vss) n12 w=1.6u l=0.13u
MP5662 (n5658 cd7 vdd vdd) p12 w=2.4u l=0.13u
MP5663 (n5658 n5655 vdd vdd) p12 w=2.4u l=0.13u
MN5666 (n5664 cd7 n5665 vss) n12 w=1.6u l=0.13u
MN5667 (n5665 n5658 vss vss) n12 w=1.6u l=0.13u
MP5668 (n5664 cd7 vdd vdd) p12 w=2.4u l=0.13u
MP5669 (n5664 n5658 vdd vdd) p12 w=2.4u l=0.13u
MN5672 (n5670 n5655 n5671 vss) n12 w=1.6u l=0.13u
MN5673 (n5671 n5658 vss vss) n12 w=1.6u l=0.13u
MP5674 (n5670 n5655 vdd vdd) p12 w=2.4u l=0.13u
MP5675 (n5670 n5658 vdd vdd) p12 w=2.4u l=0.13u
MN5678 (n5676 n5664 n5677 vss) n12 w=1.6u l=0.13u
MN5679 (n5677 n5670 vss vss) n12 w=1.6u l=0.13u
MP5680 (n5676 n5664 vdd vdd) p12 w=2.4u l=0.13u
MP5681 (n5676 n5670 vdd vdd) p12 w=2.4u l=0.13u
MN5684 (n5682 n5652 n5683 vss) n12 w=1.6u l=0.13u
MN5685 (n5683 n5676 vss vss) n12 w=1.6u l=0.13u
MP5686 (n5682 n5652 vdd vdd) p12 w=2.4u l=0.13u
MP5687 (n5682 n5676 vdd vdd) p12 w=2.4u l=0.13u
MN5690 (n5688 n5652 n5689 vss) n12 w=1.6u l=0.13u
MN5691 (n5689 n5682 vss vss) n12 w=1.6u l=0.13u
MP5692 (n5688 n5652 vdd vdd) p12 w=2.4u l=0.13u
MP5693 (n5688 n5682 vdd vdd) p12 w=2.4u l=0.13u
MN5696 (n5694 n5676 n5695 vss) n12 w=1.6u l=0.13u
MN5697 (n5695 n5682 vss vss) n12 w=1.6u l=0.13u
MP5698 (n5694 n5676 vdd vdd) p12 w=2.4u l=0.13u
MP5699 (n5694 n5682 vdd vdd) p12 w=2.4u l=0.13u
MN5702 (n5700 n5688 n5701 vss) n12 w=1.6u l=0.13u
MN5703 (n5701 n5694 vss vss) n12 w=1.6u l=0.13u
MP5704 (n5700 n5688 vdd vdd) p12 w=2.4u l=0.13u
MP5705 (n5700 n5694 vdd vdd) p12 w=2.4u l=0.13u
MN5707 (n5706 n5658 vss vss) n12 w=0.8u l=0.13u
MP5708 (n5706 n5658 vdd vdd) p12 w=2.4u l=0.13u
MN5710 (n5709 n5682 vss vss) n12 w=0.8u l=0.13u
MP5711 (n5709 n5682 vdd vdd) p12 w=2.4u l=0.13u
MN5714 (n5712 n5706 vss vss) n12 w=0.8u l=0.13u
MN5715 (n5712 n5709 vss vss) n12 w=0.8u l=0.13u
MP5716 (n5712 n5706 n5713 vdd) p12 w=4.8u l=0.13u
MP5717 (n5713 n5709 vdd vdd) p12 w=4.8u l=0.13u
MN5719 (n5718 n5712 vss vss) n12 w=0.8u l=0.13u
MP5720 (n5718 n5712 vdd vdd) p12 w=2.4u l=0.13u
MN5723 (n5721 n5304 vss vss) n12 w=0.8u l=0.13u
MN5724 (n5721 n5370 vss vss) n12 w=0.8u l=0.13u
MP5725 (n5721 n5304 n5722 vdd) p12 w=4.8u l=0.13u
MP5726 (n5722 n5370 vdd vdd) p12 w=4.8u l=0.13u
MN5728 (n5727 n5721 vss vss) n12 w=0.8u l=0.13u
MP5729 (n5727 n5721 vdd vdd) p12 w=2.4u l=0.13u
MN5732 (n5730 n5436 vss vss) n12 w=0.8u l=0.13u
MN5733 (n5730 n5502 vss vss) n12 w=0.8u l=0.13u
MP5734 (n5730 n5436 n5731 vdd) p12 w=4.8u l=0.13u
MP5735 (n5731 n5502 vdd vdd) p12 w=4.8u l=0.13u
MN5737 (n5736 n5730 vss vss) n12 w=0.8u l=0.13u
MP5738 (n5736 n5730 vdd vdd) p12 w=2.4u l=0.13u
MN5741 (n5739 n5568 vss vss) n12 w=0.8u l=0.13u
MN5742 (n5739 n5634 vss vss) n12 w=0.8u l=0.13u
MP5743 (n5739 n5568 n5740 vdd) p12 w=4.8u l=0.13u
MP5744 (n5740 n5634 vdd vdd) p12 w=4.8u l=0.13u
MN5746 (n5745 n5739 vss vss) n12 w=0.8u l=0.13u
MP5747 (n5745 n5739 vdd vdd) p12 w=2.4u l=0.13u
MN5750 (n5748 n5727 vss vss) n12 w=0.8u l=0.13u
MN5751 (n5748 n5736 vss vss) n12 w=0.8u l=0.13u
MP5752 (n5748 n5727 n5749 vdd) p12 w=4.8u l=0.13u
MP5753 (n5749 n5736 vdd vdd) p12 w=4.8u l=0.13u
MN5755 (n5754 n5748 vss vss) n12 w=0.8u l=0.13u
MP5756 (n5754 n5748 vdd vdd) p12 w=2.4u l=0.13u
MN5759 (n5757 n5700 vss vss) n12 w=0.8u l=0.13u
MN5760 (n5757 n5745 vss vss) n12 w=0.8u l=0.13u
MP5761 (n5757 n5700 n5758 vdd) p12 w=4.8u l=0.13u
MP5762 (n5758 n5745 vdd vdd) p12 w=4.8u l=0.13u
MN5764 (n5763 n5757 vss vss) n12 w=0.8u l=0.13u
MP5765 (n5763 n5757 vdd vdd) p12 w=2.4u l=0.13u
MN5768 (n5766 n5754 vss vss) n12 w=0.8u l=0.13u
MN5769 (n5766 n5763 vss vss) n12 w=0.8u l=0.13u
MP5770 (n5766 n5754 n5767 vdd) p12 w=4.8u l=0.13u
MP5771 (n5767 n5763 vdd vdd) p12 w=4.8u l=0.13u
MN5773 (n5772 n5766 vss vss) n12 w=0.8u l=0.13u
MP5774 (n5772 n5766 vdd vdd) p12 w=2.4u l=0.13u
MN5777 (n5775 n5718 n5776 vss) n12 w=1.6u l=0.13u
MN5778 (n5776 n5772 vss vss) n12 w=1.6u l=0.13u
MP5779 (n5775 n5718 vdd vdd) p12 w=2.4u l=0.13u
MP5780 (n5775 n5772 vdd vdd) p12 w=2.4u l=0.13u
MN5782 (n5781 n5775 vss vss) n12 w=0.8u l=0.13u
MP5783 (n5781 n5775 vdd vdd) p12 w=2.4u l=0.13u
MN5785 (n5784 n5214 vss vss) n12 w=0.8u l=0.13u
MP5786 (n5784 n5214 vdd vdd) p12 w=2.4u l=0.13u
MN5788 (n5787 n5784 vss vss) n12 w=0.8u l=0.13u
MP5789 (n5787 n5784 vdd vdd) p12 w=2.4u l=0.13u
MN5791 (n5790 n5787 vss vss) n12 w=0.8u l=0.13u
MP5792 (n5790 n5787 vdd vdd) p12 w=2.4u l=0.13u
MN5793 (slow_raw n5790 vss vss) n12 w=0.8u l=0.13u
MP5794 (slow_raw n5790 vdd vdd) p12 w=2.4u l=0.13u
MN5796 (n5795 n5781 vss vss) n12 w=0.8u l=0.13u
MP5797 (n5795 n5781 vdd vdd) p12 w=2.4u l=0.13u
MN5799 (n5798 n5795 vss vss) n12 w=0.8u l=0.13u
MP5800 (n5798 n5795 vdd vdd) p12 w=2.4u l=0.13u
MN5802 (n5801 n5798 vss vss) n12 w=0.8u l=0.13u
MP5803 (n5801 n5798 vdd vdd) p12 w=2.4u l=0.13u
MN5804 (fast_raw n5801 vss vss) n12 w=0.8u l=0.13u
MP5805 (fast_raw n5801 vdd vdd) p12 w=2.4u l=0.13u
MN5807 (n5806 measure vss vss) n12 w=0.8u l=0.13u
MP5808 (n5806 measure vdd vdd) p12 w=2.4u l=0.13u
MN5811 (n5809 n5806 vss vss) n12 w=0.8u l=0.13u
MN5812 (n5809 rst vss vss) n12 w=0.8u l=0.13u
MP5813 (n5809 n5806 n5810 vdd) p12 w=4.8u l=0.13u
MP5814 (n5810 rst vdd vdd) p12 w=4.8u l=0.13u
MN5816 (n5815 n5809 vss vss) n12 w=0.8u l=0.13u
MP5817 (n5815 n5809 vdd vdd) p12 w=2.4u l=0.13u
MN5819 (n5818 n5815 vss vss) n12 w=0.8u l=0.13u
MP5820 (n5818 n5815 vdd vdd) p12 w=2.4u l=0.13u
MN5823 (n5821 n22 n5822 vss) n12 w=1.6u l=0.13u
MN5824 (n5822 n5818 vss vss) n12 w=1.6u l=0.13u
MP5825 (n5821 n22 vdd vdd) p12 w=2.4u l=0.13u
MP5826 (n5821 n5818 vdd vdd) p12 w=2.4u l=0.13u
MN5828 (n5827 n5821 vss vss) n12 w=0.8u l=0.13u
MP5829 (n5827 n5821 vdd vdd) p12 w=2.4u l=0.13u
MN5832 (n5830 n19 n5831 vss) n12 w=1.6u l=0.13u
MN5833 (n5831 n5818 vss vss) n12 w=1.6u l=0.13u
MP5834 (n5830 n19 vdd vdd) p12 w=2.4u l=0.13u
MP5835 (n5830 n5818 vdd vdd) p12 w=2.4u l=0.13u
MN5837 (n5836 n5830 vss vss) n12 w=0.8u l=0.13u
MP5838 (n5836 n5830 vdd vdd) p12 w=2.4u l=0.13u
MN5840 (n5839 n5827 vss vss) n12 w=0.8u l=0.13u
MP5841 (n5839 n5827 vdd vdd) p12 w=2.4u l=0.13u
MN5843 (n5842 n5836 vss vss) n12 w=0.8u l=0.13u
MP5844 (n5842 n5836 vdd vdd) p12 w=2.4u l=0.13u
MN5849 (n5214 n5827 storage5848 vss) n12 w=1.2u l=0.13u
MP5850 (n5214 n5839 storage5848 vdd) p12 w=3.6u l=0.13u
MN5851 (qm5845 n5836 storage5848 vss) n12 w=1.2u l=0.13u
MP5852 (qm5845 n5842 storage5848 vdd) p12 w=3.6u l=0.13u
MN5853 (qmb5846 storage5848 vss vss) n12 w=0.5u l=0.13u
MP5854 (qmb5846 storage5848 vdd vdd) p12 w=1.5u l=0.13u
MN5855 (qm5845 qmb5846 vss vss) n12 w=0.5u l=0.13u
MP5856 (qm5845 qmb5846 vdd vdd) p12 w=1.5u l=0.13u
MN5857 (storage5848 n5815 vss vss) n12 w=2u l=0.13u
MN5859 (qm5845 n5836 storage5858 vss) n12 w=1.2u l=0.13u
MP5860 (qm5845 n5842 storage5858 vdd) p12 w=3.6u l=0.13u
MN5861 (slow_prev n5827 storage5858 vss) n12 w=1.2u l=0.13u
MP5862 (slow_prev n5839 storage5858 vdd) p12 w=3.6u l=0.13u
MN5863 (qb5847 storage5858 vss vss) n12 w=0.5u l=0.13u
MP5864 (qb5847 storage5858 vdd vdd) p12 w=1.5u l=0.13u
MN5865 (slow_prev qb5847 vss vss) n12 w=0.5u l=0.13u
MP5866 (slow_prev qb5847 vdd vdd) p12 w=1.5u l=0.13u
MN5867 (storage5858 n5815 vss vss) n12 w=2u l=0.13u
MN5872 (n5781 n5827 storage5871 vss) n12 w=1.2u l=0.13u
MP5873 (n5781 n5839 storage5871 vdd) p12 w=3.6u l=0.13u
MN5874 (qm5868 n5836 storage5871 vss) n12 w=1.2u l=0.13u
MP5875 (qm5868 n5842 storage5871 vdd) p12 w=3.6u l=0.13u
MN5876 (qmb5869 storage5871 vss vss) n12 w=0.5u l=0.13u
MP5877 (qmb5869 storage5871 vdd vdd) p12 w=1.5u l=0.13u
MN5878 (qm5868 qmb5869 vss vss) n12 w=0.5u l=0.13u
MP5879 (qm5868 qmb5869 vdd vdd) p12 w=1.5u l=0.13u
MN5880 (storage5871 n5815 vss vss) n12 w=2u l=0.13u
MN5882 (qm5868 n5836 storage5881 vss) n12 w=1.2u l=0.13u
MP5883 (qm5868 n5842 storage5881 vdd) p12 w=3.6u l=0.13u
MN5884 (fast_prev n5827 storage5881 vss) n12 w=1.2u l=0.13u
MP5885 (fast_prev n5839 storage5881 vdd) p12 w=3.6u l=0.13u
MN5886 (qb5870 storage5881 vss vss) n12 w=0.5u l=0.13u
MP5887 (qb5870 storage5881 vdd vdd) p12 w=1.5u l=0.13u
MN5888 (fast_prev qb5870 vss vss) n12 w=0.5u l=0.13u
MP5889 (fast_prev qb5870 vdd vdd) p12 w=1.5u l=0.13u
MN5890 (storage5881 n5815 vss vss) n12 w=2u l=0.13u
MN5893 (n5891 n5214 n5892 vss) n12 w=1.6u l=0.13u
MN5894 (n5892 slow_prev vss vss) n12 w=1.6u l=0.13u
MP5895 (n5891 n5214 vdd vdd) p12 w=2.4u l=0.13u
MP5896 (n5891 slow_prev vdd vdd) p12 w=2.4u l=0.13u
MN5898 (n5897 n5891 vss vss) n12 w=0.8u l=0.13u
MP5899 (n5897 n5891 vdd vdd) p12 w=2.4u l=0.13u
MN5902 (n5900 fast_prev n5901 vss) n12 w=1.6u l=0.13u
MN5903 (n5901 n5781 vss vss) n12 w=1.6u l=0.13u
MP5904 (n5900 fast_prev vdd vdd) p12 w=2.4u l=0.13u
MP5905 (n5900 n5781 vdd vdd) p12 w=2.4u l=0.13u
MN5907 (n5906 n5900 vss vss) n12 w=0.8u l=0.13u
MP5908 (n5906 n5900 vdd vdd) p12 w=2.4u l=0.13u
MN5910 (n5909 n5897 vss vss) n12 w=0.8u l=0.13u
MP5911 (n5909 n5897 vdd vdd) p12 w=2.4u l=0.13u
MN5913 (n5912 n5909 vss vss) n12 w=0.8u l=0.13u
MP5914 (n5912 n5909 vdd vdd) p12 w=2.4u l=0.13u
MN5916 (n5915 n5912 vss vss) n12 w=0.8u l=0.13u
MP5917 (n5915 n5912 vdd vdd) p12 w=2.4u l=0.13u
MN5918 (slow_qualified n5915 vss vss) n12 w=0.8u l=0.13u
MP5919 (slow_qualified n5915 vdd vdd) p12 w=2.4u l=0.13u
MN5921 (n5920 n5906 vss vss) n12 w=0.8u l=0.13u
MP5922 (n5920 n5906 vdd vdd) p12 w=2.4u l=0.13u
MN5924 (n5923 n5920 vss vss) n12 w=0.8u l=0.13u
MP5925 (n5923 n5920 vdd vdd) p12 w=2.4u l=0.13u
MN5927 (n5926 n5923 vss vss) n12 w=0.8u l=0.13u
MP5928 (n5926 n5923 vdd vdd) p12 w=2.4u l=0.13u
MN5929 (fast_qualified n5926 vss vss) n12 w=0.8u l=0.13u
MP5930 (fast_qualified n5926 vdd vdd) p12 w=2.4u l=0.13u
MN5933 (n5931 n5897 n5932 vss) n12 w=1.6u l=0.13u
MN5934 (n5932 n5906 vss vss) n12 w=1.6u l=0.13u
MP5935 (n5931 n5897 vdd vdd) p12 w=2.4u l=0.13u
MP5936 (n5931 n5906 vdd vdd) p12 w=2.4u l=0.13u
MN5938 (n5937 n5931 vss vss) n12 w=0.8u l=0.13u
MP5939 (n5937 n5931 vdd vdd) p12 w=2.4u l=0.13u
MN5942 (n5940 n5897 vss vss) n12 w=0.8u l=0.13u
MN5943 (n5940 n5906 vss vss) n12 w=0.8u l=0.13u
MP5944 (n5940 n5897 n5941 vdd) p12 w=4.8u l=0.13u
MP5945 (n5941 n5906 vdd vdd) p12 w=4.8u l=0.13u
MN5947 (n5946 n5940 vss vss) n12 w=0.8u l=0.13u
MP5948 (n5946 n5940 vdd vdd) p12 w=2.4u l=0.13u
MN5951 (n5949 cg7 vss vss) n12 w=0.8u l=0.13u
MN5952 (n5949 n5946 vss vss) n12 w=0.8u l=0.13u
MP5953 (n5949 cg7 n5950 vdd) p12 w=4.8u l=0.13u
MP5954 (n5950 n5946 vdd vdd) p12 w=4.8u l=0.13u
MN5956 (n5955 n5949 vss vss) n12 w=0.8u l=0.13u
MP5957 (n5955 n5949 vdd vdd) p12 w=2.4u l=0.13u
MN5960 (n5958 measure n5959 vss) n12 w=1.6u l=0.13u
MN5961 (n5959 n5955 vss vss) n12 w=1.6u l=0.13u
MP5962 (n5958 measure vdd vdd) p12 w=2.4u l=0.13u
MP5963 (n5958 n5955 vdd vdd) p12 w=2.4u l=0.13u
MN5965 (n5964 n5958 vss vss) n12 w=0.8u l=0.13u
MP5966 (n5964 n5958 vdd vdd) p12 w=2.4u l=0.13u
MN5968 (n5967 n5964 vss vss) n12 w=0.8u l=0.13u
MP5969 (n5967 n5964 vdd vdd) p12 w=2.4u l=0.13u
MN5971 (n5970 n5967 vss vss) n12 w=0.8u l=0.13u
MP5972 (n5970 n5967 vdd vdd) p12 w=2.4u l=0.13u
MN5974 (n5973 n5970 vss vss) n12 w=0.8u l=0.13u
MP5975 (n5973 n5970 vdd vdd) p12 w=2.4u l=0.13u
MN5976 (decision n5973 vss vss) n12 w=0.8u l=0.13u
MP5977 (decision n5973 vdd vdd) p12 w=2.4u l=0.13u
MN5980 (n5978 n5906 n5979 vss) n12 w=1.6u l=0.13u
MN5981 (n5979 n5964 vss vss) n12 w=1.6u l=0.13u
MP5982 (n5978 n5906 vdd vdd) p12 w=2.4u l=0.13u
MP5983 (n5978 n5964 vdd vdd) p12 w=2.4u l=0.13u
MN5986 (n5984 n5967 n5985 vss) n12 w=1.6u l=0.13u
MN5987 (n5985 was_fast vss vss) n12 w=1.6u l=0.13u
MP5988 (n5984 n5967 vdd vdd) p12 w=2.4u l=0.13u
MP5989 (n5984 was_fast vdd vdd) p12 w=2.4u l=0.13u
MN5992 (n5990 n5978 n5991 vss) n12 w=1.6u l=0.13u
MN5993 (n5991 n5984 vss vss) n12 w=1.6u l=0.13u
MP5994 (n5990 n5978 vdd vdd) p12 w=2.4u l=0.13u
MP5995 (n5990 n5984 vdd vdd) p12 w=2.4u l=0.13u
MN6000 (n5990 n93 storage5999 vss) n12 w=1.2u l=0.13u
MP6001 (n5990 n105 storage5999 vdd) p12 w=3.6u l=0.13u
MN6002 (qm5996 n102 storage5999 vss) n12 w=1.2u l=0.13u
MP6003 (qm5996 n108 storage5999 vdd) p12 w=3.6u l=0.13u
MN6004 (qmb5997 storage5999 vss vss) n12 w=0.5u l=0.13u
MP6005 (qmb5997 storage5999 vdd vdd) p12 w=1.5u l=0.13u
MN6006 (qm5996 qmb5997 vss vss) n12 w=0.5u l=0.13u
MP6007 (qm5996 qmb5997 vdd vdd) p12 w=1.5u l=0.13u
MN6008 (storage5999 rst vss vss) n12 w=2u l=0.13u
MN6010 (qm5996 n102 storage6009 vss) n12 w=1.2u l=0.13u
MP6011 (qm5996 n108 storage6009 vdd) p12 w=3.6u l=0.13u
MN6012 (was_fast n93 storage6009 vss) n12 w=1.2u l=0.13u
MP6013 (was_fast n105 storage6009 vdd) p12 w=3.6u l=0.13u
MN6014 (qb5998 storage6009 vss vss) n12 w=0.5u l=0.13u
MP6015 (qb5998 storage6009 vdd vdd) p12 w=1.5u l=0.13u
MN6016 (was_fast qb5998 vss vss) n12 w=0.5u l=0.13u
MP6017 (was_fast qb5998 vdd vdd) p12 w=1.5u l=0.13u
MN6018 (storage6009 rst vss vss) n12 w=2u l=0.13u
MN6021 (n6019 n5897 n6020 vss) n12 w=1.6u l=0.13u
MN6022 (n6020 n5964 vss vss) n12 w=1.6u l=0.13u
MP6023 (n6019 n5897 vdd vdd) p12 w=2.4u l=0.13u
MP6024 (n6019 n5964 vdd vdd) p12 w=2.4u l=0.13u
MN6027 (n6025 n5967 n6026 vss) n12 w=1.6u l=0.13u
MN6028 (n6026 was_slow vss vss) n12 w=1.6u l=0.13u
MP6029 (n6025 n5967 vdd vdd) p12 w=2.4u l=0.13u
MP6030 (n6025 was_slow vdd vdd) p12 w=2.4u l=0.13u
MN6033 (n6031 n6019 n6032 vss) n12 w=1.6u l=0.13u
MN6034 (n6032 n6025 vss vss) n12 w=1.6u l=0.13u
MP6035 (n6031 n6019 vdd vdd) p12 w=2.4u l=0.13u
MP6036 (n6031 n6025 vdd vdd) p12 w=2.4u l=0.13u
MN6041 (n6031 n93 storage6040 vss) n12 w=1.2u l=0.13u
MP6042 (n6031 n105 storage6040 vdd) p12 w=3.6u l=0.13u
MN6043 (qm6037 n102 storage6040 vss) n12 w=1.2u l=0.13u
MP6044 (qm6037 n108 storage6040 vdd) p12 w=3.6u l=0.13u
MN6045 (qmb6038 storage6040 vss vss) n12 w=0.5u l=0.13u
MP6046 (qmb6038 storage6040 vdd vdd) p12 w=1.5u l=0.13u
MN6047 (qm6037 qmb6038 vss vss) n12 w=0.5u l=0.13u
MP6048 (qm6037 qmb6038 vdd vdd) p12 w=1.5u l=0.13u
MN6049 (storage6040 rst vss vss) n12 w=2u l=0.13u
MN6051 (qm6037 n102 storage6050 vss) n12 w=1.2u l=0.13u
MP6052 (qm6037 n108 storage6050 vdd) p12 w=3.6u l=0.13u
MN6053 (was_slow n93 storage6050 vss) n12 w=1.2u l=0.13u
MP6054 (was_slow n105 storage6050 vdd) p12 w=3.6u l=0.13u
MN6055 (qb6039 storage6050 vss vss) n12 w=0.5u l=0.13u
MP6056 (qb6039 storage6050 vdd vdd) p12 w=1.5u l=0.13u
MN6057 (was_slow qb6039 vss vss) n12 w=0.5u l=0.13u
MP6058 (was_slow qb6039 vdd vdd) p12 w=1.5u l=0.13u
MN6059 (storage6050 rst vss vss) n12 w=2u l=0.13u
MN6061 (n6060 n5946 vss vss) n12 w=0.8u l=0.13u
MP6062 (n6060 n5946 vdd vdd) p12 w=2.4u l=0.13u
MN6065 (n6063 cg7 n6064 vss) n12 w=1.6u l=0.13u
MN6066 (n6064 n6060 vss vss) n12 w=1.6u l=0.13u
MP6067 (n6063 cg7 vdd vdd) p12 w=2.4u l=0.13u
MP6068 (n6063 n6060 vdd vdd) p12 w=2.4u l=0.13u
MN6070 (n6069 n6063 vss vss) n12 w=0.8u l=0.13u
MP6071 (n6069 n6063 vdd vdd) p12 w=2.4u l=0.13u
MN6074 (n6072 n5964 n6073 vss) n12 w=1.6u l=0.13u
MN6075 (n6073 n6069 vss vss) n12 w=1.6u l=0.13u
MP6076 (n6072 n5964 vdd vdd) p12 w=2.4u l=0.13u
MP6077 (n6072 n6069 vdd vdd) p12 w=2.4u l=0.13u
MN6080 (n6078 n5967 n6079 vss) n12 w=1.6u l=0.13u
MN6081 (n6079 was_near vss vss) n12 w=1.6u l=0.13u
MP6082 (n6078 n5967 vdd vdd) p12 w=2.4u l=0.13u
MP6083 (n6078 was_near vdd vdd) p12 w=2.4u l=0.13u
MN6086 (n6084 n6072 n6085 vss) n12 w=1.6u l=0.13u
MN6087 (n6085 n6078 vss vss) n12 w=1.6u l=0.13u
MP6088 (n6084 n6072 vdd vdd) p12 w=2.4u l=0.13u
MP6089 (n6084 n6078 vdd vdd) p12 w=2.4u l=0.13u
MN6094 (n6084 n93 storage6093 vss) n12 w=1.2u l=0.13u
MP6095 (n6084 n105 storage6093 vdd) p12 w=3.6u l=0.13u
MN6096 (qm6090 n102 storage6093 vss) n12 w=1.2u l=0.13u
MP6097 (qm6090 n108 storage6093 vdd) p12 w=3.6u l=0.13u
MN6098 (qmb6091 storage6093 vss vss) n12 w=0.5u l=0.13u
MP6099 (qmb6091 storage6093 vdd vdd) p12 w=1.5u l=0.13u
MN6100 (qm6090 qmb6091 vss vss) n12 w=0.5u l=0.13u
MP6101 (qm6090 qmb6091 vdd vdd) p12 w=1.5u l=0.13u
MN6102 (storage6093 rst vss vss) n12 w=2u l=0.13u
MN6104 (qm6090 n102 storage6103 vss) n12 w=1.2u l=0.13u
MP6105 (qm6090 n108 storage6103 vdd) p12 w=3.6u l=0.13u
MN6106 (was_near n93 storage6103 vss) n12 w=1.2u l=0.13u
MP6107 (was_near n105 storage6103 vdd) p12 w=3.6u l=0.13u
MN6108 (qb6092 storage6103 vss vss) n12 w=0.5u l=0.13u
MP6109 (qb6092 storage6103 vdd vdd) p12 w=1.5u l=0.13u
MN6110 (was_near qb6092 vss vss) n12 w=0.5u l=0.13u
MP6111 (was_near qb6092 vdd vdd) p12 w=1.5u l=0.13u
MN6112 (storage6103 rst vss vss) n12 w=2u l=0.13u
MN6115 (n6113 cl0 n6114 vss) n12 w=1.6u l=0.13u
MN6116 (n6114 n5964 vss vss) n12 w=1.6u l=0.13u
MP6117 (n6113 cl0 vdd vdd) p12 w=2.4u l=0.13u
MP6118 (n6113 n5964 vdd vdd) p12 w=2.4u l=0.13u
MN6121 (n6119 dl0 n6120 vss) n12 w=1.6u l=0.13u
MN6122 (n6120 n5967 vss vss) n12 w=1.6u l=0.13u
MP6123 (n6119 dl0 vdd vdd) p12 w=2.4u l=0.13u
MP6124 (n6119 n5967 vdd vdd) p12 w=2.4u l=0.13u
MN6127 (n6125 n6113 n6126 vss) n12 w=1.6u l=0.13u
MN6128 (n6126 n6119 vss vss) n12 w=1.6u l=0.13u
MP6129 (n6125 n6113 vdd vdd) p12 w=2.4u l=0.13u
MP6130 (n6125 n6119 vdd vdd) p12 w=2.4u l=0.13u
MN6135 (n6125 n93 storage6134 vss) n12 w=1.2u l=0.13u
MP6136 (n6125 n105 storage6134 vdd) p12 w=3.6u l=0.13u
MN6137 (qm6131 n102 storage6134 vss) n12 w=1.2u l=0.13u
MP6138 (qm6131 n108 storage6134 vdd) p12 w=3.6u l=0.13u
MN6139 (qmb6132 storage6134 vss vss) n12 w=0.5u l=0.13u
MP6140 (qmb6132 storage6134 vdd vdd) p12 w=1.5u l=0.13u
MN6141 (qm6131 qmb6132 vss vss) n12 w=0.5u l=0.13u
MP6142 (qm6131 qmb6132 vdd vdd) p12 w=1.5u l=0.13u
MN6143 (storage6134 rst vss vss) n12 w=2u l=0.13u
MN6145 (qm6131 n102 storage6144 vss) n12 w=1.2u l=0.13u
MP6146 (qm6131 n108 storage6144 vdd) p12 w=3.6u l=0.13u
MN6147 (dl0 n93 storage6144 vss) n12 w=1.2u l=0.13u
MP6148 (dl0 n105 storage6144 vdd) p12 w=3.6u l=0.13u
MN6149 (qb6133 storage6144 vss vss) n12 w=0.5u l=0.13u
MP6150 (qb6133 storage6144 vdd vdd) p12 w=1.5u l=0.13u
MN6151 (dl0 qb6133 vss vss) n12 w=0.5u l=0.13u
MP6152 (dl0 qb6133 vdd vdd) p12 w=1.5u l=0.13u
MN6153 (storage6144 rst vss vss) n12 w=2u l=0.13u
MN6156 (n6154 cl1 n6155 vss) n12 w=1.6u l=0.13u
MN6157 (n6155 n5964 vss vss) n12 w=1.6u l=0.13u
MP6158 (n6154 cl1 vdd vdd) p12 w=2.4u l=0.13u
MP6159 (n6154 n5964 vdd vdd) p12 w=2.4u l=0.13u
MN6162 (n6160 dl1 n6161 vss) n12 w=1.6u l=0.13u
MN6163 (n6161 n5967 vss vss) n12 w=1.6u l=0.13u
MP6164 (n6160 dl1 vdd vdd) p12 w=2.4u l=0.13u
MP6165 (n6160 n5967 vdd vdd) p12 w=2.4u l=0.13u
MN6168 (n6166 n6154 n6167 vss) n12 w=1.6u l=0.13u
MN6169 (n6167 n6160 vss vss) n12 w=1.6u l=0.13u
MP6170 (n6166 n6154 vdd vdd) p12 w=2.4u l=0.13u
MP6171 (n6166 n6160 vdd vdd) p12 w=2.4u l=0.13u
MN6176 (n6166 n93 storage6175 vss) n12 w=1.2u l=0.13u
MP6177 (n6166 n105 storage6175 vdd) p12 w=3.6u l=0.13u
MN6178 (qm6172 n102 storage6175 vss) n12 w=1.2u l=0.13u
MP6179 (qm6172 n108 storage6175 vdd) p12 w=3.6u l=0.13u
MN6180 (qmb6173 storage6175 vss vss) n12 w=0.5u l=0.13u
MP6181 (qmb6173 storage6175 vdd vdd) p12 w=1.5u l=0.13u
MN6182 (qm6172 qmb6173 vss vss) n12 w=0.5u l=0.13u
MP6183 (qm6172 qmb6173 vdd vdd) p12 w=1.5u l=0.13u
MN6184 (storage6175 rst vss vss) n12 w=2u l=0.13u
MN6186 (qm6172 n102 storage6185 vss) n12 w=1.2u l=0.13u
MP6187 (qm6172 n108 storage6185 vdd) p12 w=3.6u l=0.13u
MN6188 (dl1 n93 storage6185 vss) n12 w=1.2u l=0.13u
MP6189 (dl1 n105 storage6185 vdd) p12 w=3.6u l=0.13u
MN6190 (qb6174 storage6185 vss vss) n12 w=0.5u l=0.13u
MP6191 (qb6174 storage6185 vdd vdd) p12 w=1.5u l=0.13u
MN6192 (dl1 qb6174 vss vss) n12 w=0.5u l=0.13u
MP6193 (dl1 qb6174 vdd vdd) p12 w=1.5u l=0.13u
MN6194 (storage6185 rst vss vss) n12 w=2u l=0.13u
MN6197 (n6195 cl2 n6196 vss) n12 w=1.6u l=0.13u
MN6198 (n6196 n5964 vss vss) n12 w=1.6u l=0.13u
MP6199 (n6195 cl2 vdd vdd) p12 w=2.4u l=0.13u
MP6200 (n6195 n5964 vdd vdd) p12 w=2.4u l=0.13u
MN6203 (n6201 dl2 n6202 vss) n12 w=1.6u l=0.13u
MN6204 (n6202 n5967 vss vss) n12 w=1.6u l=0.13u
MP6205 (n6201 dl2 vdd vdd) p12 w=2.4u l=0.13u
MP6206 (n6201 n5967 vdd vdd) p12 w=2.4u l=0.13u
MN6209 (n6207 n6195 n6208 vss) n12 w=1.6u l=0.13u
MN6210 (n6208 n6201 vss vss) n12 w=1.6u l=0.13u
MP6211 (n6207 n6195 vdd vdd) p12 w=2.4u l=0.13u
MP6212 (n6207 n6201 vdd vdd) p12 w=2.4u l=0.13u
MN6217 (n6207 n93 storage6216 vss) n12 w=1.2u l=0.13u
MP6218 (n6207 n105 storage6216 vdd) p12 w=3.6u l=0.13u
MN6219 (qm6213 n102 storage6216 vss) n12 w=1.2u l=0.13u
MP6220 (qm6213 n108 storage6216 vdd) p12 w=3.6u l=0.13u
MN6221 (qmb6214 storage6216 vss vss) n12 w=0.5u l=0.13u
MP6222 (qmb6214 storage6216 vdd vdd) p12 w=1.5u l=0.13u
MN6223 (qm6213 qmb6214 vss vss) n12 w=0.5u l=0.13u
MP6224 (qm6213 qmb6214 vdd vdd) p12 w=1.5u l=0.13u
MN6225 (storage6216 rst vss vss) n12 w=2u l=0.13u
MN6227 (qm6213 n102 storage6226 vss) n12 w=1.2u l=0.13u
MP6228 (qm6213 n108 storage6226 vdd) p12 w=3.6u l=0.13u
MN6229 (dl2 n93 storage6226 vss) n12 w=1.2u l=0.13u
MP6230 (dl2 n105 storage6226 vdd) p12 w=3.6u l=0.13u
MN6231 (qb6215 storage6226 vss vss) n12 w=0.5u l=0.13u
MP6232 (qb6215 storage6226 vdd vdd) p12 w=1.5u l=0.13u
MN6233 (dl2 qb6215 vss vss) n12 w=0.5u l=0.13u
MP6234 (dl2 qb6215 vdd vdd) p12 w=1.5u l=0.13u
MN6235 (storage6226 rst vss vss) n12 w=2u l=0.13u
MN6238 (n6236 cl3 n6237 vss) n12 w=1.6u l=0.13u
MN6239 (n6237 n5964 vss vss) n12 w=1.6u l=0.13u
MP6240 (n6236 cl3 vdd vdd) p12 w=2.4u l=0.13u
MP6241 (n6236 n5964 vdd vdd) p12 w=2.4u l=0.13u
MN6244 (n6242 dl3 n6243 vss) n12 w=1.6u l=0.13u
MN6245 (n6243 n5967 vss vss) n12 w=1.6u l=0.13u
MP6246 (n6242 dl3 vdd vdd) p12 w=2.4u l=0.13u
MP6247 (n6242 n5967 vdd vdd) p12 w=2.4u l=0.13u
MN6250 (n6248 n6236 n6249 vss) n12 w=1.6u l=0.13u
MN6251 (n6249 n6242 vss vss) n12 w=1.6u l=0.13u
MP6252 (n6248 n6236 vdd vdd) p12 w=2.4u l=0.13u
MP6253 (n6248 n6242 vdd vdd) p12 w=2.4u l=0.13u
MN6258 (n6248 n93 storage6257 vss) n12 w=1.2u l=0.13u
MP6259 (n6248 n105 storage6257 vdd) p12 w=3.6u l=0.13u
MN6260 (qm6254 n102 storage6257 vss) n12 w=1.2u l=0.13u
MP6261 (qm6254 n108 storage6257 vdd) p12 w=3.6u l=0.13u
MN6262 (qmb6255 storage6257 vss vss) n12 w=0.5u l=0.13u
MP6263 (qmb6255 storage6257 vdd vdd) p12 w=1.5u l=0.13u
MN6264 (qm6254 qmb6255 vss vss) n12 w=0.5u l=0.13u
MP6265 (qm6254 qmb6255 vdd vdd) p12 w=1.5u l=0.13u
MN6266 (storage6257 rst vss vss) n12 w=2u l=0.13u
MN6268 (qm6254 n102 storage6267 vss) n12 w=1.2u l=0.13u
MP6269 (qm6254 n108 storage6267 vdd) p12 w=3.6u l=0.13u
MN6270 (dl3 n93 storage6267 vss) n12 w=1.2u l=0.13u
MP6271 (dl3 n105 storage6267 vdd) p12 w=3.6u l=0.13u
MN6272 (qb6256 storage6267 vss vss) n12 w=0.5u l=0.13u
MP6273 (qb6256 storage6267 vdd vdd) p12 w=1.5u l=0.13u
MN6274 (dl3 qb6256 vss vss) n12 w=0.5u l=0.13u
MP6275 (dl3 qb6256 vdd vdd) p12 w=1.5u l=0.13u
MN6276 (storage6267 rst vss vss) n12 w=2u l=0.13u
MN6279 (n6277 cl4 n6278 vss) n12 w=1.6u l=0.13u
MN6280 (n6278 n5964 vss vss) n12 w=1.6u l=0.13u
MP6281 (n6277 cl4 vdd vdd) p12 w=2.4u l=0.13u
MP6282 (n6277 n5964 vdd vdd) p12 w=2.4u l=0.13u
MN6285 (n6283 dl4 n6284 vss) n12 w=1.6u l=0.13u
MN6286 (n6284 n5967 vss vss) n12 w=1.6u l=0.13u
MP6287 (n6283 dl4 vdd vdd) p12 w=2.4u l=0.13u
MP6288 (n6283 n5967 vdd vdd) p12 w=2.4u l=0.13u
MN6291 (n6289 n6277 n6290 vss) n12 w=1.6u l=0.13u
MN6292 (n6290 n6283 vss vss) n12 w=1.6u l=0.13u
MP6293 (n6289 n6277 vdd vdd) p12 w=2.4u l=0.13u
MP6294 (n6289 n6283 vdd vdd) p12 w=2.4u l=0.13u
MN6299 (n6289 n93 storage6298 vss) n12 w=1.2u l=0.13u
MP6300 (n6289 n105 storage6298 vdd) p12 w=3.6u l=0.13u
MN6301 (qm6295 n102 storage6298 vss) n12 w=1.2u l=0.13u
MP6302 (qm6295 n108 storage6298 vdd) p12 w=3.6u l=0.13u
MN6303 (qmb6296 storage6298 vss vss) n12 w=0.5u l=0.13u
MP6304 (qmb6296 storage6298 vdd vdd) p12 w=1.5u l=0.13u
MN6305 (qm6295 qmb6296 vss vss) n12 w=0.5u l=0.13u
MP6306 (qm6295 qmb6296 vdd vdd) p12 w=1.5u l=0.13u
MN6307 (storage6298 rst vss vss) n12 w=2u l=0.13u
MN6309 (qm6295 n102 storage6308 vss) n12 w=1.2u l=0.13u
MP6310 (qm6295 n108 storage6308 vdd) p12 w=3.6u l=0.13u
MN6311 (dl4 n93 storage6308 vss) n12 w=1.2u l=0.13u
MP6312 (dl4 n105 storage6308 vdd) p12 w=3.6u l=0.13u
MN6313 (qb6297 storage6308 vss vss) n12 w=0.5u l=0.13u
MP6314 (qb6297 storage6308 vdd vdd) p12 w=1.5u l=0.13u
MN6315 (dl4 qb6297 vss vss) n12 w=0.5u l=0.13u
MP6316 (dl4 qb6297 vdd vdd) p12 w=1.5u l=0.13u
MN6317 (storage6308 rst vss vss) n12 w=2u l=0.13u
MN6320 (n6318 cl5 n6319 vss) n12 w=1.6u l=0.13u
MN6321 (n6319 n5964 vss vss) n12 w=1.6u l=0.13u
MP6322 (n6318 cl5 vdd vdd) p12 w=2.4u l=0.13u
MP6323 (n6318 n5964 vdd vdd) p12 w=2.4u l=0.13u
MN6326 (n6324 dl5 n6325 vss) n12 w=1.6u l=0.13u
MN6327 (n6325 n5967 vss vss) n12 w=1.6u l=0.13u
MP6328 (n6324 dl5 vdd vdd) p12 w=2.4u l=0.13u
MP6329 (n6324 n5967 vdd vdd) p12 w=2.4u l=0.13u
MN6332 (n6330 n6318 n6331 vss) n12 w=1.6u l=0.13u
MN6333 (n6331 n6324 vss vss) n12 w=1.6u l=0.13u
MP6334 (n6330 n6318 vdd vdd) p12 w=2.4u l=0.13u
MP6335 (n6330 n6324 vdd vdd) p12 w=2.4u l=0.13u
MN6340 (n6330 n93 storage6339 vss) n12 w=1.2u l=0.13u
MP6341 (n6330 n105 storage6339 vdd) p12 w=3.6u l=0.13u
MN6342 (qm6336 n102 storage6339 vss) n12 w=1.2u l=0.13u
MP6343 (qm6336 n108 storage6339 vdd) p12 w=3.6u l=0.13u
MN6344 (qmb6337 storage6339 vss vss) n12 w=0.5u l=0.13u
MP6345 (qmb6337 storage6339 vdd vdd) p12 w=1.5u l=0.13u
MN6346 (qm6336 qmb6337 vss vss) n12 w=0.5u l=0.13u
MP6347 (qm6336 qmb6337 vdd vdd) p12 w=1.5u l=0.13u
MN6348 (storage6339 rst vss vss) n12 w=2u l=0.13u
MN6350 (qm6336 n102 storage6349 vss) n12 w=1.2u l=0.13u
MP6351 (qm6336 n108 storage6349 vdd) p12 w=3.6u l=0.13u
MN6352 (dl5 n93 storage6349 vss) n12 w=1.2u l=0.13u
MP6353 (dl5 n105 storage6349 vdd) p12 w=3.6u l=0.13u
MN6354 (qb6338 storage6349 vss vss) n12 w=0.5u l=0.13u
MP6355 (qb6338 storage6349 vdd vdd) p12 w=1.5u l=0.13u
MN6356 (dl5 qb6338 vss vss) n12 w=0.5u l=0.13u
MP6357 (dl5 qb6338 vdd vdd) p12 w=1.5u l=0.13u
MN6358 (storage6349 rst vss vss) n12 w=2u l=0.13u
MN6361 (n6359 cl6 n6360 vss) n12 w=1.6u l=0.13u
MN6362 (n6360 n5964 vss vss) n12 w=1.6u l=0.13u
MP6363 (n6359 cl6 vdd vdd) p12 w=2.4u l=0.13u
MP6364 (n6359 n5964 vdd vdd) p12 w=2.4u l=0.13u
MN6367 (n6365 dl6 n6366 vss) n12 w=1.6u l=0.13u
MN6368 (n6366 n5967 vss vss) n12 w=1.6u l=0.13u
MP6369 (n6365 dl6 vdd vdd) p12 w=2.4u l=0.13u
MP6370 (n6365 n5967 vdd vdd) p12 w=2.4u l=0.13u
MN6373 (n6371 n6359 n6372 vss) n12 w=1.6u l=0.13u
MN6374 (n6372 n6365 vss vss) n12 w=1.6u l=0.13u
MP6375 (n6371 n6359 vdd vdd) p12 w=2.4u l=0.13u
MP6376 (n6371 n6365 vdd vdd) p12 w=2.4u l=0.13u
MN6381 (n6371 n93 storage6380 vss) n12 w=1.2u l=0.13u
MP6382 (n6371 n105 storage6380 vdd) p12 w=3.6u l=0.13u
MN6383 (qm6377 n102 storage6380 vss) n12 w=1.2u l=0.13u
MP6384 (qm6377 n108 storage6380 vdd) p12 w=3.6u l=0.13u
MN6385 (qmb6378 storage6380 vss vss) n12 w=0.5u l=0.13u
MP6386 (qmb6378 storage6380 vdd vdd) p12 w=1.5u l=0.13u
MN6387 (qm6377 qmb6378 vss vss) n12 w=0.5u l=0.13u
MP6388 (qm6377 qmb6378 vdd vdd) p12 w=1.5u l=0.13u
MN6389 (storage6380 rst vss vss) n12 w=2u l=0.13u
MN6391 (qm6377 n102 storage6390 vss) n12 w=1.2u l=0.13u
MP6392 (qm6377 n108 storage6390 vdd) p12 w=3.6u l=0.13u
MN6393 (dl6 n93 storage6390 vss) n12 w=1.2u l=0.13u
MP6394 (dl6 n105 storage6390 vdd) p12 w=3.6u l=0.13u
MN6395 (qb6379 storage6390 vss vss) n12 w=0.5u l=0.13u
MP6396 (qb6379 storage6390 vdd vdd) p12 w=1.5u l=0.13u
MN6397 (dl6 qb6379 vss vss) n12 w=0.5u l=0.13u
MP6398 (dl6 qb6379 vdd vdd) p12 w=1.5u l=0.13u
MN6399 (storage6390 rst vss vss) n12 w=2u l=0.13u
MN6402 (n6400 cl7 n6401 vss) n12 w=1.6u l=0.13u
MN6403 (n6401 n5964 vss vss) n12 w=1.6u l=0.13u
MP6404 (n6400 cl7 vdd vdd) p12 w=2.4u l=0.13u
MP6405 (n6400 n5964 vdd vdd) p12 w=2.4u l=0.13u
MN6408 (n6406 dl7 n6407 vss) n12 w=1.6u l=0.13u
MN6409 (n6407 n5967 vss vss) n12 w=1.6u l=0.13u
MP6410 (n6406 dl7 vdd vdd) p12 w=2.4u l=0.13u
MP6411 (n6406 n5967 vdd vdd) p12 w=2.4u l=0.13u
MN6414 (n6412 n6400 n6413 vss) n12 w=1.6u l=0.13u
MN6415 (n6413 n6406 vss vss) n12 w=1.6u l=0.13u
MP6416 (n6412 n6400 vdd vdd) p12 w=2.4u l=0.13u
MP6417 (n6412 n6406 vdd vdd) p12 w=2.4u l=0.13u
MN6422 (n6412 n93 storage6421 vss) n12 w=1.2u l=0.13u
MP6423 (n6412 n105 storage6421 vdd) p12 w=3.6u l=0.13u
MN6424 (qm6418 n102 storage6421 vss) n12 w=1.2u l=0.13u
MP6425 (qm6418 n108 storage6421 vdd) p12 w=3.6u l=0.13u
MN6426 (qmb6419 storage6421 vss vss) n12 w=0.5u l=0.13u
MP6427 (qmb6419 storage6421 vdd vdd) p12 w=1.5u l=0.13u
MN6428 (qm6418 qmb6419 vss vss) n12 w=0.5u l=0.13u
MP6429 (qm6418 qmb6419 vdd vdd) p12 w=1.5u l=0.13u
MN6430 (storage6421 rst vss vss) n12 w=2u l=0.13u
MN6432 (qm6418 n102 storage6431 vss) n12 w=1.2u l=0.13u
MP6433 (qm6418 n108 storage6431 vdd) p12 w=3.6u l=0.13u
MN6434 (dl7 n93 storage6431 vss) n12 w=1.2u l=0.13u
MP6435 (dl7 n105 storage6431 vdd) p12 w=3.6u l=0.13u
MN6436 (qb6420 storage6431 vss vss) n12 w=0.5u l=0.13u
MP6437 (qb6420 storage6431 vdd vdd) p12 w=1.5u l=0.13u
MN6438 (dl7 qb6420 vss vss) n12 w=0.5u l=0.13u
MP6439 (dl7 qb6420 vdd vdd) p12 w=1.5u l=0.13u
MN6440 (storage6431 rst vss vss) n12 w=2u l=0.13u
MN6443 (n6441 cg0 n6442 vss) n12 w=1.6u l=0.13u
MN6444 (n6442 n5964 vss vss) n12 w=1.6u l=0.13u
MP6445 (n6441 cg0 vdd vdd) p12 w=2.4u l=0.13u
MP6446 (n6441 n5964 vdd vdd) p12 w=2.4u l=0.13u
MN6449 (n6447 dg0 n6448 vss) n12 w=1.6u l=0.13u
MN6450 (n6448 n5967 vss vss) n12 w=1.6u l=0.13u
MP6451 (n6447 dg0 vdd vdd) p12 w=2.4u l=0.13u
MP6452 (n6447 n5967 vdd vdd) p12 w=2.4u l=0.13u
MN6455 (n6453 n6441 n6454 vss) n12 w=1.6u l=0.13u
MN6456 (n6454 n6447 vss vss) n12 w=1.6u l=0.13u
MP6457 (n6453 n6441 vdd vdd) p12 w=2.4u l=0.13u
MP6458 (n6453 n6447 vdd vdd) p12 w=2.4u l=0.13u
MN6463 (n6453 n93 storage6462 vss) n12 w=1.2u l=0.13u
MP6464 (n6453 n105 storage6462 vdd) p12 w=3.6u l=0.13u
MN6465 (qm6459 n102 storage6462 vss) n12 w=1.2u l=0.13u
MP6466 (qm6459 n108 storage6462 vdd) p12 w=3.6u l=0.13u
MN6467 (qmb6460 storage6462 vss vss) n12 w=0.5u l=0.13u
MP6468 (qmb6460 storage6462 vdd vdd) p12 w=1.5u l=0.13u
MN6469 (qm6459 qmb6460 vss vss) n12 w=0.5u l=0.13u
MP6470 (qm6459 qmb6460 vdd vdd) p12 w=1.5u l=0.13u
MN6471 (storage6462 rst vss vss) n12 w=2u l=0.13u
MN6473 (qm6459 n102 storage6472 vss) n12 w=1.2u l=0.13u
MP6474 (qm6459 n108 storage6472 vdd) p12 w=3.6u l=0.13u
MN6475 (dg0 n93 storage6472 vss) n12 w=1.2u l=0.13u
MP6476 (dg0 n105 storage6472 vdd) p12 w=3.6u l=0.13u
MN6477 (qb6461 storage6472 vss vss) n12 w=0.5u l=0.13u
MP6478 (qb6461 storage6472 vdd vdd) p12 w=1.5u l=0.13u
MN6479 (dg0 qb6461 vss vss) n12 w=0.5u l=0.13u
MP6480 (dg0 qb6461 vdd vdd) p12 w=1.5u l=0.13u
MN6481 (storage6472 rst vss vss) n12 w=2u l=0.13u
MN6484 (n6482 cg1 n6483 vss) n12 w=1.6u l=0.13u
MN6485 (n6483 n5964 vss vss) n12 w=1.6u l=0.13u
MP6486 (n6482 cg1 vdd vdd) p12 w=2.4u l=0.13u
MP6487 (n6482 n5964 vdd vdd) p12 w=2.4u l=0.13u
MN6490 (n6488 dg1 n6489 vss) n12 w=1.6u l=0.13u
MN6491 (n6489 n5967 vss vss) n12 w=1.6u l=0.13u
MP6492 (n6488 dg1 vdd vdd) p12 w=2.4u l=0.13u
MP6493 (n6488 n5967 vdd vdd) p12 w=2.4u l=0.13u
MN6496 (n6494 n6482 n6495 vss) n12 w=1.6u l=0.13u
MN6497 (n6495 n6488 vss vss) n12 w=1.6u l=0.13u
MP6498 (n6494 n6482 vdd vdd) p12 w=2.4u l=0.13u
MP6499 (n6494 n6488 vdd vdd) p12 w=2.4u l=0.13u
MN6504 (n6494 n93 storage6503 vss) n12 w=1.2u l=0.13u
MP6505 (n6494 n105 storage6503 vdd) p12 w=3.6u l=0.13u
MN6506 (qm6500 n102 storage6503 vss) n12 w=1.2u l=0.13u
MP6507 (qm6500 n108 storage6503 vdd) p12 w=3.6u l=0.13u
MN6508 (qmb6501 storage6503 vss vss) n12 w=0.5u l=0.13u
MP6509 (qmb6501 storage6503 vdd vdd) p12 w=1.5u l=0.13u
MN6510 (qm6500 qmb6501 vss vss) n12 w=0.5u l=0.13u
MP6511 (qm6500 qmb6501 vdd vdd) p12 w=1.5u l=0.13u
MN6512 (storage6503 rst vss vss) n12 w=2u l=0.13u
MN6514 (qm6500 n102 storage6513 vss) n12 w=1.2u l=0.13u
MP6515 (qm6500 n108 storage6513 vdd) p12 w=3.6u l=0.13u
MN6516 (dg1 n93 storage6513 vss) n12 w=1.2u l=0.13u
MP6517 (dg1 n105 storage6513 vdd) p12 w=3.6u l=0.13u
MN6518 (qb6502 storage6513 vss vss) n12 w=0.5u l=0.13u
MP6519 (qb6502 storage6513 vdd vdd) p12 w=1.5u l=0.13u
MN6520 (dg1 qb6502 vss vss) n12 w=0.5u l=0.13u
MP6521 (dg1 qb6502 vdd vdd) p12 w=1.5u l=0.13u
MN6522 (storage6513 rst vss vss) n12 w=2u l=0.13u
MN6525 (n6523 cg2 n6524 vss) n12 w=1.6u l=0.13u
MN6526 (n6524 n5964 vss vss) n12 w=1.6u l=0.13u
MP6527 (n6523 cg2 vdd vdd) p12 w=2.4u l=0.13u
MP6528 (n6523 n5964 vdd vdd) p12 w=2.4u l=0.13u
MN6531 (n6529 dg2 n6530 vss) n12 w=1.6u l=0.13u
MN6532 (n6530 n5967 vss vss) n12 w=1.6u l=0.13u
MP6533 (n6529 dg2 vdd vdd) p12 w=2.4u l=0.13u
MP6534 (n6529 n5967 vdd vdd) p12 w=2.4u l=0.13u
MN6537 (n6535 n6523 n6536 vss) n12 w=1.6u l=0.13u
MN6538 (n6536 n6529 vss vss) n12 w=1.6u l=0.13u
MP6539 (n6535 n6523 vdd vdd) p12 w=2.4u l=0.13u
MP6540 (n6535 n6529 vdd vdd) p12 w=2.4u l=0.13u
MN6545 (n6535 n93 storage6544 vss) n12 w=1.2u l=0.13u
MP6546 (n6535 n105 storage6544 vdd) p12 w=3.6u l=0.13u
MN6547 (qm6541 n102 storage6544 vss) n12 w=1.2u l=0.13u
MP6548 (qm6541 n108 storage6544 vdd) p12 w=3.6u l=0.13u
MN6549 (qmb6542 storage6544 vss vss) n12 w=0.5u l=0.13u
MP6550 (qmb6542 storage6544 vdd vdd) p12 w=1.5u l=0.13u
MN6551 (qm6541 qmb6542 vss vss) n12 w=0.5u l=0.13u
MP6552 (qm6541 qmb6542 vdd vdd) p12 w=1.5u l=0.13u
MN6553 (storage6544 rst vss vss) n12 w=2u l=0.13u
MN6555 (qm6541 n102 storage6554 vss) n12 w=1.2u l=0.13u
MP6556 (qm6541 n108 storage6554 vdd) p12 w=3.6u l=0.13u
MN6557 (dg2 n93 storage6554 vss) n12 w=1.2u l=0.13u
MP6558 (dg2 n105 storage6554 vdd) p12 w=3.6u l=0.13u
MN6559 (qb6543 storage6554 vss vss) n12 w=0.5u l=0.13u
MP6560 (qb6543 storage6554 vdd vdd) p12 w=1.5u l=0.13u
MN6561 (dg2 qb6543 vss vss) n12 w=0.5u l=0.13u
MP6562 (dg2 qb6543 vdd vdd) p12 w=1.5u l=0.13u
MN6563 (storage6554 rst vss vss) n12 w=2u l=0.13u
MN6566 (n6564 cg3 n6565 vss) n12 w=1.6u l=0.13u
MN6567 (n6565 n5964 vss vss) n12 w=1.6u l=0.13u
MP6568 (n6564 cg3 vdd vdd) p12 w=2.4u l=0.13u
MP6569 (n6564 n5964 vdd vdd) p12 w=2.4u l=0.13u
MN6572 (n6570 dg3 n6571 vss) n12 w=1.6u l=0.13u
MN6573 (n6571 n5967 vss vss) n12 w=1.6u l=0.13u
MP6574 (n6570 dg3 vdd vdd) p12 w=2.4u l=0.13u
MP6575 (n6570 n5967 vdd vdd) p12 w=2.4u l=0.13u
MN6578 (n6576 n6564 n6577 vss) n12 w=1.6u l=0.13u
MN6579 (n6577 n6570 vss vss) n12 w=1.6u l=0.13u
MP6580 (n6576 n6564 vdd vdd) p12 w=2.4u l=0.13u
MP6581 (n6576 n6570 vdd vdd) p12 w=2.4u l=0.13u
MN6586 (n6576 n93 storage6585 vss) n12 w=1.2u l=0.13u
MP6587 (n6576 n105 storage6585 vdd) p12 w=3.6u l=0.13u
MN6588 (qm6582 n102 storage6585 vss) n12 w=1.2u l=0.13u
MP6589 (qm6582 n108 storage6585 vdd) p12 w=3.6u l=0.13u
MN6590 (qmb6583 storage6585 vss vss) n12 w=0.5u l=0.13u
MP6591 (qmb6583 storage6585 vdd vdd) p12 w=1.5u l=0.13u
MN6592 (qm6582 qmb6583 vss vss) n12 w=0.5u l=0.13u
MP6593 (qm6582 qmb6583 vdd vdd) p12 w=1.5u l=0.13u
MN6594 (storage6585 rst vss vss) n12 w=2u l=0.13u
MN6596 (qm6582 n102 storage6595 vss) n12 w=1.2u l=0.13u
MP6597 (qm6582 n108 storage6595 vdd) p12 w=3.6u l=0.13u
MN6598 (dg3 n93 storage6595 vss) n12 w=1.2u l=0.13u
MP6599 (dg3 n105 storage6595 vdd) p12 w=3.6u l=0.13u
MN6600 (qb6584 storage6595 vss vss) n12 w=0.5u l=0.13u
MP6601 (qb6584 storage6595 vdd vdd) p12 w=1.5u l=0.13u
MN6602 (dg3 qb6584 vss vss) n12 w=0.5u l=0.13u
MP6603 (dg3 qb6584 vdd vdd) p12 w=1.5u l=0.13u
MN6604 (storage6595 rst vss vss) n12 w=2u l=0.13u
MN6607 (n6605 cg4 n6606 vss) n12 w=1.6u l=0.13u
MN6608 (n6606 n5964 vss vss) n12 w=1.6u l=0.13u
MP6609 (n6605 cg4 vdd vdd) p12 w=2.4u l=0.13u
MP6610 (n6605 n5964 vdd vdd) p12 w=2.4u l=0.13u
MN6613 (n6611 dg4 n6612 vss) n12 w=1.6u l=0.13u
MN6614 (n6612 n5967 vss vss) n12 w=1.6u l=0.13u
MP6615 (n6611 dg4 vdd vdd) p12 w=2.4u l=0.13u
MP6616 (n6611 n5967 vdd vdd) p12 w=2.4u l=0.13u
MN6619 (n6617 n6605 n6618 vss) n12 w=1.6u l=0.13u
MN6620 (n6618 n6611 vss vss) n12 w=1.6u l=0.13u
MP6621 (n6617 n6605 vdd vdd) p12 w=2.4u l=0.13u
MP6622 (n6617 n6611 vdd vdd) p12 w=2.4u l=0.13u
MN6627 (n6617 n93 storage6626 vss) n12 w=1.2u l=0.13u
MP6628 (n6617 n105 storage6626 vdd) p12 w=3.6u l=0.13u
MN6629 (qm6623 n102 storage6626 vss) n12 w=1.2u l=0.13u
MP6630 (qm6623 n108 storage6626 vdd) p12 w=3.6u l=0.13u
MN6631 (qmb6624 storage6626 vss vss) n12 w=0.5u l=0.13u
MP6632 (qmb6624 storage6626 vdd vdd) p12 w=1.5u l=0.13u
MN6633 (qm6623 qmb6624 vss vss) n12 w=0.5u l=0.13u
MP6634 (qm6623 qmb6624 vdd vdd) p12 w=1.5u l=0.13u
MN6635 (storage6626 rst vss vss) n12 w=2u l=0.13u
MN6637 (qm6623 n102 storage6636 vss) n12 w=1.2u l=0.13u
MP6638 (qm6623 n108 storage6636 vdd) p12 w=3.6u l=0.13u
MN6639 (dg4 n93 storage6636 vss) n12 w=1.2u l=0.13u
MP6640 (dg4 n105 storage6636 vdd) p12 w=3.6u l=0.13u
MN6641 (qb6625 storage6636 vss vss) n12 w=0.5u l=0.13u
MP6642 (qb6625 storage6636 vdd vdd) p12 w=1.5u l=0.13u
MN6643 (dg4 qb6625 vss vss) n12 w=0.5u l=0.13u
MP6644 (dg4 qb6625 vdd vdd) p12 w=1.5u l=0.13u
MN6645 (storage6636 rst vss vss) n12 w=2u l=0.13u
MN6648 (n6646 cg5 n6647 vss) n12 w=1.6u l=0.13u
MN6649 (n6647 n5964 vss vss) n12 w=1.6u l=0.13u
MP6650 (n6646 cg5 vdd vdd) p12 w=2.4u l=0.13u
MP6651 (n6646 n5964 vdd vdd) p12 w=2.4u l=0.13u
MN6654 (n6652 dg5 n6653 vss) n12 w=1.6u l=0.13u
MN6655 (n6653 n5967 vss vss) n12 w=1.6u l=0.13u
MP6656 (n6652 dg5 vdd vdd) p12 w=2.4u l=0.13u
MP6657 (n6652 n5967 vdd vdd) p12 w=2.4u l=0.13u
MN6660 (n6658 n6646 n6659 vss) n12 w=1.6u l=0.13u
MN6661 (n6659 n6652 vss vss) n12 w=1.6u l=0.13u
MP6662 (n6658 n6646 vdd vdd) p12 w=2.4u l=0.13u
MP6663 (n6658 n6652 vdd vdd) p12 w=2.4u l=0.13u
MN6668 (n6658 n93 storage6667 vss) n12 w=1.2u l=0.13u
MP6669 (n6658 n105 storage6667 vdd) p12 w=3.6u l=0.13u
MN6670 (qm6664 n102 storage6667 vss) n12 w=1.2u l=0.13u
MP6671 (qm6664 n108 storage6667 vdd) p12 w=3.6u l=0.13u
MN6672 (qmb6665 storage6667 vss vss) n12 w=0.5u l=0.13u
MP6673 (qmb6665 storage6667 vdd vdd) p12 w=1.5u l=0.13u
MN6674 (qm6664 qmb6665 vss vss) n12 w=0.5u l=0.13u
MP6675 (qm6664 qmb6665 vdd vdd) p12 w=1.5u l=0.13u
MN6676 (storage6667 rst vss vss) n12 w=2u l=0.13u
MN6678 (qm6664 n102 storage6677 vss) n12 w=1.2u l=0.13u
MP6679 (qm6664 n108 storage6677 vdd) p12 w=3.6u l=0.13u
MN6680 (dg5 n93 storage6677 vss) n12 w=1.2u l=0.13u
MP6681 (dg5 n105 storage6677 vdd) p12 w=3.6u l=0.13u
MN6682 (qb6666 storage6677 vss vss) n12 w=0.5u l=0.13u
MP6683 (qb6666 storage6677 vdd vdd) p12 w=1.5u l=0.13u
MN6684 (dg5 qb6666 vss vss) n12 w=0.5u l=0.13u
MP6685 (dg5 qb6666 vdd vdd) p12 w=1.5u l=0.13u
MN6686 (storage6677 rst vss vss) n12 w=2u l=0.13u
MN6689 (n6687 cg6 n6688 vss) n12 w=1.6u l=0.13u
MN6690 (n6688 n5964 vss vss) n12 w=1.6u l=0.13u
MP6691 (n6687 cg6 vdd vdd) p12 w=2.4u l=0.13u
MP6692 (n6687 n5964 vdd vdd) p12 w=2.4u l=0.13u
MN6695 (n6693 dg6 n6694 vss) n12 w=1.6u l=0.13u
MN6696 (n6694 n5967 vss vss) n12 w=1.6u l=0.13u
MP6697 (n6693 dg6 vdd vdd) p12 w=2.4u l=0.13u
MP6698 (n6693 n5967 vdd vdd) p12 w=2.4u l=0.13u
MN6701 (n6699 n6687 n6700 vss) n12 w=1.6u l=0.13u
MN6702 (n6700 n6693 vss vss) n12 w=1.6u l=0.13u
MP6703 (n6699 n6687 vdd vdd) p12 w=2.4u l=0.13u
MP6704 (n6699 n6693 vdd vdd) p12 w=2.4u l=0.13u
MN6709 (n6699 n93 storage6708 vss) n12 w=1.2u l=0.13u
MP6710 (n6699 n105 storage6708 vdd) p12 w=3.6u l=0.13u
MN6711 (qm6705 n102 storage6708 vss) n12 w=1.2u l=0.13u
MP6712 (qm6705 n108 storage6708 vdd) p12 w=3.6u l=0.13u
MN6713 (qmb6706 storage6708 vss vss) n12 w=0.5u l=0.13u
MP6714 (qmb6706 storage6708 vdd vdd) p12 w=1.5u l=0.13u
MN6715 (qm6705 qmb6706 vss vss) n12 w=0.5u l=0.13u
MP6716 (qm6705 qmb6706 vdd vdd) p12 w=1.5u l=0.13u
MN6717 (storage6708 rst vss vss) n12 w=2u l=0.13u
MN6719 (qm6705 n102 storage6718 vss) n12 w=1.2u l=0.13u
MP6720 (qm6705 n108 storage6718 vdd) p12 w=3.6u l=0.13u
MN6721 (dg6 n93 storage6718 vss) n12 w=1.2u l=0.13u
MP6722 (dg6 n105 storage6718 vdd) p12 w=3.6u l=0.13u
MN6723 (qb6707 storage6718 vss vss) n12 w=0.5u l=0.13u
MP6724 (qb6707 storage6718 vdd vdd) p12 w=1.5u l=0.13u
MN6725 (dg6 qb6707 vss vss) n12 w=0.5u l=0.13u
MP6726 (dg6 qb6707 vdd vdd) p12 w=1.5u l=0.13u
MN6727 (storage6718 rst vss vss) n12 w=2u l=0.13u
MN6730 (n6728 cg7 n6729 vss) n12 w=1.6u l=0.13u
MN6731 (n6729 n5964 vss vss) n12 w=1.6u l=0.13u
MP6732 (n6728 cg7 vdd vdd) p12 w=2.4u l=0.13u
MP6733 (n6728 n5964 vdd vdd) p12 w=2.4u l=0.13u
MN6736 (n6734 dg7 n6735 vss) n12 w=1.6u l=0.13u
MN6737 (n6735 n5967 vss vss) n12 w=1.6u l=0.13u
MP6738 (n6734 dg7 vdd vdd) p12 w=2.4u l=0.13u
MP6739 (n6734 n5967 vdd vdd) p12 w=2.4u l=0.13u
MN6742 (n6740 n6728 n6741 vss) n12 w=1.6u l=0.13u
MN6743 (n6741 n6734 vss vss) n12 w=1.6u l=0.13u
MP6744 (n6740 n6728 vdd vdd) p12 w=2.4u l=0.13u
MP6745 (n6740 n6734 vdd vdd) p12 w=2.4u l=0.13u
MN6750 (n6740 n93 storage6749 vss) n12 w=1.2u l=0.13u
MP6751 (n6740 n105 storage6749 vdd) p12 w=3.6u l=0.13u
MN6752 (qm6746 n102 storage6749 vss) n12 w=1.2u l=0.13u
MP6753 (qm6746 n108 storage6749 vdd) p12 w=3.6u l=0.13u
MN6754 (qmb6747 storage6749 vss vss) n12 w=0.5u l=0.13u
MP6755 (qmb6747 storage6749 vdd vdd) p12 w=1.5u l=0.13u
MN6756 (qm6746 qmb6747 vss vss) n12 w=0.5u l=0.13u
MP6757 (qm6746 qmb6747 vdd vdd) p12 w=1.5u l=0.13u
MN6758 (storage6749 rst vss vss) n12 w=2u l=0.13u
MN6760 (qm6746 n102 storage6759 vss) n12 w=1.2u l=0.13u
MP6761 (qm6746 n108 storage6759 vdd) p12 w=3.6u l=0.13u
MN6762 (dg7 n93 storage6759 vss) n12 w=1.2u l=0.13u
MP6763 (dg7 n105 storage6759 vdd) p12 w=3.6u l=0.13u
MN6764 (qb6748 storage6759 vss vss) n12 w=0.5u l=0.13u
MP6765 (qb6748 storage6759 vdd vdd) p12 w=1.5u l=0.13u
MN6766 (dg7 qb6748 vss vss) n12 w=0.5u l=0.13u
MP6767 (dg7 qb6748 vdd vdd) p12 w=1.5u l=0.13u
MN6768 (storage6759 rst vss vss) n12 w=2u l=0.13u
MN6771 (n6769 cd0 n6770 vss) n12 w=1.6u l=0.13u
MN6772 (n6770 n5964 vss vss) n12 w=1.6u l=0.13u
MP6773 (n6769 cd0 vdd vdd) p12 w=2.4u l=0.13u
MP6774 (n6769 n5964 vdd vdd) p12 w=2.4u l=0.13u
MN6777 (n6775 dd0 n6776 vss) n12 w=1.6u l=0.13u
MN6778 (n6776 n5967 vss vss) n12 w=1.6u l=0.13u
MP6779 (n6775 dd0 vdd vdd) p12 w=2.4u l=0.13u
MP6780 (n6775 n5967 vdd vdd) p12 w=2.4u l=0.13u
MN6783 (n6781 n6769 n6782 vss) n12 w=1.6u l=0.13u
MN6784 (n6782 n6775 vss vss) n12 w=1.6u l=0.13u
MP6785 (n6781 n6769 vdd vdd) p12 w=2.4u l=0.13u
MP6786 (n6781 n6775 vdd vdd) p12 w=2.4u l=0.13u
MN6791 (n6781 n93 storage6790 vss) n12 w=1.2u l=0.13u
MP6792 (n6781 n105 storage6790 vdd) p12 w=3.6u l=0.13u
MN6793 (qm6787 n102 storage6790 vss) n12 w=1.2u l=0.13u
MP6794 (qm6787 n108 storage6790 vdd) p12 w=3.6u l=0.13u
MN6795 (qmb6788 storage6790 vss vss) n12 w=0.5u l=0.13u
MP6796 (qmb6788 storage6790 vdd vdd) p12 w=1.5u l=0.13u
MN6797 (qm6787 qmb6788 vss vss) n12 w=0.5u l=0.13u
MP6798 (qm6787 qmb6788 vdd vdd) p12 w=1.5u l=0.13u
MN6799 (storage6790 rst vss vss) n12 w=2u l=0.13u
MN6801 (qm6787 n102 storage6800 vss) n12 w=1.2u l=0.13u
MP6802 (qm6787 n108 storage6800 vdd) p12 w=3.6u l=0.13u
MN6803 (dd0 n93 storage6800 vss) n12 w=1.2u l=0.13u
MP6804 (dd0 n105 storage6800 vdd) p12 w=3.6u l=0.13u
MN6805 (qb6789 storage6800 vss vss) n12 w=0.5u l=0.13u
MP6806 (qb6789 storage6800 vdd vdd) p12 w=1.5u l=0.13u
MN6807 (dd0 qb6789 vss vss) n12 w=0.5u l=0.13u
MP6808 (dd0 qb6789 vdd vdd) p12 w=1.5u l=0.13u
MN6809 (storage6800 rst vss vss) n12 w=2u l=0.13u
MN6812 (n6810 cd1 n6811 vss) n12 w=1.6u l=0.13u
MN6813 (n6811 n5964 vss vss) n12 w=1.6u l=0.13u
MP6814 (n6810 cd1 vdd vdd) p12 w=2.4u l=0.13u
MP6815 (n6810 n5964 vdd vdd) p12 w=2.4u l=0.13u
MN6818 (n6816 dd1 n6817 vss) n12 w=1.6u l=0.13u
MN6819 (n6817 n5967 vss vss) n12 w=1.6u l=0.13u
MP6820 (n6816 dd1 vdd vdd) p12 w=2.4u l=0.13u
MP6821 (n6816 n5967 vdd vdd) p12 w=2.4u l=0.13u
MN6824 (n6822 n6810 n6823 vss) n12 w=1.6u l=0.13u
MN6825 (n6823 n6816 vss vss) n12 w=1.6u l=0.13u
MP6826 (n6822 n6810 vdd vdd) p12 w=2.4u l=0.13u
MP6827 (n6822 n6816 vdd vdd) p12 w=2.4u l=0.13u
MN6832 (n6822 n93 storage6831 vss) n12 w=1.2u l=0.13u
MP6833 (n6822 n105 storage6831 vdd) p12 w=3.6u l=0.13u
MN6834 (qm6828 n102 storage6831 vss) n12 w=1.2u l=0.13u
MP6835 (qm6828 n108 storage6831 vdd) p12 w=3.6u l=0.13u
MN6836 (qmb6829 storage6831 vss vss) n12 w=0.5u l=0.13u
MP6837 (qmb6829 storage6831 vdd vdd) p12 w=1.5u l=0.13u
MN6838 (qm6828 qmb6829 vss vss) n12 w=0.5u l=0.13u
MP6839 (qm6828 qmb6829 vdd vdd) p12 w=1.5u l=0.13u
MN6840 (storage6831 rst vss vss) n12 w=2u l=0.13u
MN6842 (qm6828 n102 storage6841 vss) n12 w=1.2u l=0.13u
MP6843 (qm6828 n108 storage6841 vdd) p12 w=3.6u l=0.13u
MN6844 (dd1 n93 storage6841 vss) n12 w=1.2u l=0.13u
MP6845 (dd1 n105 storage6841 vdd) p12 w=3.6u l=0.13u
MN6846 (qb6830 storage6841 vss vss) n12 w=0.5u l=0.13u
MP6847 (qb6830 storage6841 vdd vdd) p12 w=1.5u l=0.13u
MN6848 (dd1 qb6830 vss vss) n12 w=0.5u l=0.13u
MP6849 (dd1 qb6830 vdd vdd) p12 w=1.5u l=0.13u
MN6850 (storage6841 rst vss vss) n12 w=2u l=0.13u
MN6853 (n6851 cd2 n6852 vss) n12 w=1.6u l=0.13u
MN6854 (n6852 n5964 vss vss) n12 w=1.6u l=0.13u
MP6855 (n6851 cd2 vdd vdd) p12 w=2.4u l=0.13u
MP6856 (n6851 n5964 vdd vdd) p12 w=2.4u l=0.13u
MN6859 (n6857 dd2 n6858 vss) n12 w=1.6u l=0.13u
MN6860 (n6858 n5967 vss vss) n12 w=1.6u l=0.13u
MP6861 (n6857 dd2 vdd vdd) p12 w=2.4u l=0.13u
MP6862 (n6857 n5967 vdd vdd) p12 w=2.4u l=0.13u
MN6865 (n6863 n6851 n6864 vss) n12 w=1.6u l=0.13u
MN6866 (n6864 n6857 vss vss) n12 w=1.6u l=0.13u
MP6867 (n6863 n6851 vdd vdd) p12 w=2.4u l=0.13u
MP6868 (n6863 n6857 vdd vdd) p12 w=2.4u l=0.13u
MN6873 (n6863 n93 storage6872 vss) n12 w=1.2u l=0.13u
MP6874 (n6863 n105 storage6872 vdd) p12 w=3.6u l=0.13u
MN6875 (qm6869 n102 storage6872 vss) n12 w=1.2u l=0.13u
MP6876 (qm6869 n108 storage6872 vdd) p12 w=3.6u l=0.13u
MN6877 (qmb6870 storage6872 vss vss) n12 w=0.5u l=0.13u
MP6878 (qmb6870 storage6872 vdd vdd) p12 w=1.5u l=0.13u
MN6879 (qm6869 qmb6870 vss vss) n12 w=0.5u l=0.13u
MP6880 (qm6869 qmb6870 vdd vdd) p12 w=1.5u l=0.13u
MN6881 (storage6872 rst vss vss) n12 w=2u l=0.13u
MN6883 (qm6869 n102 storage6882 vss) n12 w=1.2u l=0.13u
MP6884 (qm6869 n108 storage6882 vdd) p12 w=3.6u l=0.13u
MN6885 (dd2 n93 storage6882 vss) n12 w=1.2u l=0.13u
MP6886 (dd2 n105 storage6882 vdd) p12 w=3.6u l=0.13u
MN6887 (qb6871 storage6882 vss vss) n12 w=0.5u l=0.13u
MP6888 (qb6871 storage6882 vdd vdd) p12 w=1.5u l=0.13u
MN6889 (dd2 qb6871 vss vss) n12 w=0.5u l=0.13u
MP6890 (dd2 qb6871 vdd vdd) p12 w=1.5u l=0.13u
MN6891 (storage6882 rst vss vss) n12 w=2u l=0.13u
MN6894 (n6892 cd3 n6893 vss) n12 w=1.6u l=0.13u
MN6895 (n6893 n5964 vss vss) n12 w=1.6u l=0.13u
MP6896 (n6892 cd3 vdd vdd) p12 w=2.4u l=0.13u
MP6897 (n6892 n5964 vdd vdd) p12 w=2.4u l=0.13u
MN6900 (n6898 dd3 n6899 vss) n12 w=1.6u l=0.13u
MN6901 (n6899 n5967 vss vss) n12 w=1.6u l=0.13u
MP6902 (n6898 dd3 vdd vdd) p12 w=2.4u l=0.13u
MP6903 (n6898 n5967 vdd vdd) p12 w=2.4u l=0.13u
MN6906 (n6904 n6892 n6905 vss) n12 w=1.6u l=0.13u
MN6907 (n6905 n6898 vss vss) n12 w=1.6u l=0.13u
MP6908 (n6904 n6892 vdd vdd) p12 w=2.4u l=0.13u
MP6909 (n6904 n6898 vdd vdd) p12 w=2.4u l=0.13u
MN6914 (n6904 n93 storage6913 vss) n12 w=1.2u l=0.13u
MP6915 (n6904 n105 storage6913 vdd) p12 w=3.6u l=0.13u
MN6916 (qm6910 n102 storage6913 vss) n12 w=1.2u l=0.13u
MP6917 (qm6910 n108 storage6913 vdd) p12 w=3.6u l=0.13u
MN6918 (qmb6911 storage6913 vss vss) n12 w=0.5u l=0.13u
MP6919 (qmb6911 storage6913 vdd vdd) p12 w=1.5u l=0.13u
MN6920 (qm6910 qmb6911 vss vss) n12 w=0.5u l=0.13u
MP6921 (qm6910 qmb6911 vdd vdd) p12 w=1.5u l=0.13u
MN6922 (storage6913 rst vss vss) n12 w=2u l=0.13u
MN6924 (qm6910 n102 storage6923 vss) n12 w=1.2u l=0.13u
MP6925 (qm6910 n108 storage6923 vdd) p12 w=3.6u l=0.13u
MN6926 (dd3 n93 storage6923 vss) n12 w=1.2u l=0.13u
MP6927 (dd3 n105 storage6923 vdd) p12 w=3.6u l=0.13u
MN6928 (qb6912 storage6923 vss vss) n12 w=0.5u l=0.13u
MP6929 (qb6912 storage6923 vdd vdd) p12 w=1.5u l=0.13u
MN6930 (dd3 qb6912 vss vss) n12 w=0.5u l=0.13u
MP6931 (dd3 qb6912 vdd vdd) p12 w=1.5u l=0.13u
MN6932 (storage6923 rst vss vss) n12 w=2u l=0.13u
MN6935 (n6933 cd4 n6934 vss) n12 w=1.6u l=0.13u
MN6936 (n6934 n5964 vss vss) n12 w=1.6u l=0.13u
MP6937 (n6933 cd4 vdd vdd) p12 w=2.4u l=0.13u
MP6938 (n6933 n5964 vdd vdd) p12 w=2.4u l=0.13u
MN6941 (n6939 dd4 n6940 vss) n12 w=1.6u l=0.13u
MN6942 (n6940 n5967 vss vss) n12 w=1.6u l=0.13u
MP6943 (n6939 dd4 vdd vdd) p12 w=2.4u l=0.13u
MP6944 (n6939 n5967 vdd vdd) p12 w=2.4u l=0.13u
MN6947 (n6945 n6933 n6946 vss) n12 w=1.6u l=0.13u
MN6948 (n6946 n6939 vss vss) n12 w=1.6u l=0.13u
MP6949 (n6945 n6933 vdd vdd) p12 w=2.4u l=0.13u
MP6950 (n6945 n6939 vdd vdd) p12 w=2.4u l=0.13u
MN6955 (n6945 n93 storage6954 vss) n12 w=1.2u l=0.13u
MP6956 (n6945 n105 storage6954 vdd) p12 w=3.6u l=0.13u
MN6957 (qm6951 n102 storage6954 vss) n12 w=1.2u l=0.13u
MP6958 (qm6951 n108 storage6954 vdd) p12 w=3.6u l=0.13u
MN6959 (qmb6952 storage6954 vss vss) n12 w=0.5u l=0.13u
MP6960 (qmb6952 storage6954 vdd vdd) p12 w=1.5u l=0.13u
MN6961 (qm6951 qmb6952 vss vss) n12 w=0.5u l=0.13u
MP6962 (qm6951 qmb6952 vdd vdd) p12 w=1.5u l=0.13u
MN6963 (storage6954 rst vss vss) n12 w=2u l=0.13u
MN6965 (qm6951 n102 storage6964 vss) n12 w=1.2u l=0.13u
MP6966 (qm6951 n108 storage6964 vdd) p12 w=3.6u l=0.13u
MN6967 (dd4 n93 storage6964 vss) n12 w=1.2u l=0.13u
MP6968 (dd4 n105 storage6964 vdd) p12 w=3.6u l=0.13u
MN6969 (qb6953 storage6964 vss vss) n12 w=0.5u l=0.13u
MP6970 (qb6953 storage6964 vdd vdd) p12 w=1.5u l=0.13u
MN6971 (dd4 qb6953 vss vss) n12 w=0.5u l=0.13u
MP6972 (dd4 qb6953 vdd vdd) p12 w=1.5u l=0.13u
MN6973 (storage6964 rst vss vss) n12 w=2u l=0.13u
MN6976 (n6974 cd5 n6975 vss) n12 w=1.6u l=0.13u
MN6977 (n6975 n5964 vss vss) n12 w=1.6u l=0.13u
MP6978 (n6974 cd5 vdd vdd) p12 w=2.4u l=0.13u
MP6979 (n6974 n5964 vdd vdd) p12 w=2.4u l=0.13u
MN6982 (n6980 dd5 n6981 vss) n12 w=1.6u l=0.13u
MN6983 (n6981 n5967 vss vss) n12 w=1.6u l=0.13u
MP6984 (n6980 dd5 vdd vdd) p12 w=2.4u l=0.13u
MP6985 (n6980 n5967 vdd vdd) p12 w=2.4u l=0.13u
MN6988 (n6986 n6974 n6987 vss) n12 w=1.6u l=0.13u
MN6989 (n6987 n6980 vss vss) n12 w=1.6u l=0.13u
MP6990 (n6986 n6974 vdd vdd) p12 w=2.4u l=0.13u
MP6991 (n6986 n6980 vdd vdd) p12 w=2.4u l=0.13u
MN6996 (n6986 n93 storage6995 vss) n12 w=1.2u l=0.13u
MP6997 (n6986 n105 storage6995 vdd) p12 w=3.6u l=0.13u
MN6998 (qm6992 n102 storage6995 vss) n12 w=1.2u l=0.13u
MP6999 (qm6992 n108 storage6995 vdd) p12 w=3.6u l=0.13u
MN7000 (qmb6993 storage6995 vss vss) n12 w=0.5u l=0.13u
MP7001 (qmb6993 storage6995 vdd vdd) p12 w=1.5u l=0.13u
MN7002 (qm6992 qmb6993 vss vss) n12 w=0.5u l=0.13u
MP7003 (qm6992 qmb6993 vdd vdd) p12 w=1.5u l=0.13u
MN7004 (storage6995 rst vss vss) n12 w=2u l=0.13u
MN7006 (qm6992 n102 storage7005 vss) n12 w=1.2u l=0.13u
MP7007 (qm6992 n108 storage7005 vdd) p12 w=3.6u l=0.13u
MN7008 (dd5 n93 storage7005 vss) n12 w=1.2u l=0.13u
MP7009 (dd5 n105 storage7005 vdd) p12 w=3.6u l=0.13u
MN7010 (qb6994 storage7005 vss vss) n12 w=0.5u l=0.13u
MP7011 (qb6994 storage7005 vdd vdd) p12 w=1.5u l=0.13u
MN7012 (dd5 qb6994 vss vss) n12 w=0.5u l=0.13u
MP7013 (dd5 qb6994 vdd vdd) p12 w=1.5u l=0.13u
MN7014 (storage7005 rst vss vss) n12 w=2u l=0.13u
MN7017 (n7015 cd6 n7016 vss) n12 w=1.6u l=0.13u
MN7018 (n7016 n5964 vss vss) n12 w=1.6u l=0.13u
MP7019 (n7015 cd6 vdd vdd) p12 w=2.4u l=0.13u
MP7020 (n7015 n5964 vdd vdd) p12 w=2.4u l=0.13u
MN7023 (n7021 dd6 n7022 vss) n12 w=1.6u l=0.13u
MN7024 (n7022 n5967 vss vss) n12 w=1.6u l=0.13u
MP7025 (n7021 dd6 vdd vdd) p12 w=2.4u l=0.13u
MP7026 (n7021 n5967 vdd vdd) p12 w=2.4u l=0.13u
MN7029 (n7027 n7015 n7028 vss) n12 w=1.6u l=0.13u
MN7030 (n7028 n7021 vss vss) n12 w=1.6u l=0.13u
MP7031 (n7027 n7015 vdd vdd) p12 w=2.4u l=0.13u
MP7032 (n7027 n7021 vdd vdd) p12 w=2.4u l=0.13u
MN7037 (n7027 n93 storage7036 vss) n12 w=1.2u l=0.13u
MP7038 (n7027 n105 storage7036 vdd) p12 w=3.6u l=0.13u
MN7039 (qm7033 n102 storage7036 vss) n12 w=1.2u l=0.13u
MP7040 (qm7033 n108 storage7036 vdd) p12 w=3.6u l=0.13u
MN7041 (qmb7034 storage7036 vss vss) n12 w=0.5u l=0.13u
MP7042 (qmb7034 storage7036 vdd vdd) p12 w=1.5u l=0.13u
MN7043 (qm7033 qmb7034 vss vss) n12 w=0.5u l=0.13u
MP7044 (qm7033 qmb7034 vdd vdd) p12 w=1.5u l=0.13u
MN7045 (storage7036 rst vss vss) n12 w=2u l=0.13u
MN7047 (qm7033 n102 storage7046 vss) n12 w=1.2u l=0.13u
MP7048 (qm7033 n108 storage7046 vdd) p12 w=3.6u l=0.13u
MN7049 (dd6 n93 storage7046 vss) n12 w=1.2u l=0.13u
MP7050 (dd6 n105 storage7046 vdd) p12 w=3.6u l=0.13u
MN7051 (qb7035 storage7046 vss vss) n12 w=0.5u l=0.13u
MP7052 (qb7035 storage7046 vdd vdd) p12 w=1.5u l=0.13u
MN7053 (dd6 qb7035 vss vss) n12 w=0.5u l=0.13u
MP7054 (dd6 qb7035 vdd vdd) p12 w=1.5u l=0.13u
MN7055 (storage7046 rst vss vss) n12 w=2u l=0.13u
MN7058 (n7056 cd7 n7057 vss) n12 w=1.6u l=0.13u
MN7059 (n7057 n5964 vss vss) n12 w=1.6u l=0.13u
MP7060 (n7056 cd7 vdd vdd) p12 w=2.4u l=0.13u
MP7061 (n7056 n5964 vdd vdd) p12 w=2.4u l=0.13u
MN7064 (n7062 dd7 n7063 vss) n12 w=1.6u l=0.13u
MN7065 (n7063 n5967 vss vss) n12 w=1.6u l=0.13u
MP7066 (n7062 dd7 vdd vdd) p12 w=2.4u l=0.13u
MP7067 (n7062 n5967 vdd vdd) p12 w=2.4u l=0.13u
MN7070 (n7068 n7056 n7069 vss) n12 w=1.6u l=0.13u
MN7071 (n7069 n7062 vss vss) n12 w=1.6u l=0.13u
MP7072 (n7068 n7056 vdd vdd) p12 w=2.4u l=0.13u
MP7073 (n7068 n7062 vdd vdd) p12 w=2.4u l=0.13u
MN7078 (n7068 n93 storage7077 vss) n12 w=1.2u l=0.13u
MP7079 (n7068 n105 storage7077 vdd) p12 w=3.6u l=0.13u
MN7080 (qm7074 n102 storage7077 vss) n12 w=1.2u l=0.13u
MP7081 (qm7074 n108 storage7077 vdd) p12 w=3.6u l=0.13u
MN7082 (qmb7075 storage7077 vss vss) n12 w=0.5u l=0.13u
MP7083 (qmb7075 storage7077 vdd vdd) p12 w=1.5u l=0.13u
MN7084 (qm7074 qmb7075 vss vss) n12 w=0.5u l=0.13u
MP7085 (qm7074 qmb7075 vdd vdd) p12 w=1.5u l=0.13u
MN7086 (storage7077 rst vss vss) n12 w=2u l=0.13u
MN7088 (qm7074 n102 storage7087 vss) n12 w=1.2u l=0.13u
MP7089 (qm7074 n108 storage7087 vdd) p12 w=3.6u l=0.13u
MN7090 (dd7 n93 storage7087 vss) n12 w=1.2u l=0.13u
MP7091 (dd7 n105 storage7087 vdd) p12 w=3.6u l=0.13u
MN7092 (qb7076 storage7087 vss vss) n12 w=0.5u l=0.13u
MP7093 (qb7076 storage7087 vdd vdd) p12 w=1.5u l=0.13u
MN7094 (dd7 qb7076 vss vss) n12 w=0.5u l=0.13u
MP7095 (dd7 qb7076 vdd vdd) p12 w=1.5u l=0.13u
MN7096 (storage7087 rst vss vss) n12 w=2u l=0.13u
MN7098 (n7097 settle vss vss) n12 w=0.8u l=0.13u
MP7099 (n7097 settle vdd vdd) p12 w=2.4u l=0.13u
MN7102 (n7100 n7097 vss vss) n12 w=0.8u l=0.13u
MN7103 (n7100 rst vss vss) n12 w=0.8u l=0.13u
MP7104 (n7100 n7097 n7101 vdd) p12 w=4.8u l=0.13u
MP7105 (n7101 rst vdd vdd) p12 w=4.8u l=0.13u
MN7107 (n7106 n7100 vss vss) n12 w=0.8u l=0.13u
MP7108 (n7106 n7100 vdd vdd) p12 w=2.4u l=0.13u
MN7110 (n7109 settletick0 vss vss) n12 w=0.8u l=0.13u
MP7111 (n7109 settletick0 vdd vdd) p12 w=2.4u l=0.13u
MN7113 (n7112 n7106 vss vss) n12 w=0.8u l=0.13u
MP7114 (n7112 n7106 vdd vdd) p12 w=2.4u l=0.13u
MN7117 (n7115 n22 n7116 vss) n12 w=1.6u l=0.13u
MN7118 (n7116 n7112 vss vss) n12 w=1.6u l=0.13u
MP7119 (n7115 n22 vdd vdd) p12 w=2.4u l=0.13u
MP7120 (n7115 n7112 vdd vdd) p12 w=2.4u l=0.13u
MN7122 (n7121 n7115 vss vss) n12 w=0.8u l=0.13u
MP7123 (n7121 n7115 vdd vdd) p12 w=2.4u l=0.13u
MN7126 (n7124 n19 n7125 vss) n12 w=1.6u l=0.13u
MN7127 (n7125 n7112 vss vss) n12 w=1.6u l=0.13u
MP7128 (n7124 n19 vdd vdd) p12 w=2.4u l=0.13u
MP7129 (n7124 n7112 vdd vdd) p12 w=2.4u l=0.13u
MN7131 (n7130 n7124 vss vss) n12 w=0.8u l=0.13u
MP7132 (n7130 n7124 vdd vdd) p12 w=2.4u l=0.13u
MN7134 (n7133 n7121 vss vss) n12 w=0.8u l=0.13u
MP7135 (n7133 n7121 vdd vdd) p12 w=2.4u l=0.13u
MN7137 (n7136 n7130 vss vss) n12 w=0.8u l=0.13u
MP7138 (n7136 n7130 vdd vdd) p12 w=2.4u l=0.13u
MN7143 (n7109 n7121 storage7142 vss) n12 w=1.2u l=0.13u
MP7144 (n7109 n7133 storage7142 vdd) p12 w=3.6u l=0.13u
MN7145 (qm7139 n7130 storage7142 vss) n12 w=1.2u l=0.13u
MP7146 (qm7139 n7136 storage7142 vdd) p12 w=3.6u l=0.13u
MN7147 (qmb7140 storage7142 vss vss) n12 w=0.5u l=0.13u
MP7148 (qmb7140 storage7142 vdd vdd) p12 w=1.5u l=0.13u
MN7149 (qm7139 qmb7140 vss vss) n12 w=0.5u l=0.13u
MP7150 (qm7139 qmb7140 vdd vdd) p12 w=1.5u l=0.13u
MN7151 (storage7142 n7106 vss vss) n12 w=2u l=0.13u
MN7153 (qm7139 n7130 storage7152 vss) n12 w=1.2u l=0.13u
MP7154 (qm7139 n7136 storage7152 vdd) p12 w=3.6u l=0.13u
MN7155 (settletick0 n7121 storage7152 vss) n12 w=1.2u l=0.13u
MP7156 (settletick0 n7133 storage7152 vdd) p12 w=3.6u l=0.13u
MN7157 (qb7141 storage7152 vss vss) n12 w=0.5u l=0.13u
MP7158 (qb7141 storage7152 vdd vdd) p12 w=1.5u l=0.13u
MN7159 (settletick0 qb7141 vss vss) n12 w=0.5u l=0.13u
MP7160 (settletick0 qb7141 vdd vdd) p12 w=1.5u l=0.13u
MN7161 (storage7152 n7106 vss vss) n12 w=2u l=0.13u
MN7164 (n7162 settletick0 n7163 vss) n12 w=1.6u l=0.13u
MN7165 (n7163 settletick1 vss vss) n12 w=1.6u l=0.13u
MP7166 (n7162 settletick0 vdd vdd) p12 w=2.4u l=0.13u
MP7167 (n7162 settletick1 vdd vdd) p12 w=2.4u l=0.13u
MN7170 (n7168 n7162 n7169 vss) n12 w=1.6u l=0.13u
MN7171 (n7169 settletick0 vss vss) n12 w=1.6u l=0.13u
MP7172 (n7168 n7162 vdd vdd) p12 w=2.4u l=0.13u
MP7173 (n7168 settletick0 vdd vdd) p12 w=2.4u l=0.13u
MN7176 (n7174 n7162 n7175 vss) n12 w=1.6u l=0.13u
MN7177 (n7175 settletick1 vss vss) n12 w=1.6u l=0.13u
MP7178 (n7174 n7162 vdd vdd) p12 w=2.4u l=0.13u
MP7179 (n7174 settletick1 vdd vdd) p12 w=2.4u l=0.13u
MN7182 (n7180 n7168 n7181 vss) n12 w=1.6u l=0.13u
MN7183 (n7181 n7174 vss vss) n12 w=1.6u l=0.13u
MP7184 (n7180 n7168 vdd vdd) p12 w=2.4u l=0.13u
MP7185 (n7180 n7174 vdd vdd) p12 w=2.4u l=0.13u
MN7187 (n7186 n7162 vss vss) n12 w=0.8u l=0.13u
MP7188 (n7186 n7162 vdd vdd) p12 w=2.4u l=0.13u
MN7193 (n7180 n7121 storage7192 vss) n12 w=1.2u l=0.13u
MP7194 (n7180 n7133 storage7192 vdd) p12 w=3.6u l=0.13u
MN7195 (qm7189 n7130 storage7192 vss) n12 w=1.2u l=0.13u
MP7196 (qm7189 n7136 storage7192 vdd) p12 w=3.6u l=0.13u
MN7197 (qmb7190 storage7192 vss vss) n12 w=0.5u l=0.13u
MP7198 (qmb7190 storage7192 vdd vdd) p12 w=1.5u l=0.13u
MN7199 (qm7189 qmb7190 vss vss) n12 w=0.5u l=0.13u
MP7200 (qm7189 qmb7190 vdd vdd) p12 w=1.5u l=0.13u
MN7201 (storage7192 n7106 vss vss) n12 w=2u l=0.13u
MN7203 (qm7189 n7130 storage7202 vss) n12 w=1.2u l=0.13u
MP7204 (qm7189 n7136 storage7202 vdd) p12 w=3.6u l=0.13u
MN7205 (settletick1 n7121 storage7202 vss) n12 w=1.2u l=0.13u
MP7206 (settletick1 n7133 storage7202 vdd) p12 w=3.6u l=0.13u
MN7207 (qb7191 storage7202 vss vss) n12 w=0.5u l=0.13u
MP7208 (qb7191 storage7202 vdd vdd) p12 w=1.5u l=0.13u
MN7209 (settletick1 qb7191 vss vss) n12 w=0.5u l=0.13u
MP7210 (settletick1 qb7191 vdd vdd) p12 w=1.5u l=0.13u
MN7211 (storage7202 n7106 vss vss) n12 w=2u l=0.13u
MN7214 (n7212 n7186 n7213 vss) n12 w=1.6u l=0.13u
MN7215 (n7213 settletick2 vss vss) n12 w=1.6u l=0.13u
MP7216 (n7212 n7186 vdd vdd) p12 w=2.4u l=0.13u
MP7217 (n7212 settletick2 vdd vdd) p12 w=2.4u l=0.13u
MN7220 (n7218 n7186 n7219 vss) n12 w=1.6u l=0.13u
MN7221 (n7219 n7212 vss vss) n12 w=1.6u l=0.13u
MP7222 (n7218 n7186 vdd vdd) p12 w=2.4u l=0.13u
MP7223 (n7218 n7212 vdd vdd) p12 w=2.4u l=0.13u
MN7226 (n7224 n7212 n7225 vss) n12 w=1.6u l=0.13u
MN7227 (n7225 settletick2 vss vss) n12 w=1.6u l=0.13u
MP7228 (n7224 n7212 vdd vdd) p12 w=2.4u l=0.13u
MP7229 (n7224 settletick2 vdd vdd) p12 w=2.4u l=0.13u
MN7232 (n7230 n7218 n7231 vss) n12 w=1.6u l=0.13u
MN7233 (n7231 n7224 vss vss) n12 w=1.6u l=0.13u
MP7234 (n7230 n7218 vdd vdd) p12 w=2.4u l=0.13u
MP7235 (n7230 n7224 vdd vdd) p12 w=2.4u l=0.13u
MN7237 (n7236 n7212 vss vss) n12 w=0.8u l=0.13u
MP7238 (n7236 n7212 vdd vdd) p12 w=2.4u l=0.13u
MN7243 (n7230 n7121 storage7242 vss) n12 w=1.2u l=0.13u
MP7244 (n7230 n7133 storage7242 vdd) p12 w=3.6u l=0.13u
MN7245 (qm7239 n7130 storage7242 vss) n12 w=1.2u l=0.13u
MP7246 (qm7239 n7136 storage7242 vdd) p12 w=3.6u l=0.13u
MN7247 (qmb7240 storage7242 vss vss) n12 w=0.5u l=0.13u
MP7248 (qmb7240 storage7242 vdd vdd) p12 w=1.5u l=0.13u
MN7249 (qm7239 qmb7240 vss vss) n12 w=0.5u l=0.13u
MP7250 (qm7239 qmb7240 vdd vdd) p12 w=1.5u l=0.13u
MN7251 (storage7242 n7106 vss vss) n12 w=2u l=0.13u
MN7253 (qm7239 n7130 storage7252 vss) n12 w=1.2u l=0.13u
MP7254 (qm7239 n7136 storage7252 vdd) p12 w=3.6u l=0.13u
MN7255 (settletick2 n7121 storage7252 vss) n12 w=1.2u l=0.13u
MP7256 (settletick2 n7133 storage7252 vdd) p12 w=3.6u l=0.13u
MN7257 (qb7241 storage7252 vss vss) n12 w=0.5u l=0.13u
MP7258 (qb7241 storage7252 vdd vdd) p12 w=1.5u l=0.13u
MN7259 (settletick2 qb7241 vss vss) n12 w=0.5u l=0.13u
MP7260 (settletick2 qb7241 vdd vdd) p12 w=1.5u l=0.13u
MN7261 (storage7252 n7106 vss vss) n12 w=2u l=0.13u
MN7263 (n7262 settletick2 vss vss) n12 w=0.8u l=0.13u
MP7264 (n7262 settletick2 vdd vdd) p12 w=2.4u l=0.13u
MN7267 (n7265 settle n7266 vss) n12 w=1.6u l=0.13u
MN7268 (n7266 settletick0 vss vss) n12 w=1.6u l=0.13u
MP7269 (n7265 settle vdd vdd) p12 w=2.4u l=0.13u
MP7270 (n7265 settletick0 vdd vdd) p12 w=2.4u l=0.13u
MN7272 (n7271 n7265 vss vss) n12 w=0.8u l=0.13u
MP7273 (n7271 n7265 vdd vdd) p12 w=2.4u l=0.13u
MN7276 (n7274 n7262 n7275 vss) n12 w=1.6u l=0.13u
MN7277 (n7275 settletick1 vss vss) n12 w=1.6u l=0.13u
MP7278 (n7274 n7262 vdd vdd) p12 w=2.4u l=0.13u
MP7279 (n7274 settletick1 vdd vdd) p12 w=2.4u l=0.13u
MN7281 (n7280 n7274 vss vss) n12 w=0.8u l=0.13u
MP7282 (n7280 n7274 vdd vdd) p12 w=2.4u l=0.13u
MN7285 (n7283 n7271 n7284 vss) n12 w=1.6u l=0.13u
MN7286 (n7284 n7280 vss vss) n12 w=1.6u l=0.13u
MP7287 (n7283 n7271 vdd vdd) p12 w=2.4u l=0.13u
MP7288 (n7283 n7280 vdd vdd) p12 w=2.4u l=0.13u
MN7290 (n7289 n7283 vss vss) n12 w=0.8u l=0.13u
MP7291 (n7289 n7283 vdd vdd) p12 w=2.4u l=0.13u
MN7293 (n7292 arm vss vss) n12 w=0.8u l=0.13u
MP7294 (n7292 arm vdd vdd) p12 w=2.4u l=0.13u
MN7297 (n7295 n7292 vss vss) n12 w=0.8u l=0.13u
MN7298 (n7295 rst vss vss) n12 w=0.8u l=0.13u
MP7299 (n7295 n7292 n7296 vdd) p12 w=4.8u l=0.13u
MP7300 (n7296 rst vdd vdd) p12 w=4.8u l=0.13u
MN7302 (n7301 n7295 vss vss) n12 w=0.8u l=0.13u
MP7303 (n7301 n7295 vdd vdd) p12 w=2.4u l=0.13u
MN7305 (n7304 armtick0 vss vss) n12 w=0.8u l=0.13u
MP7306 (n7304 armtick0 vdd vdd) p12 w=2.4u l=0.13u
MN7308 (n7307 n7301 vss vss) n12 w=0.8u l=0.13u
MP7309 (n7307 n7301 vdd vdd) p12 w=2.4u l=0.13u
MN7312 (n7310 n22 n7311 vss) n12 w=1.6u l=0.13u
MN7313 (n7311 n7307 vss vss) n12 w=1.6u l=0.13u
MP7314 (n7310 n22 vdd vdd) p12 w=2.4u l=0.13u
MP7315 (n7310 n7307 vdd vdd) p12 w=2.4u l=0.13u
MN7317 (n7316 n7310 vss vss) n12 w=0.8u l=0.13u
MP7318 (n7316 n7310 vdd vdd) p12 w=2.4u l=0.13u
MN7321 (n7319 n19 n7320 vss) n12 w=1.6u l=0.13u
MN7322 (n7320 n7307 vss vss) n12 w=1.6u l=0.13u
MP7323 (n7319 n19 vdd vdd) p12 w=2.4u l=0.13u
MP7324 (n7319 n7307 vdd vdd) p12 w=2.4u l=0.13u
MN7326 (n7325 n7319 vss vss) n12 w=0.8u l=0.13u
MP7327 (n7325 n7319 vdd vdd) p12 w=2.4u l=0.13u
MN7329 (n7328 n7316 vss vss) n12 w=0.8u l=0.13u
MP7330 (n7328 n7316 vdd vdd) p12 w=2.4u l=0.13u
MN7332 (n7331 n7325 vss vss) n12 w=0.8u l=0.13u
MP7333 (n7331 n7325 vdd vdd) p12 w=2.4u l=0.13u
MN7338 (n7304 n7316 storage7337 vss) n12 w=1.2u l=0.13u
MP7339 (n7304 n7328 storage7337 vdd) p12 w=3.6u l=0.13u
MN7340 (qm7334 n7325 storage7337 vss) n12 w=1.2u l=0.13u
MP7341 (qm7334 n7331 storage7337 vdd) p12 w=3.6u l=0.13u
MN7342 (qmb7335 storage7337 vss vss) n12 w=0.5u l=0.13u
MP7343 (qmb7335 storage7337 vdd vdd) p12 w=1.5u l=0.13u
MN7344 (qm7334 qmb7335 vss vss) n12 w=0.5u l=0.13u
MP7345 (qm7334 qmb7335 vdd vdd) p12 w=1.5u l=0.13u
MN7346 (storage7337 n7301 vss vss) n12 w=2u l=0.13u
MN7348 (qm7334 n7325 storage7347 vss) n12 w=1.2u l=0.13u
MP7349 (qm7334 n7331 storage7347 vdd) p12 w=3.6u l=0.13u
MN7350 (armtick0 n7316 storage7347 vss) n12 w=1.2u l=0.13u
MP7351 (armtick0 n7328 storage7347 vdd) p12 w=3.6u l=0.13u
MN7352 (qb7336 storage7347 vss vss) n12 w=0.5u l=0.13u
MP7353 (qb7336 storage7347 vdd vdd) p12 w=1.5u l=0.13u
MN7354 (armtick0 qb7336 vss vss) n12 w=0.5u l=0.13u
MP7355 (armtick0 qb7336 vdd vdd) p12 w=1.5u l=0.13u
MN7356 (storage7347 n7301 vss vss) n12 w=2u l=0.13u
MN7359 (n7357 armtick0 n7358 vss) n12 w=1.6u l=0.13u
MN7360 (n7358 armtick1 vss vss) n12 w=1.6u l=0.13u
MP7361 (n7357 armtick0 vdd vdd) p12 w=2.4u l=0.13u
MP7362 (n7357 armtick1 vdd vdd) p12 w=2.4u l=0.13u
MN7365 (n7363 armtick0 n7364 vss) n12 w=1.6u l=0.13u
MN7366 (n7364 n7357 vss vss) n12 w=1.6u l=0.13u
MP7367 (n7363 armtick0 vdd vdd) p12 w=2.4u l=0.13u
MP7368 (n7363 n7357 vdd vdd) p12 w=2.4u l=0.13u
MN7371 (n7369 armtick1 n7370 vss) n12 w=1.6u l=0.13u
MN7372 (n7370 n7357 vss vss) n12 w=1.6u l=0.13u
MP7373 (n7369 armtick1 vdd vdd) p12 w=2.4u l=0.13u
MP7374 (n7369 n7357 vdd vdd) p12 w=2.4u l=0.13u
MN7377 (n7375 n7363 n7376 vss) n12 w=1.6u l=0.13u
MN7378 (n7376 n7369 vss vss) n12 w=1.6u l=0.13u
MP7379 (n7375 n7363 vdd vdd) p12 w=2.4u l=0.13u
MP7380 (n7375 n7369 vdd vdd) p12 w=2.4u l=0.13u
MN7382 (n7381 n7357 vss vss) n12 w=0.8u l=0.13u
MP7383 (n7381 n7357 vdd vdd) p12 w=2.4u l=0.13u
MN7388 (n7375 n7316 storage7387 vss) n12 w=1.2u l=0.13u
MP7389 (n7375 n7328 storage7387 vdd) p12 w=3.6u l=0.13u
MN7390 (qm7384 n7325 storage7387 vss) n12 w=1.2u l=0.13u
MP7391 (qm7384 n7331 storage7387 vdd) p12 w=3.6u l=0.13u
MN7392 (qmb7385 storage7387 vss vss) n12 w=0.5u l=0.13u
MP7393 (qmb7385 storage7387 vdd vdd) p12 w=1.5u l=0.13u
MN7394 (qm7384 qmb7385 vss vss) n12 w=0.5u l=0.13u
MP7395 (qm7384 qmb7385 vdd vdd) p12 w=1.5u l=0.13u
MN7396 (storage7387 n7301 vss vss) n12 w=2u l=0.13u
MN7398 (qm7384 n7325 storage7397 vss) n12 w=1.2u l=0.13u
MP7399 (qm7384 n7331 storage7397 vdd) p12 w=3.6u l=0.13u
MN7400 (armtick1 n7316 storage7397 vss) n12 w=1.2u l=0.13u
MP7401 (armtick1 n7328 storage7397 vdd) p12 w=3.6u l=0.13u
MN7402 (qb7386 storage7397 vss vss) n12 w=0.5u l=0.13u
MP7403 (qb7386 storage7397 vdd vdd) p12 w=1.5u l=0.13u
MN7404 (armtick1 qb7386 vss vss) n12 w=0.5u l=0.13u
MP7405 (armtick1 qb7386 vdd vdd) p12 w=1.5u l=0.13u
MN7406 (storage7397 n7301 vss vss) n12 w=2u l=0.13u
MN7409 (n7407 armtick2 n7408 vss) n12 w=1.6u l=0.13u
MN7410 (n7408 n7381 vss vss) n12 w=1.6u l=0.13u
MP7411 (n7407 armtick2 vdd vdd) p12 w=2.4u l=0.13u
MP7412 (n7407 n7381 vdd vdd) p12 w=2.4u l=0.13u
MN7415 (n7413 armtick2 n7414 vss) n12 w=1.6u l=0.13u
MN7416 (n7414 n7407 vss vss) n12 w=1.6u l=0.13u
MP7417 (n7413 armtick2 vdd vdd) p12 w=2.4u l=0.13u
MP7418 (n7413 n7407 vdd vdd) p12 w=2.4u l=0.13u
MN7421 (n7419 n7381 n7420 vss) n12 w=1.6u l=0.13u
MN7422 (n7420 n7407 vss vss) n12 w=1.6u l=0.13u
MP7423 (n7419 n7381 vdd vdd) p12 w=2.4u l=0.13u
MP7424 (n7419 n7407 vdd vdd) p12 w=2.4u l=0.13u
MN7427 (n7425 n7413 n7426 vss) n12 w=1.6u l=0.13u
MN7428 (n7426 n7419 vss vss) n12 w=1.6u l=0.13u
MP7429 (n7425 n7413 vdd vdd) p12 w=2.4u l=0.13u
MP7430 (n7425 n7419 vdd vdd) p12 w=2.4u l=0.13u
MN7432 (n7431 n7407 vss vss) n12 w=0.8u l=0.13u
MP7433 (n7431 n7407 vdd vdd) p12 w=2.4u l=0.13u
MN7438 (n7425 n7316 storage7437 vss) n12 w=1.2u l=0.13u
MP7439 (n7425 n7328 storage7437 vdd) p12 w=3.6u l=0.13u
MN7440 (qm7434 n7325 storage7437 vss) n12 w=1.2u l=0.13u
MP7441 (qm7434 n7331 storage7437 vdd) p12 w=3.6u l=0.13u
MN7442 (qmb7435 storage7437 vss vss) n12 w=0.5u l=0.13u
MP7443 (qmb7435 storage7437 vdd vdd) p12 w=1.5u l=0.13u
MN7444 (qm7434 qmb7435 vss vss) n12 w=0.5u l=0.13u
MP7445 (qm7434 qmb7435 vdd vdd) p12 w=1.5u l=0.13u
MN7446 (storage7437 n7301 vss vss) n12 w=2u l=0.13u
MN7448 (qm7434 n7325 storage7447 vss) n12 w=1.2u l=0.13u
MP7449 (qm7434 n7331 storage7447 vdd) p12 w=3.6u l=0.13u
MN7450 (armtick2 n7316 storage7447 vss) n12 w=1.2u l=0.13u
MP7451 (armtick2 n7328 storage7447 vdd) p12 w=3.6u l=0.13u
MN7452 (qb7436 storage7447 vss vss) n12 w=0.5u l=0.13u
MP7453 (qb7436 storage7447 vdd vdd) p12 w=1.5u l=0.13u
MN7454 (armtick2 qb7436 vss vss) n12 w=0.5u l=0.13u
MP7455 (armtick2 qb7436 vdd vdd) p12 w=1.5u l=0.13u
MN7456 (storage7447 n7301 vss vss) n12 w=2u l=0.13u
MN7459 (n7457 armtick3 n7458 vss) n12 w=1.6u l=0.13u
MN7460 (n7458 n7431 vss vss) n12 w=1.6u l=0.13u
MP7461 (n7457 armtick3 vdd vdd) p12 w=2.4u l=0.13u
MP7462 (n7457 n7431 vdd vdd) p12 w=2.4u l=0.13u
MN7465 (n7463 armtick3 n7464 vss) n12 w=1.6u l=0.13u
MN7466 (n7464 n7457 vss vss) n12 w=1.6u l=0.13u
MP7467 (n7463 armtick3 vdd vdd) p12 w=2.4u l=0.13u
MP7468 (n7463 n7457 vdd vdd) p12 w=2.4u l=0.13u
MN7471 (n7469 n7431 n7470 vss) n12 w=1.6u l=0.13u
MN7472 (n7470 n7457 vss vss) n12 w=1.6u l=0.13u
MP7473 (n7469 n7431 vdd vdd) p12 w=2.4u l=0.13u
MP7474 (n7469 n7457 vdd vdd) p12 w=2.4u l=0.13u
MN7477 (n7475 n7463 n7476 vss) n12 w=1.6u l=0.13u
MN7478 (n7476 n7469 vss vss) n12 w=1.6u l=0.13u
MP7479 (n7475 n7463 vdd vdd) p12 w=2.4u l=0.13u
MP7480 (n7475 n7469 vdd vdd) p12 w=2.4u l=0.13u
MN7482 (n7481 n7457 vss vss) n12 w=0.8u l=0.13u
MP7483 (n7481 n7457 vdd vdd) p12 w=2.4u l=0.13u
MN7488 (n7475 n7316 storage7487 vss) n12 w=1.2u l=0.13u
MP7489 (n7475 n7328 storage7487 vdd) p12 w=3.6u l=0.13u
MN7490 (qm7484 n7325 storage7487 vss) n12 w=1.2u l=0.13u
MP7491 (qm7484 n7331 storage7487 vdd) p12 w=3.6u l=0.13u
MN7492 (qmb7485 storage7487 vss vss) n12 w=0.5u l=0.13u
MP7493 (qmb7485 storage7487 vdd vdd) p12 w=1.5u l=0.13u
MN7494 (qm7484 qmb7485 vss vss) n12 w=0.5u l=0.13u
MP7495 (qm7484 qmb7485 vdd vdd) p12 w=1.5u l=0.13u
MN7496 (storage7487 n7301 vss vss) n12 w=2u l=0.13u
MN7498 (qm7484 n7325 storage7497 vss) n12 w=1.2u l=0.13u
MP7499 (qm7484 n7331 storage7497 vdd) p12 w=3.6u l=0.13u
MN7500 (armtick3 n7316 storage7497 vss) n12 w=1.2u l=0.13u
MP7501 (armtick3 n7328 storage7497 vdd) p12 w=3.6u l=0.13u
MN7502 (qb7486 storage7497 vss vss) n12 w=0.5u l=0.13u
MP7503 (qb7486 storage7497 vdd vdd) p12 w=1.5u l=0.13u
MN7504 (armtick3 qb7486 vss vss) n12 w=0.5u l=0.13u
MP7505 (armtick3 qb7486 vdd vdd) p12 w=1.5u l=0.13u
MN7506 (storage7497 n7301 vss vss) n12 w=2u l=0.13u
MN7509 (n7507 armtick4 n7508 vss) n12 w=1.6u l=0.13u
MN7510 (n7508 n7481 vss vss) n12 w=1.6u l=0.13u
MP7511 (n7507 armtick4 vdd vdd) p12 w=2.4u l=0.13u
MP7512 (n7507 n7481 vdd vdd) p12 w=2.4u l=0.13u
MN7515 (n7513 armtick4 n7514 vss) n12 w=1.6u l=0.13u
MN7516 (n7514 n7507 vss vss) n12 w=1.6u l=0.13u
MP7517 (n7513 armtick4 vdd vdd) p12 w=2.4u l=0.13u
MP7518 (n7513 n7507 vdd vdd) p12 w=2.4u l=0.13u
MN7521 (n7519 n7481 n7520 vss) n12 w=1.6u l=0.13u
MN7522 (n7520 n7507 vss vss) n12 w=1.6u l=0.13u
MP7523 (n7519 n7481 vdd vdd) p12 w=2.4u l=0.13u
MP7524 (n7519 n7507 vdd vdd) p12 w=2.4u l=0.13u
MN7527 (n7525 n7513 n7526 vss) n12 w=1.6u l=0.13u
MN7528 (n7526 n7519 vss vss) n12 w=1.6u l=0.13u
MP7529 (n7525 n7513 vdd vdd) p12 w=2.4u l=0.13u
MP7530 (n7525 n7519 vdd vdd) p12 w=2.4u l=0.13u
MN7532 (n7531 n7507 vss vss) n12 w=0.8u l=0.13u
MP7533 (n7531 n7507 vdd vdd) p12 w=2.4u l=0.13u
MN7538 (n7525 n7316 storage7537 vss) n12 w=1.2u l=0.13u
MP7539 (n7525 n7328 storage7537 vdd) p12 w=3.6u l=0.13u
MN7540 (qm7534 n7325 storage7537 vss) n12 w=1.2u l=0.13u
MP7541 (qm7534 n7331 storage7537 vdd) p12 w=3.6u l=0.13u
MN7542 (qmb7535 storage7537 vss vss) n12 w=0.5u l=0.13u
MP7543 (qmb7535 storage7537 vdd vdd) p12 w=1.5u l=0.13u
MN7544 (qm7534 qmb7535 vss vss) n12 w=0.5u l=0.13u
MP7545 (qm7534 qmb7535 vdd vdd) p12 w=1.5u l=0.13u
MN7546 (storage7537 n7301 vss vss) n12 w=2u l=0.13u
MN7548 (qm7534 n7325 storage7547 vss) n12 w=1.2u l=0.13u
MP7549 (qm7534 n7331 storage7547 vdd) p12 w=3.6u l=0.13u
MN7550 (armtick4 n7316 storage7547 vss) n12 w=1.2u l=0.13u
MP7551 (armtick4 n7328 storage7547 vdd) p12 w=3.6u l=0.13u
MN7552 (qb7536 storage7547 vss vss) n12 w=0.5u l=0.13u
MP7553 (qb7536 storage7547 vdd vdd) p12 w=1.5u l=0.13u
MN7554 (armtick4 qb7536 vss vss) n12 w=0.5u l=0.13u
MP7555 (armtick4 qb7536 vdd vdd) p12 w=1.5u l=0.13u
MN7556 (storage7547 n7301 vss vss) n12 w=2u l=0.13u
MN7559 (n7557 armtick5 n7558 vss) n12 w=1.6u l=0.13u
MN7560 (n7558 n7531 vss vss) n12 w=1.6u l=0.13u
MP7561 (n7557 armtick5 vdd vdd) p12 w=2.4u l=0.13u
MP7562 (n7557 n7531 vdd vdd) p12 w=2.4u l=0.13u
MN7565 (n7563 armtick5 n7564 vss) n12 w=1.6u l=0.13u
MN7566 (n7564 n7557 vss vss) n12 w=1.6u l=0.13u
MP7567 (n7563 armtick5 vdd vdd) p12 w=2.4u l=0.13u
MP7568 (n7563 n7557 vdd vdd) p12 w=2.4u l=0.13u
MN7571 (n7569 n7531 n7570 vss) n12 w=1.6u l=0.13u
MN7572 (n7570 n7557 vss vss) n12 w=1.6u l=0.13u
MP7573 (n7569 n7531 vdd vdd) p12 w=2.4u l=0.13u
MP7574 (n7569 n7557 vdd vdd) p12 w=2.4u l=0.13u
MN7577 (n7575 n7563 n7576 vss) n12 w=1.6u l=0.13u
MN7578 (n7576 n7569 vss vss) n12 w=1.6u l=0.13u
MP7579 (n7575 n7563 vdd vdd) p12 w=2.4u l=0.13u
MP7580 (n7575 n7569 vdd vdd) p12 w=2.4u l=0.13u
MN7582 (n7581 n7557 vss vss) n12 w=0.8u l=0.13u
MP7583 (n7581 n7557 vdd vdd) p12 w=2.4u l=0.13u
MN7588 (n7575 n7316 storage7587 vss) n12 w=1.2u l=0.13u
MP7589 (n7575 n7328 storage7587 vdd) p12 w=3.6u l=0.13u
MN7590 (qm7584 n7325 storage7587 vss) n12 w=1.2u l=0.13u
MP7591 (qm7584 n7331 storage7587 vdd) p12 w=3.6u l=0.13u
MN7592 (qmb7585 storage7587 vss vss) n12 w=0.5u l=0.13u
MP7593 (qmb7585 storage7587 vdd vdd) p12 w=1.5u l=0.13u
MN7594 (qm7584 qmb7585 vss vss) n12 w=0.5u l=0.13u
MP7595 (qm7584 qmb7585 vdd vdd) p12 w=1.5u l=0.13u
MN7596 (storage7587 n7301 vss vss) n12 w=2u l=0.13u
MN7598 (qm7584 n7325 storage7597 vss) n12 w=1.2u l=0.13u
MP7599 (qm7584 n7331 storage7597 vdd) p12 w=3.6u l=0.13u
MN7600 (armtick5 n7316 storage7597 vss) n12 w=1.2u l=0.13u
MP7601 (armtick5 n7328 storage7597 vdd) p12 w=3.6u l=0.13u
MN7602 (qb7586 storage7597 vss vss) n12 w=0.5u l=0.13u
MP7603 (qb7586 storage7597 vdd vdd) p12 w=1.5u l=0.13u
MN7604 (armtick5 qb7586 vss vss) n12 w=0.5u l=0.13u
MP7605 (armtick5 qb7586 vdd vdd) p12 w=1.5u l=0.13u
MN7606 (storage7597 n7301 vss vss) n12 w=2u l=0.13u
MN7609 (n7607 arm n7608 vss) n12 w=1.6u l=0.13u
MN7610 (n7608 epoch_valid vss vss) n12 w=1.6u l=0.13u
MP7611 (n7607 arm vdd vdd) p12 w=2.4u l=0.13u
MP7612 (n7607 epoch_valid vdd vdd) p12 w=2.4u l=0.13u
MN7614 (n7613 n7607 vss vss) n12 w=0.8u l=0.13u
MP7615 (n7613 n7607 vdd vdd) p12 w=2.4u l=0.13u
MN7617 (n7616 epoch_valid vss vss) n12 w=0.8u l=0.13u
MP7618 (n7616 epoch_valid vdd vdd) p12 w=2.4u l=0.13u
MN7621 (n7619 arm n7620 vss) n12 w=1.6u l=0.13u
MN7622 (n7620 armtick5 vss vss) n12 w=1.6u l=0.13u
MP7623 (n7619 arm vdd vdd) p12 w=2.4u l=0.13u
MP7624 (n7619 armtick5 vdd vdd) p12 w=2.4u l=0.13u
MN7626 (n7625 n7619 vss vss) n12 w=0.8u l=0.13u
MP7627 (n7625 n7619 vdd vdd) p12 w=2.4u l=0.13u
MN7630 (n7628 n7616 n7629 vss) n12 w=1.6u l=0.13u
MN7631 (n7629 n7625 vss vss) n12 w=1.6u l=0.13u
MP7632 (n7628 n7616 vdd vdd) p12 w=2.4u l=0.13u
MP7633 (n7628 n7625 vdd vdd) p12 w=2.4u l=0.13u
MN7635 (n7634 n7628 vss vss) n12 w=0.8u l=0.13u
MP7636 (n7634 n7628 vdd vdd) p12 w=2.4u l=0.13u
MN7638 (n7637 drain vss vss) n12 w=0.8u l=0.13u
MP7639 (n7637 drain vdd vdd) p12 w=2.4u l=0.13u
MN7642 (n7640 n7637 vss vss) n12 w=0.8u l=0.13u
MN7643 (n7640 rst vss vss) n12 w=0.8u l=0.13u
MP7644 (n7640 n7637 n7641 vdd) p12 w=4.8u l=0.13u
MP7645 (n7641 rst vdd vdd) p12 w=4.8u l=0.13u
MN7647 (n7646 n7640 vss vss) n12 w=0.8u l=0.13u
MP7648 (n7646 n7640 vdd vdd) p12 w=2.4u l=0.13u
MN7650 (n7649 draintick0 vss vss) n12 w=0.8u l=0.13u
MP7651 (n7649 draintick0 vdd vdd) p12 w=2.4u l=0.13u
MN7653 (n7652 n7646 vss vss) n12 w=0.8u l=0.13u
MP7654 (n7652 n7646 vdd vdd) p12 w=2.4u l=0.13u
MN7657 (n7655 n22 n7656 vss) n12 w=1.6u l=0.13u
MN7658 (n7656 n7652 vss vss) n12 w=1.6u l=0.13u
MP7659 (n7655 n22 vdd vdd) p12 w=2.4u l=0.13u
MP7660 (n7655 n7652 vdd vdd) p12 w=2.4u l=0.13u
MN7662 (n7661 n7655 vss vss) n12 w=0.8u l=0.13u
MP7663 (n7661 n7655 vdd vdd) p12 w=2.4u l=0.13u
MN7666 (n7664 n19 n7665 vss) n12 w=1.6u l=0.13u
MN7667 (n7665 n7652 vss vss) n12 w=1.6u l=0.13u
MP7668 (n7664 n19 vdd vdd) p12 w=2.4u l=0.13u
MP7669 (n7664 n7652 vdd vdd) p12 w=2.4u l=0.13u
MN7671 (n7670 n7664 vss vss) n12 w=0.8u l=0.13u
MP7672 (n7670 n7664 vdd vdd) p12 w=2.4u l=0.13u
MN7674 (n7673 n7661 vss vss) n12 w=0.8u l=0.13u
MP7675 (n7673 n7661 vdd vdd) p12 w=2.4u l=0.13u
MN7677 (n7676 n7670 vss vss) n12 w=0.8u l=0.13u
MP7678 (n7676 n7670 vdd vdd) p12 w=2.4u l=0.13u
MN7683 (n7649 n7661 storage7682 vss) n12 w=1.2u l=0.13u
MP7684 (n7649 n7673 storage7682 vdd) p12 w=3.6u l=0.13u
MN7685 (qm7679 n7670 storage7682 vss) n12 w=1.2u l=0.13u
MP7686 (qm7679 n7676 storage7682 vdd) p12 w=3.6u l=0.13u
MN7687 (qmb7680 storage7682 vss vss) n12 w=0.5u l=0.13u
MP7688 (qmb7680 storage7682 vdd vdd) p12 w=1.5u l=0.13u
MN7689 (qm7679 qmb7680 vss vss) n12 w=0.5u l=0.13u
MP7690 (qm7679 qmb7680 vdd vdd) p12 w=1.5u l=0.13u
MN7691 (storage7682 n7646 vss vss) n12 w=2u l=0.13u
MN7693 (qm7679 n7670 storage7692 vss) n12 w=1.2u l=0.13u
MP7694 (qm7679 n7676 storage7692 vdd) p12 w=3.6u l=0.13u
MN7695 (draintick0 n7661 storage7692 vss) n12 w=1.2u l=0.13u
MP7696 (draintick0 n7673 storage7692 vdd) p12 w=3.6u l=0.13u
MN7697 (qb7681 storage7692 vss vss) n12 w=0.5u l=0.13u
MP7698 (qb7681 storage7692 vdd vdd) p12 w=1.5u l=0.13u
MN7699 (draintick0 qb7681 vss vss) n12 w=0.5u l=0.13u
MP7700 (draintick0 qb7681 vdd vdd) p12 w=1.5u l=0.13u
MN7701 (storage7692 n7646 vss vss) n12 w=2u l=0.13u
MN7704 (n7702 draintick0 n7703 vss) n12 w=1.6u l=0.13u
MN7705 (n7703 draintick1 vss vss) n12 w=1.6u l=0.13u
MP7706 (n7702 draintick0 vdd vdd) p12 w=2.4u l=0.13u
MP7707 (n7702 draintick1 vdd vdd) p12 w=2.4u l=0.13u
MN7710 (n7708 draintick0 n7709 vss) n12 w=1.6u l=0.13u
MN7711 (n7709 n7702 vss vss) n12 w=1.6u l=0.13u
MP7712 (n7708 draintick0 vdd vdd) p12 w=2.4u l=0.13u
MP7713 (n7708 n7702 vdd vdd) p12 w=2.4u l=0.13u
MN7716 (n7714 draintick1 n7715 vss) n12 w=1.6u l=0.13u
MN7717 (n7715 n7702 vss vss) n12 w=1.6u l=0.13u
MP7718 (n7714 draintick1 vdd vdd) p12 w=2.4u l=0.13u
MP7719 (n7714 n7702 vdd vdd) p12 w=2.4u l=0.13u
MN7722 (n7720 n7708 n7721 vss) n12 w=1.6u l=0.13u
MN7723 (n7721 n7714 vss vss) n12 w=1.6u l=0.13u
MP7724 (n7720 n7708 vdd vdd) p12 w=2.4u l=0.13u
MP7725 (n7720 n7714 vdd vdd) p12 w=2.4u l=0.13u
MN7727 (n7726 n7702 vss vss) n12 w=0.8u l=0.13u
MP7728 (n7726 n7702 vdd vdd) p12 w=2.4u l=0.13u
MN7733 (n7720 n7661 storage7732 vss) n12 w=1.2u l=0.13u
MP7734 (n7720 n7673 storage7732 vdd) p12 w=3.6u l=0.13u
MN7735 (qm7729 n7670 storage7732 vss) n12 w=1.2u l=0.13u
MP7736 (qm7729 n7676 storage7732 vdd) p12 w=3.6u l=0.13u
MN7737 (qmb7730 storage7732 vss vss) n12 w=0.5u l=0.13u
MP7738 (qmb7730 storage7732 vdd vdd) p12 w=1.5u l=0.13u
MN7739 (qm7729 qmb7730 vss vss) n12 w=0.5u l=0.13u
MP7740 (qm7729 qmb7730 vdd vdd) p12 w=1.5u l=0.13u
MN7741 (storage7732 n7646 vss vss) n12 w=2u l=0.13u
MN7743 (qm7729 n7670 storage7742 vss) n12 w=1.2u l=0.13u
MP7744 (qm7729 n7676 storage7742 vdd) p12 w=3.6u l=0.13u
MN7745 (draintick1 n7661 storage7742 vss) n12 w=1.2u l=0.13u
MP7746 (draintick1 n7673 storage7742 vdd) p12 w=3.6u l=0.13u
MN7747 (qb7731 storage7742 vss vss) n12 w=0.5u l=0.13u
MP7748 (qb7731 storage7742 vdd vdd) p12 w=1.5u l=0.13u
MN7749 (draintick1 qb7731 vss vss) n12 w=0.5u l=0.13u
MP7750 (draintick1 qb7731 vdd vdd) p12 w=1.5u l=0.13u
MN7751 (storage7742 n7646 vss vss) n12 w=2u l=0.13u
MN7754 (n7752 drain n7753 vss) n12 w=1.6u l=0.13u
MN7755 (n7753 draintick0 vss vss) n12 w=1.6u l=0.13u
MP7756 (n7752 drain vdd vdd) p12 w=2.4u l=0.13u
MP7757 (n7752 draintick0 vdd vdd) p12 w=2.4u l=0.13u
MN7759 (n7758 n7752 vss vss) n12 w=0.8u l=0.13u
MP7760 (n7758 n7752 vdd vdd) p12 w=2.4u l=0.13u
MN7762 (n7761 measuretick0 vss vss) n12 w=0.8u l=0.13u
MP7763 (n7761 measuretick0 vdd vdd) p12 w=2.4u l=0.13u
MN7768 (n7761 n5827 storage7767 vss) n12 w=1.2u l=0.13u
MP7769 (n7761 n5839 storage7767 vdd) p12 w=3.6u l=0.13u
MN7770 (qm7764 n5836 storage7767 vss) n12 w=1.2u l=0.13u
MP7771 (qm7764 n5842 storage7767 vdd) p12 w=3.6u l=0.13u
MN7772 (qmb7765 storage7767 vss vss) n12 w=0.5u l=0.13u
MP7773 (qmb7765 storage7767 vdd vdd) p12 w=1.5u l=0.13u
MN7774 (qm7764 qmb7765 vss vss) n12 w=0.5u l=0.13u
MP7775 (qm7764 qmb7765 vdd vdd) p12 w=1.5u l=0.13u
MN7776 (storage7767 n5815 vss vss) n12 w=2u l=0.13u
MN7778 (qm7764 n5836 storage7777 vss) n12 w=1.2u l=0.13u
MP7779 (qm7764 n5842 storage7777 vdd) p12 w=3.6u l=0.13u
MN7780 (measuretick0 n5827 storage7777 vss) n12 w=1.2u l=0.13u
MP7781 (measuretick0 n5839 storage7777 vdd) p12 w=3.6u l=0.13u
MN7782 (qb7766 storage7777 vss vss) n12 w=0.5u l=0.13u
MP7783 (qb7766 storage7777 vdd vdd) p12 w=1.5u l=0.13u
MN7784 (measuretick0 qb7766 vss vss) n12 w=0.5u l=0.13u
MP7785 (measuretick0 qb7766 vdd vdd) p12 w=1.5u l=0.13u
MN7786 (storage7777 n5815 vss vss) n12 w=2u l=0.13u
MN7789 (n7787 measuretick0 n7788 vss) n12 w=1.6u l=0.13u
MN7790 (n7788 measuretick1 vss vss) n12 w=1.6u l=0.13u
MP7791 (n7787 measuretick0 vdd vdd) p12 w=2.4u l=0.13u
MP7792 (n7787 measuretick1 vdd vdd) p12 w=2.4u l=0.13u
MN7795 (n7793 measuretick0 n7794 vss) n12 w=1.6u l=0.13u
MN7796 (n7794 n7787 vss vss) n12 w=1.6u l=0.13u
MP7797 (n7793 measuretick0 vdd vdd) p12 w=2.4u l=0.13u
MP7798 (n7793 n7787 vdd vdd) p12 w=2.4u l=0.13u
MN7801 (n7799 measuretick1 n7800 vss) n12 w=1.6u l=0.13u
MN7802 (n7800 n7787 vss vss) n12 w=1.6u l=0.13u
MP7803 (n7799 measuretick1 vdd vdd) p12 w=2.4u l=0.13u
MP7804 (n7799 n7787 vdd vdd) p12 w=2.4u l=0.13u
MN7807 (n7805 n7793 n7806 vss) n12 w=1.6u l=0.13u
MN7808 (n7806 n7799 vss vss) n12 w=1.6u l=0.13u
MP7809 (n7805 n7793 vdd vdd) p12 w=2.4u l=0.13u
MP7810 (n7805 n7799 vdd vdd) p12 w=2.4u l=0.13u
MN7812 (n7811 n7787 vss vss) n12 w=0.8u l=0.13u
MP7813 (n7811 n7787 vdd vdd) p12 w=2.4u l=0.13u
MN7818 (n7805 n5827 storage7817 vss) n12 w=1.2u l=0.13u
MP7819 (n7805 n5839 storage7817 vdd) p12 w=3.6u l=0.13u
MN7820 (qm7814 n5836 storage7817 vss) n12 w=1.2u l=0.13u
MP7821 (qm7814 n5842 storage7817 vdd) p12 w=3.6u l=0.13u
MN7822 (qmb7815 storage7817 vss vss) n12 w=0.5u l=0.13u
MP7823 (qmb7815 storage7817 vdd vdd) p12 w=1.5u l=0.13u
MN7824 (qm7814 qmb7815 vss vss) n12 w=0.5u l=0.13u
MP7825 (qm7814 qmb7815 vdd vdd) p12 w=1.5u l=0.13u
MN7826 (storage7817 n5815 vss vss) n12 w=2u l=0.13u
MN7828 (qm7814 n5836 storage7827 vss) n12 w=1.2u l=0.13u
MP7829 (qm7814 n5842 storage7827 vdd) p12 w=3.6u l=0.13u
MN7830 (measuretick1 n5827 storage7827 vss) n12 w=1.2u l=0.13u
MP7831 (measuretick1 n5839 storage7827 vdd) p12 w=3.6u l=0.13u
MN7832 (qb7816 storage7827 vss vss) n12 w=0.5u l=0.13u
MP7833 (qb7816 storage7827 vdd vdd) p12 w=1.5u l=0.13u
MN7834 (measuretick1 qb7816 vss vss) n12 w=0.5u l=0.13u
MP7835 (measuretick1 qb7816 vdd vdd) p12 w=1.5u l=0.13u
MN7836 (storage7827 n5815 vss vss) n12 w=2u l=0.13u
MN7839 (n7837 measuretick2 n7838 vss) n12 w=1.6u l=0.13u
MN7840 (n7838 n7811 vss vss) n12 w=1.6u l=0.13u
MP7841 (n7837 measuretick2 vdd vdd) p12 w=2.4u l=0.13u
MP7842 (n7837 n7811 vdd vdd) p12 w=2.4u l=0.13u
MN7845 (n7843 measuretick2 n7844 vss) n12 w=1.6u l=0.13u
MN7846 (n7844 n7837 vss vss) n12 w=1.6u l=0.13u
MP7847 (n7843 measuretick2 vdd vdd) p12 w=2.4u l=0.13u
MP7848 (n7843 n7837 vdd vdd) p12 w=2.4u l=0.13u
MN7851 (n7849 n7811 n7850 vss) n12 w=1.6u l=0.13u
MN7852 (n7850 n7837 vss vss) n12 w=1.6u l=0.13u
MP7853 (n7849 n7811 vdd vdd) p12 w=2.4u l=0.13u
MP7854 (n7849 n7837 vdd vdd) p12 w=2.4u l=0.13u
MN7857 (n7855 n7843 n7856 vss) n12 w=1.6u l=0.13u
MN7858 (n7856 n7849 vss vss) n12 w=1.6u l=0.13u
MP7859 (n7855 n7843 vdd vdd) p12 w=2.4u l=0.13u
MP7860 (n7855 n7849 vdd vdd) p12 w=2.4u l=0.13u
MN7862 (n7861 n7837 vss vss) n12 w=0.8u l=0.13u
MP7863 (n7861 n7837 vdd vdd) p12 w=2.4u l=0.13u
MN7868 (n7855 n5827 storage7867 vss) n12 w=1.2u l=0.13u
MP7869 (n7855 n5839 storage7867 vdd) p12 w=3.6u l=0.13u
MN7870 (qm7864 n5836 storage7867 vss) n12 w=1.2u l=0.13u
MP7871 (qm7864 n5842 storage7867 vdd) p12 w=3.6u l=0.13u
MN7872 (qmb7865 storage7867 vss vss) n12 w=0.5u l=0.13u
MP7873 (qmb7865 storage7867 vdd vdd) p12 w=1.5u l=0.13u
MN7874 (qm7864 qmb7865 vss vss) n12 w=0.5u l=0.13u
MP7875 (qm7864 qmb7865 vdd vdd) p12 w=1.5u l=0.13u
MN7876 (storage7867 n5815 vss vss) n12 w=2u l=0.13u
MN7878 (qm7864 n5836 storage7877 vss) n12 w=1.2u l=0.13u
MP7879 (qm7864 n5842 storage7877 vdd) p12 w=3.6u l=0.13u
MN7880 (measuretick2 n5827 storage7877 vss) n12 w=1.2u l=0.13u
MP7881 (measuretick2 n5839 storage7877 vdd) p12 w=3.6u l=0.13u
MN7882 (qb7866 storage7877 vss vss) n12 w=0.5u l=0.13u
MP7883 (qb7866 storage7877 vdd vdd) p12 w=1.5u l=0.13u
MN7884 (measuretick2 qb7866 vss vss) n12 w=0.5u l=0.13u
MP7885 (measuretick2 qb7866 vdd vdd) p12 w=1.5u l=0.13u
MN7886 (storage7877 n5815 vss vss) n12 w=2u l=0.13u
MN7889 (n7887 measuretick3 n7888 vss) n12 w=1.6u l=0.13u
MN7890 (n7888 n7861 vss vss) n12 w=1.6u l=0.13u
MP7891 (n7887 measuretick3 vdd vdd) p12 w=2.4u l=0.13u
MP7892 (n7887 n7861 vdd vdd) p12 w=2.4u l=0.13u
MN7895 (n7893 measuretick3 n7894 vss) n12 w=1.6u l=0.13u
MN7896 (n7894 n7887 vss vss) n12 w=1.6u l=0.13u
MP7897 (n7893 measuretick3 vdd vdd) p12 w=2.4u l=0.13u
MP7898 (n7893 n7887 vdd vdd) p12 w=2.4u l=0.13u
MN7901 (n7899 n7861 n7900 vss) n12 w=1.6u l=0.13u
MN7902 (n7900 n7887 vss vss) n12 w=1.6u l=0.13u
MP7903 (n7899 n7861 vdd vdd) p12 w=2.4u l=0.13u
MP7904 (n7899 n7887 vdd vdd) p12 w=2.4u l=0.13u
MN7907 (n7905 n7893 n7906 vss) n12 w=1.6u l=0.13u
MN7908 (n7906 n7899 vss vss) n12 w=1.6u l=0.13u
MP7909 (n7905 n7893 vdd vdd) p12 w=2.4u l=0.13u
MP7910 (n7905 n7899 vdd vdd) p12 w=2.4u l=0.13u
MN7912 (n7911 n7887 vss vss) n12 w=0.8u l=0.13u
MP7913 (n7911 n7887 vdd vdd) p12 w=2.4u l=0.13u
MN7918 (n7905 n5827 storage7917 vss) n12 w=1.2u l=0.13u
MP7919 (n7905 n5839 storage7917 vdd) p12 w=3.6u l=0.13u
MN7920 (qm7914 n5836 storage7917 vss) n12 w=1.2u l=0.13u
MP7921 (qm7914 n5842 storage7917 vdd) p12 w=3.6u l=0.13u
MN7922 (qmb7915 storage7917 vss vss) n12 w=0.5u l=0.13u
MP7923 (qmb7915 storage7917 vdd vdd) p12 w=1.5u l=0.13u
MN7924 (qm7914 qmb7915 vss vss) n12 w=0.5u l=0.13u
MP7925 (qm7914 qmb7915 vdd vdd) p12 w=1.5u l=0.13u
MN7926 (storage7917 n5815 vss vss) n12 w=2u l=0.13u
MN7928 (qm7914 n5836 storage7927 vss) n12 w=1.2u l=0.13u
MP7929 (qm7914 n5842 storage7927 vdd) p12 w=3.6u l=0.13u
MN7930 (measuretick3 n5827 storage7927 vss) n12 w=1.2u l=0.13u
MP7931 (measuretick3 n5839 storage7927 vdd) p12 w=3.6u l=0.13u
MN7932 (qb7916 storage7927 vss vss) n12 w=0.5u l=0.13u
MP7933 (qb7916 storage7927 vdd vdd) p12 w=1.5u l=0.13u
MN7934 (measuretick3 qb7916 vss vss) n12 w=0.5u l=0.13u
MP7935 (measuretick3 qb7916 vdd vdd) p12 w=1.5u l=0.13u
MN7936 (storage7927 n5815 vss vss) n12 w=2u l=0.13u
MN7939 (n7937 measuretick4 n7938 vss) n12 w=1.6u l=0.13u
MN7940 (n7938 n7911 vss vss) n12 w=1.6u l=0.13u
MP7941 (n7937 measuretick4 vdd vdd) p12 w=2.4u l=0.13u
MP7942 (n7937 n7911 vdd vdd) p12 w=2.4u l=0.13u
MN7945 (n7943 measuretick4 n7944 vss) n12 w=1.6u l=0.13u
MN7946 (n7944 n7937 vss vss) n12 w=1.6u l=0.13u
MP7947 (n7943 measuretick4 vdd vdd) p12 w=2.4u l=0.13u
MP7948 (n7943 n7937 vdd vdd) p12 w=2.4u l=0.13u
MN7951 (n7949 n7911 n7950 vss) n12 w=1.6u l=0.13u
MN7952 (n7950 n7937 vss vss) n12 w=1.6u l=0.13u
MP7953 (n7949 n7911 vdd vdd) p12 w=2.4u l=0.13u
MP7954 (n7949 n7937 vdd vdd) p12 w=2.4u l=0.13u
MN7957 (n7955 n7943 n7956 vss) n12 w=1.6u l=0.13u
MN7958 (n7956 n7949 vss vss) n12 w=1.6u l=0.13u
MP7959 (n7955 n7943 vdd vdd) p12 w=2.4u l=0.13u
MP7960 (n7955 n7949 vdd vdd) p12 w=2.4u l=0.13u
MN7962 (n7961 n7937 vss vss) n12 w=0.8u l=0.13u
MP7963 (n7961 n7937 vdd vdd) p12 w=2.4u l=0.13u
MN7968 (n7955 n5827 storage7967 vss) n12 w=1.2u l=0.13u
MP7969 (n7955 n5839 storage7967 vdd) p12 w=3.6u l=0.13u
MN7970 (qm7964 n5836 storage7967 vss) n12 w=1.2u l=0.13u
MP7971 (qm7964 n5842 storage7967 vdd) p12 w=3.6u l=0.13u
MN7972 (qmb7965 storage7967 vss vss) n12 w=0.5u l=0.13u
MP7973 (qmb7965 storage7967 vdd vdd) p12 w=1.5u l=0.13u
MN7974 (qm7964 qmb7965 vss vss) n12 w=0.5u l=0.13u
MP7975 (qm7964 qmb7965 vdd vdd) p12 w=1.5u l=0.13u
MN7976 (storage7967 n5815 vss vss) n12 w=2u l=0.13u
MN7978 (qm7964 n5836 storage7977 vss) n12 w=1.2u l=0.13u
MP7979 (qm7964 n5842 storage7977 vdd) p12 w=3.6u l=0.13u
MN7980 (measuretick4 n5827 storage7977 vss) n12 w=1.2u l=0.13u
MP7981 (measuretick4 n5839 storage7977 vdd) p12 w=3.6u l=0.13u
MN7982 (qb7966 storage7977 vss vss) n12 w=0.5u l=0.13u
MP7983 (qb7966 storage7977 vdd vdd) p12 w=1.5u l=0.13u
MN7984 (measuretick4 qb7966 vss vss) n12 w=0.5u l=0.13u
MP7985 (measuretick4 qb7966 vdd vdd) p12 w=1.5u l=0.13u
MN7986 (storage7977 n5815 vss vss) n12 w=2u l=0.13u
MN7989 (n7987 measuretick5 n7988 vss) n12 w=1.6u l=0.13u
MN7990 (n7988 n7961 vss vss) n12 w=1.6u l=0.13u
MP7991 (n7987 measuretick5 vdd vdd) p12 w=2.4u l=0.13u
MP7992 (n7987 n7961 vdd vdd) p12 w=2.4u l=0.13u
MN7995 (n7993 measuretick5 n7994 vss) n12 w=1.6u l=0.13u
MN7996 (n7994 n7987 vss vss) n12 w=1.6u l=0.13u
MP7997 (n7993 measuretick5 vdd vdd) p12 w=2.4u l=0.13u
MP7998 (n7993 n7987 vdd vdd) p12 w=2.4u l=0.13u
MN8001 (n7999 n7961 n8000 vss) n12 w=1.6u l=0.13u
MN8002 (n8000 n7987 vss vss) n12 w=1.6u l=0.13u
MP8003 (n7999 n7961 vdd vdd) p12 w=2.4u l=0.13u
MP8004 (n7999 n7987 vdd vdd) p12 w=2.4u l=0.13u
MN8007 (n8005 n7993 n8006 vss) n12 w=1.6u l=0.13u
MN8008 (n8006 n7999 vss vss) n12 w=1.6u l=0.13u
MP8009 (n8005 n7993 vdd vdd) p12 w=2.4u l=0.13u
MP8010 (n8005 n7999 vdd vdd) p12 w=2.4u l=0.13u
MN8012 (n8011 n7987 vss vss) n12 w=0.8u l=0.13u
MP8013 (n8011 n7987 vdd vdd) p12 w=2.4u l=0.13u
MN8018 (n8005 n5827 storage8017 vss) n12 w=1.2u l=0.13u
MP8019 (n8005 n5839 storage8017 vdd) p12 w=3.6u l=0.13u
MN8020 (qm8014 n5836 storage8017 vss) n12 w=1.2u l=0.13u
MP8021 (qm8014 n5842 storage8017 vdd) p12 w=3.6u l=0.13u
MN8022 (qmb8015 storage8017 vss vss) n12 w=0.5u l=0.13u
MP8023 (qmb8015 storage8017 vdd vdd) p12 w=1.5u l=0.13u
MN8024 (qm8014 qmb8015 vss vss) n12 w=0.5u l=0.13u
MP8025 (qm8014 qmb8015 vdd vdd) p12 w=1.5u l=0.13u
MN8026 (storage8017 n5815 vss vss) n12 w=2u l=0.13u
MN8028 (qm8014 n5836 storage8027 vss) n12 w=1.2u l=0.13u
MP8029 (qm8014 n5842 storage8027 vdd) p12 w=3.6u l=0.13u
MN8030 (measuretick5 n5827 storage8027 vss) n12 w=1.2u l=0.13u
MP8031 (measuretick5 n5839 storage8027 vdd) p12 w=3.6u l=0.13u
MN8032 (qb8016 storage8027 vss vss) n12 w=0.5u l=0.13u
MP8033 (qb8016 storage8027 vdd vdd) p12 w=1.5u l=0.13u
MN8034 (measuretick5 qb8016 vss vss) n12 w=0.5u l=0.13u
MP8035 (measuretick5 qb8016 vdd vdd) p12 w=1.5u l=0.13u
MN8036 (storage8027 n5815 vss vss) n12 w=2u l=0.13u
MN8039 (n8037 measuretick6 n8038 vss) n12 w=1.6u l=0.13u
MN8040 (n8038 n8011 vss vss) n12 w=1.6u l=0.13u
MP8041 (n8037 measuretick6 vdd vdd) p12 w=2.4u l=0.13u
MP8042 (n8037 n8011 vdd vdd) p12 w=2.4u l=0.13u
MN8045 (n8043 measuretick6 n8044 vss) n12 w=1.6u l=0.13u
MN8046 (n8044 n8037 vss vss) n12 w=1.6u l=0.13u
MP8047 (n8043 measuretick6 vdd vdd) p12 w=2.4u l=0.13u
MP8048 (n8043 n8037 vdd vdd) p12 w=2.4u l=0.13u
MN8051 (n8049 n8011 n8050 vss) n12 w=1.6u l=0.13u
MN8052 (n8050 n8037 vss vss) n12 w=1.6u l=0.13u
MP8053 (n8049 n8011 vdd vdd) p12 w=2.4u l=0.13u
MP8054 (n8049 n8037 vdd vdd) p12 w=2.4u l=0.13u
MN8057 (n8055 n8043 n8056 vss) n12 w=1.6u l=0.13u
MN8058 (n8056 n8049 vss vss) n12 w=1.6u l=0.13u
MP8059 (n8055 n8043 vdd vdd) p12 w=2.4u l=0.13u
MP8060 (n8055 n8049 vdd vdd) p12 w=2.4u l=0.13u
MN8062 (n8061 n8037 vss vss) n12 w=0.8u l=0.13u
MP8063 (n8061 n8037 vdd vdd) p12 w=2.4u l=0.13u
MN8068 (n8055 n5827 storage8067 vss) n12 w=1.2u l=0.13u
MP8069 (n8055 n5839 storage8067 vdd) p12 w=3.6u l=0.13u
MN8070 (qm8064 n5836 storage8067 vss) n12 w=1.2u l=0.13u
MP8071 (qm8064 n5842 storage8067 vdd) p12 w=3.6u l=0.13u
MN8072 (qmb8065 storage8067 vss vss) n12 w=0.5u l=0.13u
MP8073 (qmb8065 storage8067 vdd vdd) p12 w=1.5u l=0.13u
MN8074 (qm8064 qmb8065 vss vss) n12 w=0.5u l=0.13u
MP8075 (qm8064 qmb8065 vdd vdd) p12 w=1.5u l=0.13u
MN8076 (storage8067 n5815 vss vss) n12 w=2u l=0.13u
MN8078 (qm8064 n5836 storage8077 vss) n12 w=1.2u l=0.13u
MP8079 (qm8064 n5842 storage8077 vdd) p12 w=3.6u l=0.13u
MN8080 (measuretick6 n5827 storage8077 vss) n12 w=1.2u l=0.13u
MP8081 (measuretick6 n5839 storage8077 vdd) p12 w=3.6u l=0.13u
MN8082 (qb8066 storage8077 vss vss) n12 w=0.5u l=0.13u
MP8083 (qb8066 storage8077 vdd vdd) p12 w=1.5u l=0.13u
MN8084 (measuretick6 qb8066 vss vss) n12 w=0.5u l=0.13u
MP8085 (measuretick6 qb8066 vdd vdd) p12 w=1.5u l=0.13u
MN8086 (storage8077 n5815 vss vss) n12 w=2u l=0.13u
MN8089 (n8087 measuretick7 n8088 vss) n12 w=1.6u l=0.13u
MN8090 (n8088 n8061 vss vss) n12 w=1.6u l=0.13u
MP8091 (n8087 measuretick7 vdd vdd) p12 w=2.4u l=0.13u
MP8092 (n8087 n8061 vdd vdd) p12 w=2.4u l=0.13u
MN8095 (n8093 measuretick7 n8094 vss) n12 w=1.6u l=0.13u
MN8096 (n8094 n8087 vss vss) n12 w=1.6u l=0.13u
MP8097 (n8093 measuretick7 vdd vdd) p12 w=2.4u l=0.13u
MP8098 (n8093 n8087 vdd vdd) p12 w=2.4u l=0.13u
MN8101 (n8099 n8061 n8100 vss) n12 w=1.6u l=0.13u
MN8102 (n8100 n8087 vss vss) n12 w=1.6u l=0.13u
MP8103 (n8099 n8061 vdd vdd) p12 w=2.4u l=0.13u
MP8104 (n8099 n8087 vdd vdd) p12 w=2.4u l=0.13u
MN8107 (n8105 n8093 n8106 vss) n12 w=1.6u l=0.13u
MN8108 (n8106 n8099 vss vss) n12 w=1.6u l=0.13u
MP8109 (n8105 n8093 vdd vdd) p12 w=2.4u l=0.13u
MP8110 (n8105 n8099 vdd vdd) p12 w=2.4u l=0.13u
MN8112 (n8111 n8087 vss vss) n12 w=0.8u l=0.13u
MP8113 (n8111 n8087 vdd vdd) p12 w=2.4u l=0.13u
MN8118 (n8105 n5827 storage8117 vss) n12 w=1.2u l=0.13u
MP8119 (n8105 n5839 storage8117 vdd) p12 w=3.6u l=0.13u
MN8120 (qm8114 n5836 storage8117 vss) n12 w=1.2u l=0.13u
MP8121 (qm8114 n5842 storage8117 vdd) p12 w=3.6u l=0.13u
MN8122 (qmb8115 storage8117 vss vss) n12 w=0.5u l=0.13u
MP8123 (qmb8115 storage8117 vdd vdd) p12 w=1.5u l=0.13u
MN8124 (qm8114 qmb8115 vss vss) n12 w=0.5u l=0.13u
MP8125 (qm8114 qmb8115 vdd vdd) p12 w=1.5u l=0.13u
MN8126 (storage8117 n5815 vss vss) n12 w=2u l=0.13u
MN8128 (qm8114 n5836 storage8127 vss) n12 w=1.2u l=0.13u
MP8129 (qm8114 n5842 storage8127 vdd) p12 w=3.6u l=0.13u
MN8130 (measuretick7 n5827 storage8127 vss) n12 w=1.2u l=0.13u
MP8131 (measuretick7 n5839 storage8127 vdd) p12 w=3.6u l=0.13u
MN8132 (qb8116 storage8127 vss vss) n12 w=0.5u l=0.13u
MP8133 (qb8116 storage8127 vdd vdd) p12 w=1.5u l=0.13u
MN8134 (measuretick7 qb8116 vss vss) n12 w=0.5u l=0.13u
MP8135 (measuretick7 qb8116 vdd vdd) p12 w=1.5u l=0.13u
MN8136 (storage8127 n5815 vss vss) n12 w=2u l=0.13u
MN8139 (n8137 measure n8138 vss) n12 w=1.6u l=0.13u
MN8140 (n8138 measuretick7 vss vss) n12 w=1.6u l=0.13u
MP8141 (n8137 measure vdd vdd) p12 w=2.4u l=0.13u
MP8142 (n8137 measuretick7 vdd vdd) p12 w=2.4u l=0.13u
MN8144 (n8143 n8137 vss vss) n12 w=0.8u l=0.13u
MP8145 (n8143 n8137 vdd vdd) p12 w=2.4u l=0.13u
MN8148 (n8146 measuretick6 n8147 vss) n12 w=1.6u l=0.13u
MN8149 (n8147 n8143 vss vss) n12 w=1.6u l=0.13u
MP8150 (n8146 measuretick6 vdd vdd) p12 w=2.4u l=0.13u
MP8151 (n8146 n8143 vdd vdd) p12 w=2.4u l=0.13u
MN8153 (n8152 n8146 vss vss) n12 w=0.8u l=0.13u
MP8154 (n8152 n8146 vdd vdd) p12 w=2.4u l=0.13u
MN8156 (n8155 n8152 vss vss) n12 w=0.8u l=0.13u
MP8157 (n8155 n8152 vdd vdd) p12 w=2.4u l=0.13u
MN8159 (n8158 n8155 vss vss) n12 w=0.8u l=0.13u
MP8160 (n8158 n8155 vdd vdd) p12 w=2.4u l=0.13u
MN8162 (n8161 n8158 vss vss) n12 w=0.8u l=0.13u
MP8163 (n8161 n8158 vdd vdd) p12 w=2.4u l=0.13u
MN8164 (measure_watchdog n8161 vss vss) n12 w=0.8u l=0.13u
MP8165 (measure_watchdog n8161 vdd vdd) p12 w=2.4u l=0.13u
MN8168 (n8166 step1 vss vss) n12 w=0.8u l=0.13u
MN8169 (n8166 step2 vss vss) n12 w=0.8u l=0.13u
MP8170 (n8166 step1 n8167 vdd) p12 w=4.8u l=0.13u
MP8171 (n8167 step2 vdd vdd) p12 w=4.8u l=0.13u
MN8173 (n8172 n8166 vss vss) n12 w=0.8u l=0.13u
MP8174 (n8172 n8166 vdd vdd) p12 w=2.4u l=0.13u
MN8177 (n8175 step4 vss vss) n12 w=0.8u l=0.13u
MN8178 (n8175 step8 vss vss) n12 w=0.8u l=0.13u
MP8179 (n8175 step4 n8176 vdd) p12 w=4.8u l=0.13u
MP8180 (n8176 step8 vdd vdd) p12 w=4.8u l=0.13u
MN8182 (n8181 n8175 vss vss) n12 w=0.8u l=0.13u
MP8183 (n8181 n8175 vdd vdd) p12 w=2.4u l=0.13u
MN8186 (n8184 n8172 vss vss) n12 w=0.8u l=0.13u
MN8187 (n8184 n8181 vss vss) n12 w=0.8u l=0.13u
MP8188 (n8184 n8172 n8185 vdd) p12 w=4.8u l=0.13u
MP8189 (n8185 n8181 vdd vdd) p12 w=4.8u l=0.13u
MN8191 (n8190 n8184 vss vss) n12 w=0.8u l=0.13u
MP8192 (n8190 n8184 vdd vdd) p12 w=2.4u l=0.13u
MN8194 (n8193 n8190 vss vss) n12 w=0.8u l=0.13u
MP8195 (n8193 n8190 vdd vdd) p12 w=2.4u l=0.13u
MN8197 (n8196 s1 vss vss) n12 w=0.8u l=0.13u
MP8198 (n8196 s1 vdd vdd) p12 w=2.4u l=0.13u
MN8200 (n8199 s2 vss vss) n12 w=0.8u l=0.13u
MP8201 (n8199 s2 vdd vdd) p12 w=2.4u l=0.13u
MN8203 (n8202 s3 vss vss) n12 w=0.8u l=0.13u
MP8204 (n8202 s3 vdd vdd) p12 w=2.4u l=0.13u
MN8206 (n8205 s4 vss vss) n12 w=0.8u l=0.13u
MP8207 (n8205 s4 vdd vdd) p12 w=2.4u l=0.13u
MN8210 (n8208 n8196 n8209 vss) n12 w=1.6u l=0.13u
MN8211 (n8209 s0 vss vss) n12 w=1.6u l=0.13u
MP8212 (n8208 n8196 vdd vdd) p12 w=2.4u l=0.13u
MP8213 (n8208 s0 vdd vdd) p12 w=2.4u l=0.13u
MN8215 (n8214 n8208 vss vss) n12 w=0.8u l=0.13u
MP8216 (n8214 n8208 vdd vdd) p12 w=2.4u l=0.13u
MN8219 (n8217 n8199 n8218 vss) n12 w=1.6u l=0.13u
MN8220 (n8218 n8202 vss vss) n12 w=1.6u l=0.13u
MP8221 (n8217 n8199 vdd vdd) p12 w=2.4u l=0.13u
MP8222 (n8217 n8202 vdd vdd) p12 w=2.4u l=0.13u
MN8224 (n8223 n8217 vss vss) n12 w=0.8u l=0.13u
MP8225 (n8223 n8217 vdd vdd) p12 w=2.4u l=0.13u
MN8228 (n8226 n8214 n8227 vss) n12 w=1.6u l=0.13u
MN8229 (n8227 n8223 vss vss) n12 w=1.6u l=0.13u
MP8230 (n8226 n8214 vdd vdd) p12 w=2.4u l=0.13u
MP8231 (n8226 n8223 vdd vdd) p12 w=2.4u l=0.13u
MN8233 (n8232 n8226 vss vss) n12 w=0.8u l=0.13u
MP8234 (n8232 n8226 vdd vdd) p12 w=2.4u l=0.13u
MN8237 (n8235 n8205 n8236 vss) n12 w=1.6u l=0.13u
MN8238 (n8236 n8232 vss vss) n12 w=1.6u l=0.13u
MP8239 (n8235 n8205 vdd vdd) p12 w=2.4u l=0.13u
MP8240 (n8235 n8232 vdd vdd) p12 w=2.4u l=0.13u
MN8242 (n8241 n8235 vss vss) n12 w=0.8u l=0.13u
MP8243 (n8241 n8235 vdd vdd) p12 w=2.4u l=0.13u
MN8246 (n8244 s0 n8245 vss) n12 w=1.6u l=0.13u
MN8247 (n8245 s1 vss vss) n12 w=1.6u l=0.13u
MP8248 (n8244 s0 vdd vdd) p12 w=2.4u l=0.13u
MP8249 (n8244 s1 vdd vdd) p12 w=2.4u l=0.13u
MN8251 (n8250 n8244 vss vss) n12 w=0.8u l=0.13u
MP8252 (n8250 n8244 vdd vdd) p12 w=2.4u l=0.13u
MN8255 (n8253 s2 n8254 vss) n12 w=1.6u l=0.13u
MN8256 (n8254 s3 vss vss) n12 w=1.6u l=0.13u
MP8257 (n8253 s2 vdd vdd) p12 w=2.4u l=0.13u
MP8258 (n8253 s3 vdd vdd) p12 w=2.4u l=0.13u
MN8260 (n8259 n8253 vss vss) n12 w=0.8u l=0.13u
MP8261 (n8259 n8253 vdd vdd) p12 w=2.4u l=0.13u
MN8264 (n8262 n8250 n8263 vss) n12 w=1.6u l=0.13u
MN8265 (n8263 n8259 vss vss) n12 w=1.6u l=0.13u
MP8266 (n8262 n8250 vdd vdd) p12 w=2.4u l=0.13u
MP8267 (n8262 n8259 vdd vdd) p12 w=2.4u l=0.13u
MN8269 (n8268 n8262 vss vss) n12 w=0.8u l=0.13u
MP8270 (n8268 n8262 vdd vdd) p12 w=2.4u l=0.13u
MN8273 (n8271 n8268 n8272 vss) n12 w=1.6u l=0.13u
MN8274 (n8272 s4 vss vss) n12 w=1.6u l=0.13u
MP8275 (n8271 n8268 vdd vdd) p12 w=2.4u l=0.13u
MP8276 (n8271 s4 vdd vdd) p12 w=2.4u l=0.13u
MN8278 (n8277 n8271 vss vss) n12 w=0.8u l=0.13u
MP8279 (n8277 n8271 vdd vdd) p12 w=2.4u l=0.13u
MN8282 (n8280 n8241 n8281 vss) n12 w=1.6u l=0.13u
MN8283 (n8281 was_fast vss vss) n12 w=1.6u l=0.13u
MP8284 (n8280 n8241 vdd vdd) p12 w=2.4u l=0.13u
MP8285 (n8280 was_fast vdd vdd) p12 w=2.4u l=0.13u
MN8287 (n8286 n8280 vss vss) n12 w=0.8u l=0.13u
MP8288 (n8286 n8280 vdd vdd) p12 w=2.4u l=0.13u
MN8291 (n8289 n8277 n8290 vss) n12 w=1.6u l=0.13u
MN8292 (n8290 was_slow vss vss) n12 w=1.6u l=0.13u
MP8293 (n8289 n8277 vdd vdd) p12 w=2.4u l=0.13u
MP8294 (n8289 was_slow vdd vdd) p12 w=2.4u l=0.13u
MN8296 (n8295 n8289 vss vss) n12 w=0.8u l=0.13u
MP8297 (n8295 n8289 vdd vdd) p12 w=2.4u l=0.13u
MN8300 (n8298 n8286 vss vss) n12 w=0.8u l=0.13u
MN8301 (n8298 n8295 vss vss) n12 w=0.8u l=0.13u
MP8302 (n8298 n8286 n8299 vdd) p12 w=4.8u l=0.13u
MP8303 (n8299 n8295 vdd vdd) p12 w=4.8u l=0.13u
MN8305 (n8304 n8298 vss vss) n12 w=0.8u l=0.13u
MP8306 (n8304 n8298 vdd vdd) p12 w=2.4u l=0.13u
MN8309 (n8307 n8193 vss vss) n12 w=0.8u l=0.13u
MN8310 (n8307 was_near vss vss) n12 w=0.8u l=0.13u
MP8311 (n8307 n8193 n8308 vdd) p12 w=4.8u l=0.13u
MP8312 (n8308 was_near vdd vdd) p12 w=4.8u l=0.13u
MN8314 (n8313 n8307 vss vss) n12 w=0.8u l=0.13u
MP8315 (n8313 n8307 vdd vdd) p12 w=2.4u l=0.13u
MN8317 (n8316 n8304 vss vss) n12 w=0.8u l=0.13u
MP8318 (n8316 n8304 vdd vdd) p12 w=2.4u l=0.13u
MN8321 (n8319 n7758 n8320 vss) n12 w=1.6u l=0.13u
MN8322 (n8320 n8313 vss vss) n12 w=1.6u l=0.13u
MP8323 (n8319 n7758 vdd vdd) p12 w=2.4u l=0.13u
MP8324 (n8319 n8313 vdd vdd) p12 w=2.4u l=0.13u
MN8326 (n8325 n8319 vss vss) n12 w=0.8u l=0.13u
MP8327 (n8325 n8319 vdd vdd) p12 w=2.4u l=0.13u
MN8330 (n8328 n8316 n8329 vss) n12 w=1.6u l=0.13u
MN8331 (n8329 n8325 vss vss) n12 w=1.6u l=0.13u
MP8332 (n8328 n8316 vdd vdd) p12 w=2.4u l=0.13u
MP8333 (n8328 n8325 vdd vdd) p12 w=2.4u l=0.13u
MN8335 (n8334 n8328 vss vss) n12 w=0.8u l=0.13u
MP8336 (n8334 n8328 vdd vdd) p12 w=2.4u l=0.13u
MN8339 (n8337 measure n8338 vss) n12 w=1.6u l=0.13u
MN8340 (n8338 n5937 vss vss) n12 w=1.6u l=0.13u
MP8341 (n8337 measure vdd vdd) p12 w=2.4u l=0.13u
MP8342 (n8337 n5937 vdd vdd) p12 w=2.4u l=0.13u
MN8344 (n8343 n8337 vss vss) n12 w=0.8u l=0.13u
MP8345 (n8343 n8337 vdd vdd) p12 w=2.4u l=0.13u
MN8348 (n8346 n8304 n8347 vss) n12 w=1.6u l=0.13u
MN8349 (n8347 n8325 vss vss) n12 w=1.6u l=0.13u
MP8350 (n8346 n8304 vdd vdd) p12 w=2.4u l=0.13u
MP8351 (n8346 n8325 vdd vdd) p12 w=2.4u l=0.13u
MN8353 (n8352 n8346 vss vss) n12 w=0.8u l=0.13u
MP8354 (n8352 n8346 vdd vdd) p12 w=2.4u l=0.13u
MN8357 (n8355 n7634 vss vss) n12 w=0.8u l=0.13u
MN8358 (n8355 n8152 vss vss) n12 w=0.8u l=0.13u
MP8359 (n8355 n7634 n8356 vdd) p12 w=4.8u l=0.13u
MP8360 (n8356 n8152 vdd vdd) p12 w=4.8u l=0.13u
MN8362 (n8361 n8355 vss vss) n12 w=0.8u l=0.13u
MP8363 (n8361 n8355 vdd vdd) p12 w=2.4u l=0.13u
MN8366 (n8364 n8343 vss vss) n12 w=0.8u l=0.13u
MN8367 (n8364 n8352 vss vss) n12 w=0.8u l=0.13u
MP8368 (n8364 n8343 n8365 vdd) p12 w=4.8u l=0.13u
MP8369 (n8365 n8352 vdd vdd) p12 w=4.8u l=0.13u
MN8371 (n8370 n8364 vss vss) n12 w=0.8u l=0.13u
MP8372 (n8370 n8364 vdd vdd) p12 w=2.4u l=0.13u
MN8375 (n8373 n8361 vss vss) n12 w=0.8u l=0.13u
MN8376 (n8373 n8370 vss vss) n12 w=0.8u l=0.13u
MP8377 (n8373 n8361 n8374 vdd) p12 w=4.8u l=0.13u
MP8378 (n8374 n8370 vdd vdd) p12 w=4.8u l=0.13u
MN8380 (n8379 n8373 vss vss) n12 w=0.8u l=0.13u
MP8381 (n8379 n8373 vdd vdd) p12 w=2.4u l=0.13u
MN8384 (n8382 n5964 vss vss) n12 w=0.8u l=0.13u
MN8385 (n8382 n8379 vss vss) n12 w=0.8u l=0.13u
MP8386 (n8382 n5964 n8383 vdd) p12 w=4.8u l=0.13u
MP8387 (n8383 n8379 vdd vdd) p12 w=4.8u l=0.13u
MN8389 (n8388 n8382 vss vss) n12 w=0.8u l=0.13u
MP8390 (n8388 n8382 vdd vdd) p12 w=2.4u l=0.13u
MN8392 (n8391 n8388 vss vss) n12 w=0.8u l=0.13u
MP8393 (n8391 n8388 vdd vdd) p12 w=2.4u l=0.13u
MN8396 (n8394 n5964 vss vss) n12 w=0.8u l=0.13u
MN8397 (n8394 n7289 vss vss) n12 w=0.8u l=0.13u
MP8398 (n8394 n5964 n8395 vdd) p12 w=4.8u l=0.13u
MP8399 (n8395 n7289 vdd vdd) p12 w=4.8u l=0.13u
MN8401 (n8400 n8394 vss vss) n12 w=0.8u l=0.13u
MP8402 (n8400 n8394 vdd vdd) p12 w=2.4u l=0.13u
MN8405 (n8403 n8379 vss vss) n12 w=0.8u l=0.13u
MN8406 (n8403 n8400 vss vss) n12 w=0.8u l=0.13u
MP8407 (n8403 n8379 n8404 vdd) p12 w=4.8u l=0.13u
MP8408 (n8404 n8400 vdd vdd) p12 w=4.8u l=0.13u
MN8410 (n8409 n8403 vss vss) n12 w=0.8u l=0.13u
MP8411 (n8409 n8403 vdd vdd) p12 w=2.4u l=0.13u
MN8414 (n8412 n8391 n8413 vss) n12 w=1.6u l=0.13u
MN8415 (n8413 n8409 vss vss) n12 w=1.6u l=0.13u
MP8416 (n8412 n8391 vdd vdd) p12 w=2.4u l=0.13u
MP8417 (n8412 n8409 vdd vdd) p12 w=2.4u l=0.13u
MN8419 (n8418 n8409 vss vss) n12 w=0.8u l=0.13u
MP8420 (n8418 n8409 vdd vdd) p12 w=2.4u l=0.13u
MN8423 (n8421 count_run n8422 vss) n12 w=1.6u l=0.13u
MN8424 (n8422 n8418 vss vss) n12 w=1.6u l=0.13u
MP8425 (n8421 count_run vdd vdd) p12 w=2.4u l=0.13u
MP8426 (n8421 n8418 vdd vdd) p12 w=2.4u l=0.13u
MN8429 (n8427 n8412 n8428 vss) n12 w=1.6u l=0.13u
MN8430 (n8428 n8421 vss vss) n12 w=1.6u l=0.13u
MP8431 (n8427 n8412 vdd vdd) p12 w=2.4u l=0.13u
MP8432 (n8427 n8421 vdd vdd) p12 w=2.4u l=0.13u
MN8437 (n8427 n93 storage8436 vss) n12 w=1.2u l=0.13u
MP8438 (n8427 n105 storage8436 vdd) p12 w=3.6u l=0.13u
MN8439 (qm8433 n102 storage8436 vss) n12 w=1.2u l=0.13u
MP8440 (qm8433 n108 storage8436 vdd) p12 w=3.6u l=0.13u
MN8441 (qmb8434 storage8436 vss vss) n12 w=0.5u l=0.13u
MP8442 (qmb8434 storage8436 vdd vdd) p12 w=1.5u l=0.13u
MN8443 (qm8433 qmb8434 vss vss) n12 w=0.5u l=0.13u
MP8444 (qm8433 qmb8434 vdd vdd) p12 w=1.5u l=0.13u
MN8445 (storage8436 rst vss vss) n12 w=2u l=0.13u
MN8447 (qm8433 n102 storage8446 vss) n12 w=1.2u l=0.13u
MP8448 (qm8433 n108 storage8446 vdd) p12 w=3.6u l=0.13u
MN8449 (count_run n93 storage8446 vss) n12 w=1.2u l=0.13u
MP8450 (count_run n105 storage8446 vdd) p12 w=3.6u l=0.13u
MN8451 (qb8435 storage8446 vss vss) n12 w=0.5u l=0.13u
MP8452 (qb8435 storage8446 vdd vdd) p12 w=1.5u l=0.13u
MN8453 (count_run qb8435 vss vss) n12 w=0.5u l=0.13u
MP8454 (count_run qb8435 vdd vdd) p12 w=1.5u l=0.13u
MN8455 (storage8446 rst vss vss) n12 w=2u l=0.13u
MN8457 (n8456 n8334 vss vss) n12 w=0.8u l=0.13u
MP8458 (n8456 n8334 vdd vdd) p12 w=2.4u l=0.13u
MN8461 (n8459 done n8460 vss) n12 w=1.6u l=0.13u
MN8462 (n8460 n8456 vss vss) n12 w=1.6u l=0.13u
MP8463 (n8459 done vdd vdd) p12 w=2.4u l=0.13u
MP8464 (n8459 n8456 vdd vdd) p12 w=2.4u l=0.13u
MN8467 (n8465 n8456 n8466 vss) n12 w=1.6u l=0.13u
MN8468 (n8466 n8459 vss vss) n12 w=1.6u l=0.13u
MP8469 (n8465 n8456 vdd vdd) p12 w=2.4u l=0.13u
MP8470 (n8465 n8459 vdd vdd) p12 w=2.4u l=0.13u
MN8475 (n8465 n93 storage8474 vss) n12 w=1.2u l=0.13u
MP8476 (n8465 n105 storage8474 vdd) p12 w=3.6u l=0.13u
MN8477 (qm8471 n102 storage8474 vss) n12 w=1.2u l=0.13u
MP8478 (qm8471 n108 storage8474 vdd) p12 w=3.6u l=0.13u
MN8479 (qmb8472 storage8474 vss vss) n12 w=0.5u l=0.13u
MP8480 (qmb8472 storage8474 vdd vdd) p12 w=1.5u l=0.13u
MN8481 (qm8471 qmb8472 vss vss) n12 w=0.5u l=0.13u
MP8482 (qm8471 qmb8472 vdd vdd) p12 w=1.5u l=0.13u
MN8483 (storage8474 rst vss vss) n12 w=2u l=0.13u
MN8485 (qm8471 n102 storage8484 vss) n12 w=1.2u l=0.13u
MP8486 (qm8471 n108 storage8484 vdd) p12 w=3.6u l=0.13u
MN8487 (done n93 storage8484 vss) n12 w=1.2u l=0.13u
MP8488 (done n105 storage8484 vdd) p12 w=3.6u l=0.13u
MN8489 (qb8473 storage8484 vss vss) n12 w=0.5u l=0.13u
MP8490 (qb8473 storage8484 vdd vdd) p12 w=1.5u l=0.13u
MN8491 (done qb8473 vss vss) n12 w=0.5u l=0.13u
MP8492 (done qb8473 vdd vdd) p12 w=1.5u l=0.13u
MN8493 (storage8484 rst vss vss) n12 w=2u l=0.13u
MN8495 (n8494 n8379 vss vss) n12 w=0.8u l=0.13u
MP8496 (n8494 n8379 vdd vdd) p12 w=2.4u l=0.13u
MN8499 (n8497 fail n8498 vss) n12 w=1.6u l=0.13u
MN8500 (n8498 n8494 vss vss) n12 w=1.6u l=0.13u
MP8501 (n8497 fail vdd vdd) p12 w=2.4u l=0.13u
MP8502 (n8497 n8494 vdd vdd) p12 w=2.4u l=0.13u
MN8505 (n8503 n8494 n8504 vss) n12 w=1.6u l=0.13u
MN8506 (n8504 n8497 vss vss) n12 w=1.6u l=0.13u
MP8507 (n8503 n8494 vdd vdd) p12 w=2.4u l=0.13u
MP8508 (n8503 n8497 vdd vdd) p12 w=2.4u l=0.13u
MN8513 (n8503 n93 storage8512 vss) n12 w=1.2u l=0.13u
MP8514 (n8503 n105 storage8512 vdd) p12 w=3.6u l=0.13u
MN8515 (qm8509 n102 storage8512 vss) n12 w=1.2u l=0.13u
MP8516 (qm8509 n108 storage8512 vdd) p12 w=3.6u l=0.13u
MN8517 (qmb8510 storage8512 vss vss) n12 w=0.5u l=0.13u
MP8518 (qmb8510 storage8512 vdd vdd) p12 w=1.5u l=0.13u
MN8519 (qm8509 qmb8510 vss vss) n12 w=0.5u l=0.13u
MP8520 (qm8509 qmb8510 vdd vdd) p12 w=1.5u l=0.13u
MN8521 (storage8512 rst vss vss) n12 w=2u l=0.13u
MN8523 (qm8509 n102 storage8522 vss) n12 w=1.2u l=0.13u
MP8524 (qm8509 n108 storage8522 vdd) p12 w=3.6u l=0.13u
MN8525 (fail n93 storage8522 vss) n12 w=1.2u l=0.13u
MP8526 (fail n105 storage8522 vdd) p12 w=3.6u l=0.13u
MN8527 (qb8511 storage8522 vss vss) n12 w=0.5u l=0.13u
MP8528 (qb8511 storage8522 vdd vdd) p12 w=1.5u l=0.13u
MN8529 (fail qb8511 vss vss) n12 w=0.5u l=0.13u
MP8530 (fail qb8511 vdd vdd) p12 w=1.5u l=0.13u
MN8531 (storage8522 rst vss vss) n12 w=2u l=0.13u
MN8533 (n8532 n8313 vss vss) n12 w=0.8u l=0.13u
MP8534 (n8532 n8313 vdd vdd) p12 w=2.4u l=0.13u
MN8537 (n8535 n7758 n8536 vss) n12 w=1.6u l=0.13u
MN8538 (n8536 n8532 vss vss) n12 w=1.6u l=0.13u
MP8539 (n8535 n7758 vdd vdd) p12 w=2.4u l=0.13u
MP8540 (n8535 n8532 vdd vdd) p12 w=2.4u l=0.13u
MN8542 (n8541 n8535 vss vss) n12 w=0.8u l=0.13u
MP8543 (n8541 n8535 vdd vdd) p12 w=2.4u l=0.13u
MN8546 (n8544 s0 n8545 vss) n12 w=1.6u l=0.13u
MN8547 (n8545 step1 vss vss) n12 w=1.6u l=0.13u
MP8548 (n8544 s0 vdd vdd) p12 w=2.4u l=0.13u
MP8549 (n8544 step1 vdd vdd) p12 w=2.4u l=0.13u
MN8552 (n8550 n8544 n8551 vss) n12 w=1.6u l=0.13u
MN8553 (n8551 s0 vss vss) n12 w=1.6u l=0.13u
MP8554 (n8550 n8544 vdd vdd) p12 w=2.4u l=0.13u
MP8555 (n8550 s0 vdd vdd) p12 w=2.4u l=0.13u
MN8558 (n8556 n8544 n8557 vss) n12 w=1.6u l=0.13u
MN8559 (n8557 step1 vss vss) n12 w=1.6u l=0.13u
MP8560 (n8556 n8544 vdd vdd) p12 w=2.4u l=0.13u
MP8561 (n8556 step1 vdd vdd) p12 w=2.4u l=0.13u
MN8564 (n8562 n8550 n8563 vss) n12 w=1.6u l=0.13u
MN8565 (n8563 n8556 vss vss) n12 w=1.6u l=0.13u
MP8566 (n8562 n8550 vdd vdd) p12 w=2.4u l=0.13u
MP8567 (n8562 n8556 vdd vdd) p12 w=2.4u l=0.13u
MN8570 (n8568 n8541 n8569 vss) n12 w=1.6u l=0.13u
MN8571 (n8569 n8562 vss vss) n12 w=1.6u l=0.13u
MP8572 (n8568 n8541 vdd vdd) p12 w=2.4u l=0.13u
MP8573 (n8568 n8562 vdd vdd) p12 w=2.4u l=0.13u
MN8575 (n8574 n8541 vss vss) n12 w=0.8u l=0.13u
MP8576 (n8574 n8541 vdd vdd) p12 w=2.4u l=0.13u
MN8579 (n8577 n8574 n8578 vss) n12 w=1.6u l=0.13u
MN8580 (n8578 s0 vss vss) n12 w=1.6u l=0.13u
MP8581 (n8577 n8574 vdd vdd) p12 w=2.4u l=0.13u
MP8582 (n8577 s0 vdd vdd) p12 w=2.4u l=0.13u
MN8585 (n8583 n8568 n8584 vss) n12 w=1.6u l=0.13u
MN8586 (n8584 n8577 vss vss) n12 w=1.6u l=0.13u
MP8587 (n8583 n8568 vdd vdd) p12 w=2.4u l=0.13u
MP8588 (n8583 n8577 vdd vdd) p12 w=2.4u l=0.13u
MN8593 (n8583 n93 storage8592 vss) n12 w=1.2u l=0.13u
MP8594 (n8583 n105 storage8592 vdd) p12 w=3.6u l=0.13u
MN8595 (qm8589 n102 storage8592 vss) n12 w=1.2u l=0.13u
MP8596 (qm8589 n108 storage8592 vdd) p12 w=3.6u l=0.13u
MN8597 (qmb8590 storage8592 vss vss) n12 w=0.5u l=0.13u
MP8598 (qmb8590 storage8592 vdd vdd) p12 w=1.5u l=0.13u
MN8599 (qm8589 qmb8590 vss vss) n12 w=0.5u l=0.13u
MP8600 (qm8589 qmb8590 vdd vdd) p12 w=1.5u l=0.13u
MN8601 (storage8592 rst vss vss) n12 w=2u l=0.13u
MN8603 (qm8589 n102 storage8602 vss) n12 w=1.2u l=0.13u
MP8604 (qm8589 n108 storage8602 vdd) p12 w=3.6u l=0.13u
MN8605 (s0 n93 storage8602 vss) n12 w=1.2u l=0.13u
MP8606 (s0 n105 storage8602 vdd) p12 w=3.6u l=0.13u
MN8607 (qb8591 storage8602 vss vss) n12 w=0.5u l=0.13u
MP8608 (qb8591 storage8602 vdd vdd) p12 w=1.5u l=0.13u
MN8609 (s0 qb8591 vss vss) n12 w=0.5u l=0.13u
MP8610 (s0 qb8591 vdd vdd) p12 w=1.5u l=0.13u
MN8611 (storage8602 rst vss vss) n12 w=2u l=0.13u
MN8613 (n8612 s0 vss vss) n12 w=0.8u l=0.13u
MP8614 (n8612 s0 vdd vdd) p12 w=2.4u l=0.13u
MN8617 (n8615 n8612 n8616 vss) n12 w=1.6u l=0.13u
MN8618 (n8616 step1 vss vss) n12 w=1.6u l=0.13u
MP8619 (n8615 n8612 vdd vdd) p12 w=2.4u l=0.13u
MP8620 (n8615 step1 vdd vdd) p12 w=2.4u l=0.13u
MN8622 (n8621 n8615 vss vss) n12 w=0.8u l=0.13u
MP8623 (n8621 n8615 vdd vdd) p12 w=2.4u l=0.13u
MN8625 (n8624 n8544 vss vss) n12 w=0.8u l=0.13u
MP8626 (n8624 n8544 vdd vdd) p12 w=2.4u l=0.13u
MN8629 (n8627 n8621 vss vss) n12 w=0.8u l=0.13u
MN8630 (n8627 step2 vss vss) n12 w=0.8u l=0.13u
MP8631 (n8627 n8621 n8628 vdd) p12 w=4.8u l=0.13u
MP8632 (n8628 step2 vdd vdd) p12 w=4.8u l=0.13u
MN8634 (n8633 n8627 vss vss) n12 w=0.8u l=0.13u
MP8635 (n8633 n8627 vdd vdd) p12 w=2.4u l=0.13u
MN8638 (n8636 n8624 vss vss) n12 w=0.8u l=0.13u
MN8639 (n8636 step2 vss vss) n12 w=0.8u l=0.13u
MP8640 (n8636 n8624 n8637 vdd) p12 w=4.8u l=0.13u
MP8641 (n8637 step2 vdd vdd) p12 w=4.8u l=0.13u
MN8643 (n8642 n8636 vss vss) n12 w=0.8u l=0.13u
MP8644 (n8642 n8636 vdd vdd) p12 w=2.4u l=0.13u
MN8647 (n8645 n8633 n8646 vss) n12 w=1.6u l=0.13u
MN8648 (n8646 was_fast vss vss) n12 w=1.6u l=0.13u
MP8649 (n8645 n8633 vdd vdd) p12 w=2.4u l=0.13u
MP8650 (n8645 was_fast vdd vdd) p12 w=2.4u l=0.13u
MN8652 (n8651 was_fast vss vss) n12 w=0.8u l=0.13u
MP8653 (n8651 was_fast vdd vdd) p12 w=2.4u l=0.13u
MN8656 (n8654 n8642 n8655 vss) n12 w=1.6u l=0.13u
MN8657 (n8655 n8651 vss vss) n12 w=1.6u l=0.13u
MP8658 (n8654 n8642 vdd vdd) p12 w=2.4u l=0.13u
MP8659 (n8654 n8651 vdd vdd) p12 w=2.4u l=0.13u
MN8662 (n8660 n8645 n8661 vss) n12 w=1.6u l=0.13u
MN8663 (n8661 n8654 vss vss) n12 w=1.6u l=0.13u
MP8664 (n8660 n8645 vdd vdd) p12 w=2.4u l=0.13u
MP8665 (n8660 n8654 vdd vdd) p12 w=2.4u l=0.13u
MN8668 (n8666 n8660 n8667 vss) n12 w=1.6u l=0.13u
MN8669 (n8667 s1 vss vss) n12 w=1.6u l=0.13u
MP8670 (n8666 n8660 vdd vdd) p12 w=2.4u l=0.13u
MP8671 (n8666 s1 vdd vdd) p12 w=2.4u l=0.13u
MN8674 (n8672 n8660 n8673 vss) n12 w=1.6u l=0.13u
MN8675 (n8673 n8666 vss vss) n12 w=1.6u l=0.13u
MP8676 (n8672 n8660 vdd vdd) p12 w=2.4u l=0.13u
MP8677 (n8672 n8666 vdd vdd) p12 w=2.4u l=0.13u
MN8680 (n8678 n8666 n8679 vss) n12 w=1.6u l=0.13u
MN8681 (n8679 s1 vss vss) n12 w=1.6u l=0.13u
MP8682 (n8678 n8666 vdd vdd) p12 w=2.4u l=0.13u
MP8683 (n8678 s1 vdd vdd) p12 w=2.4u l=0.13u
MN8686 (n8684 n8672 n8685 vss) n12 w=1.6u l=0.13u
MN8687 (n8685 n8678 vss vss) n12 w=1.6u l=0.13u
MP8688 (n8684 n8672 vdd vdd) p12 w=2.4u l=0.13u
MP8689 (n8684 n8678 vdd vdd) p12 w=2.4u l=0.13u
MN8692 (n8690 n8541 n8691 vss) n12 w=1.6u l=0.13u
MN8693 (n8691 n8684 vss vss) n12 w=1.6u l=0.13u
MP8694 (n8690 n8541 vdd vdd) p12 w=2.4u l=0.13u
MP8695 (n8690 n8684 vdd vdd) p12 w=2.4u l=0.13u
MN8698 (n8696 n8574 n8697 vss) n12 w=1.6u l=0.13u
MN8699 (n8697 s1 vss vss) n12 w=1.6u l=0.13u
MP8700 (n8696 n8574 vdd vdd) p12 w=2.4u l=0.13u
MP8701 (n8696 s1 vdd vdd) p12 w=2.4u l=0.13u
MN8704 (n8702 n8690 n8703 vss) n12 w=1.6u l=0.13u
MN8705 (n8703 n8696 vss vss) n12 w=1.6u l=0.13u
MP8706 (n8702 n8690 vdd vdd) p12 w=2.4u l=0.13u
MP8707 (n8702 n8696 vdd vdd) p12 w=2.4u l=0.13u
MN8712 (n8702 n93 storage8711 vss) n12 w=1.2u l=0.13u
MP8713 (n8702 n105 storage8711 vdd) p12 w=3.6u l=0.13u
MN8714 (qm8708 n102 storage8711 vss) n12 w=1.2u l=0.13u
MP8715 (qm8708 n108 storage8711 vdd) p12 w=3.6u l=0.13u
MN8716 (qmb8709 storage8711 vss vss) n12 w=0.5u l=0.13u
MP8717 (qmb8709 storage8711 vdd vdd) p12 w=1.5u l=0.13u
MN8718 (qm8708 qmb8709 vss vss) n12 w=0.5u l=0.13u
MP8719 (qm8708 qmb8709 vdd vdd) p12 w=1.5u l=0.13u
MN8720 (storage8711 rst vss vss) n12 w=2u l=0.13u
MN8722 (qm8708 n102 storage8721 vss) n12 w=1.2u l=0.13u
MP8723 (qm8708 n108 storage8721 vdd) p12 w=3.6u l=0.13u
MN8724 (s1 n93 storage8721 vss) n12 w=1.2u l=0.13u
MP8725 (s1 n105 storage8721 vdd) p12 w=3.6u l=0.13u
MN8726 (qb8710 storage8721 vss vss) n12 w=0.5u l=0.13u
MP8727 (qb8710 storage8721 vdd vdd) p12 w=1.5u l=0.13u
MN8728 (s1 qb8710 vss vss) n12 w=0.5u l=0.13u
MP8729 (s1 qb8710 vdd vdd) p12 w=1.5u l=0.13u
MN8730 (storage8721 rst vss vss) n12 w=2u l=0.13u
MN8733 (n8731 n8196 n8732 vss) n12 w=1.6u l=0.13u
MN8734 (n8732 n8621 vss vss) n12 w=1.6u l=0.13u
MP8735 (n8731 n8196 vdd vdd) p12 w=2.4u l=0.13u
MP8736 (n8731 n8621 vdd vdd) p12 w=2.4u l=0.13u
MN8738 (n8737 n8731 vss vss) n12 w=0.8u l=0.13u
MP8739 (n8737 n8731 vdd vdd) p12 w=2.4u l=0.13u
MN8742 (n8740 n8624 n8741 vss) n12 w=1.6u l=0.13u
MN8743 (n8741 s1 vss vss) n12 w=1.6u l=0.13u
MP8744 (n8740 n8624 vdd vdd) p12 w=2.4u l=0.13u
MP8745 (n8740 s1 vdd vdd) p12 w=2.4u l=0.13u
MN8747 (n8746 n8740 vss vss) n12 w=0.8u l=0.13u
MP8748 (n8746 n8740 vdd vdd) p12 w=2.4u l=0.13u
MN8751 (n8749 n8196 n8750 vss) n12 w=1.6u l=0.13u
MN8752 (n8750 step2 vss vss) n12 w=1.6u l=0.13u
MP8753 (n8749 n8196 vdd vdd) p12 w=2.4u l=0.13u
MP8754 (n8749 step2 vdd vdd) p12 w=2.4u l=0.13u
MN8756 (n8755 n8749 vss vss) n12 w=0.8u l=0.13u
MP8757 (n8755 n8749 vdd vdd) p12 w=2.4u l=0.13u
MN8760 (n8758 s1 n8759 vss) n12 w=1.6u l=0.13u
MN8761 (n8759 step2 vss vss) n12 w=1.6u l=0.13u
MP8762 (n8758 s1 vdd vdd) p12 w=2.4u l=0.13u
MP8763 (n8758 step2 vdd vdd) p12 w=2.4u l=0.13u
MN8765 (n8764 n8758 vss vss) n12 w=0.8u l=0.13u
MP8766 (n8764 n8758 vdd vdd) p12 w=2.4u l=0.13u
MN8769 (n8767 n8737 vss vss) n12 w=0.8u l=0.13u
MN8770 (n8767 n8755 vss vss) n12 w=0.8u l=0.13u
MP8771 (n8767 n8737 n8768 vdd) p12 w=4.8u l=0.13u
MP8772 (n8768 n8755 vdd vdd) p12 w=4.8u l=0.13u
MN8774 (n8773 n8767 vss vss) n12 w=0.8u l=0.13u
MP8775 (n8773 n8767 vdd vdd) p12 w=2.4u l=0.13u
MN8778 (n8776 n8773 vss vss) n12 w=0.8u l=0.13u
MN8779 (n8776 step4 vss vss) n12 w=0.8u l=0.13u
MP8780 (n8776 n8773 n8777 vdd) p12 w=4.8u l=0.13u
MP8781 (n8777 step4 vdd vdd) p12 w=4.8u l=0.13u
MN8783 (n8782 n8776 vss vss) n12 w=0.8u l=0.13u
MP8784 (n8782 n8776 vdd vdd) p12 w=2.4u l=0.13u
MN8787 (n8785 n8746 vss vss) n12 w=0.8u l=0.13u
MN8788 (n8785 n8764 vss vss) n12 w=0.8u l=0.13u
MP8789 (n8785 n8746 n8786 vdd) p12 w=4.8u l=0.13u
MP8790 (n8786 n8764 vdd vdd) p12 w=4.8u l=0.13u
MN8792 (n8791 n8785 vss vss) n12 w=0.8u l=0.13u
MP8793 (n8791 n8785 vdd vdd) p12 w=2.4u l=0.13u
MN8796 (n8794 n8791 vss vss) n12 w=0.8u l=0.13u
MN8797 (n8794 step4 vss vss) n12 w=0.8u l=0.13u
MP8798 (n8794 n8791 n8795 vdd) p12 w=4.8u l=0.13u
MP8799 (n8795 step4 vdd vdd) p12 w=4.8u l=0.13u
MN8801 (n8800 n8794 vss vss) n12 w=0.8u l=0.13u
MP8802 (n8800 n8794 vdd vdd) p12 w=2.4u l=0.13u
MN8805 (n8803 n8782 n8804 vss) n12 w=1.6u l=0.13u
MN8806 (n8804 was_fast vss vss) n12 w=1.6u l=0.13u
MP8807 (n8803 n8782 vdd vdd) p12 w=2.4u l=0.13u
MP8808 (n8803 was_fast vdd vdd) p12 w=2.4u l=0.13u
MN8811 (n8809 n8651 n8810 vss) n12 w=1.6u l=0.13u
MN8812 (n8810 n8800 vss vss) n12 w=1.6u l=0.13u
MP8813 (n8809 n8651 vdd vdd) p12 w=2.4u l=0.13u
MP8814 (n8809 n8800 vdd vdd) p12 w=2.4u l=0.13u
MN8817 (n8815 n8803 n8816 vss) n12 w=1.6u l=0.13u
MN8818 (n8816 n8809 vss vss) n12 w=1.6u l=0.13u
MP8819 (n8815 n8803 vdd vdd) p12 w=2.4u l=0.13u
MP8820 (n8815 n8809 vdd vdd) p12 w=2.4u l=0.13u
MN8823 (n8821 n8815 n8822 vss) n12 w=1.6u l=0.13u
MN8824 (n8822 s2 vss vss) n12 w=1.6u l=0.13u
MP8825 (n8821 n8815 vdd vdd) p12 w=2.4u l=0.13u
MP8826 (n8821 s2 vdd vdd) p12 w=2.4u l=0.13u
MN8829 (n8827 n8815 n8828 vss) n12 w=1.6u l=0.13u
MN8830 (n8828 n8821 vss vss) n12 w=1.6u l=0.13u
MP8831 (n8827 n8815 vdd vdd) p12 w=2.4u l=0.13u
MP8832 (n8827 n8821 vdd vdd) p12 w=2.4u l=0.13u
MN8835 (n8833 n8821 n8834 vss) n12 w=1.6u l=0.13u
MN8836 (n8834 s2 vss vss) n12 w=1.6u l=0.13u
MP8837 (n8833 n8821 vdd vdd) p12 w=2.4u l=0.13u
MP8838 (n8833 s2 vdd vdd) p12 w=2.4u l=0.13u
MN8841 (n8839 n8827 n8840 vss) n12 w=1.6u l=0.13u
MN8842 (n8840 n8833 vss vss) n12 w=1.6u l=0.13u
MP8843 (n8839 n8827 vdd vdd) p12 w=2.4u l=0.13u
MP8844 (n8839 n8833 vdd vdd) p12 w=2.4u l=0.13u
MN8847 (n8845 n8541 n8846 vss) n12 w=1.6u l=0.13u
MN8848 (n8846 n8839 vss vss) n12 w=1.6u l=0.13u
MP8849 (n8845 n8541 vdd vdd) p12 w=2.4u l=0.13u
MP8850 (n8845 n8839 vdd vdd) p12 w=2.4u l=0.13u
MN8853 (n8851 n8574 n8852 vss) n12 w=1.6u l=0.13u
MN8854 (n8852 s2 vss vss) n12 w=1.6u l=0.13u
MP8855 (n8851 n8574 vdd vdd) p12 w=2.4u l=0.13u
MP8856 (n8851 s2 vdd vdd) p12 w=2.4u l=0.13u
MN8859 (n8857 n8845 n8858 vss) n12 w=1.6u l=0.13u
MN8860 (n8858 n8851 vss vss) n12 w=1.6u l=0.13u
MP8861 (n8857 n8845 vdd vdd) p12 w=2.4u l=0.13u
MP8862 (n8857 n8851 vdd vdd) p12 w=2.4u l=0.13u
MN8867 (n8857 n93 storage8866 vss) n12 w=1.2u l=0.13u
MP8868 (n8857 n105 storage8866 vdd) p12 w=3.6u l=0.13u
MN8869 (qm8863 n102 storage8866 vss) n12 w=1.2u l=0.13u
MP8870 (qm8863 n108 storage8866 vdd) p12 w=3.6u l=0.13u
MN8871 (qmb8864 storage8866 vss vss) n12 w=0.5u l=0.13u
MP8872 (qmb8864 storage8866 vdd vdd) p12 w=1.5u l=0.13u
MN8873 (qm8863 qmb8864 vss vss) n12 w=0.5u l=0.13u
MP8874 (qm8863 qmb8864 vdd vdd) p12 w=1.5u l=0.13u
MN8875 (storage8866 rst vss vss) n12 w=2u l=0.13u
MN8877 (qm8863 n102 storage8876 vss) n12 w=1.2u l=0.13u
MP8878 (qm8863 n108 storage8876 vdd) p12 w=3.6u l=0.13u
MN8879 (s2 n93 storage8876 vss) n12 w=1.2u l=0.13u
MP8880 (s2 n105 storage8876 vdd) p12 w=3.6u l=0.13u
MN8881 (qb8865 storage8876 vss vss) n12 w=0.5u l=0.13u
MP8882 (qb8865 storage8876 vdd vdd) p12 w=1.5u l=0.13u
MN8883 (s2 qb8865 vss vss) n12 w=0.5u l=0.13u
MP8884 (s2 qb8865 vdd vdd) p12 w=1.5u l=0.13u
MN8885 (storage8876 rst vss vss) n12 w=2u l=0.13u
MN8888 (n8886 n8196 n8887 vss) n12 w=1.6u l=0.13u
MN8889 (n8887 n8199 vss vss) n12 w=1.6u l=0.13u
MP8890 (n8886 n8196 vdd vdd) p12 w=2.4u l=0.13u
MP8891 (n8886 n8199 vdd vdd) p12 w=2.4u l=0.13u
MN8893 (n8892 n8886 vss vss) n12 w=0.8u l=0.13u
MP8894 (n8892 n8886 vdd vdd) p12 w=2.4u l=0.13u
MN8897 (n8895 n8621 n8896 vss) n12 w=1.6u l=0.13u
MN8898 (n8896 n8892 vss vss) n12 w=1.6u l=0.13u
MP8899 (n8895 n8621 vdd vdd) p12 w=2.4u l=0.13u
MP8900 (n8895 n8892 vdd vdd) p12 w=2.4u l=0.13u
MN8902 (n8901 n8895 vss vss) n12 w=0.8u l=0.13u
MP8903 (n8901 n8895 vdd vdd) p12 w=2.4u l=0.13u
MN8906 (n8904 s1 n8905 vss) n12 w=1.6u l=0.13u
MN8907 (n8905 s2 vss vss) n12 w=1.6u l=0.13u
MP8908 (n8904 s1 vdd vdd) p12 w=2.4u l=0.13u
MP8909 (n8904 s2 vdd vdd) p12 w=2.4u l=0.13u
MN8911 (n8910 n8904 vss vss) n12 w=0.8u l=0.13u
MP8912 (n8910 n8904 vdd vdd) p12 w=2.4u l=0.13u
MN8915 (n8913 n8624 n8914 vss) n12 w=1.6u l=0.13u
MN8916 (n8914 n8910 vss vss) n12 w=1.6u l=0.13u
MP8917 (n8913 n8624 vdd vdd) p12 w=2.4u l=0.13u
MP8918 (n8913 n8910 vdd vdd) p12 w=2.4u l=0.13u
MN8920 (n8919 n8913 vss vss) n12 w=0.8u l=0.13u
MP8921 (n8919 n8913 vdd vdd) p12 w=2.4u l=0.13u
MN8924 (n8922 n8199 n8923 vss) n12 w=1.6u l=0.13u
MN8925 (n8923 n8755 vss vss) n12 w=1.6u l=0.13u
MP8926 (n8922 n8199 vdd vdd) p12 w=2.4u l=0.13u
MP8927 (n8922 n8755 vdd vdd) p12 w=2.4u l=0.13u
MN8929 (n8928 n8922 vss vss) n12 w=0.8u l=0.13u
MP8930 (n8928 n8922 vdd vdd) p12 w=2.4u l=0.13u
MN8933 (n8931 n8764 n8932 vss) n12 w=1.6u l=0.13u
MN8934 (n8932 s2 vss vss) n12 w=1.6u l=0.13u
MP8935 (n8931 n8764 vdd vdd) p12 w=2.4u l=0.13u
MP8936 (n8931 s2 vdd vdd) p12 w=2.4u l=0.13u
MN8938 (n8937 n8931 vss vss) n12 w=0.8u l=0.13u
MP8939 (n8937 n8931 vdd vdd) p12 w=2.4u l=0.13u
MN8942 (n8940 n8199 n8941 vss) n12 w=1.6u l=0.13u
MN8943 (n8941 step4 vss vss) n12 w=1.6u l=0.13u
MP8944 (n8940 n8199 vdd vdd) p12 w=2.4u l=0.13u
MP8945 (n8940 step4 vdd vdd) p12 w=2.4u l=0.13u
MN8947 (n8946 n8940 vss vss) n12 w=0.8u l=0.13u
MP8948 (n8946 n8940 vdd vdd) p12 w=2.4u l=0.13u
MN8951 (n8949 s2 n8950 vss) n12 w=1.6u l=0.13u
MN8952 (n8950 step4 vss vss) n12 w=1.6u l=0.13u
MP8953 (n8949 s2 vdd vdd) p12 w=2.4u l=0.13u
MP8954 (n8949 step4 vdd vdd) p12 w=2.4u l=0.13u
MN8956 (n8955 n8949 vss vss) n12 w=0.8u l=0.13u
MP8957 (n8955 n8949 vdd vdd) p12 w=2.4u l=0.13u
MN8960 (n8958 n8901 vss vss) n12 w=0.8u l=0.13u
MN8961 (n8958 n8928 vss vss) n12 w=0.8u l=0.13u
MP8962 (n8958 n8901 n8959 vdd) p12 w=4.8u l=0.13u
MP8963 (n8959 n8928 vdd vdd) p12 w=4.8u l=0.13u
MN8965 (n8964 n8958 vss vss) n12 w=0.8u l=0.13u
MP8966 (n8964 n8958 vdd vdd) p12 w=2.4u l=0.13u
MN8969 (n8967 n8946 vss vss) n12 w=0.8u l=0.13u
MN8970 (n8967 step8 vss vss) n12 w=0.8u l=0.13u
MP8971 (n8967 n8946 n8968 vdd) p12 w=4.8u l=0.13u
MP8972 (n8968 step8 vdd vdd) p12 w=4.8u l=0.13u
MN8974 (n8973 n8967 vss vss) n12 w=0.8u l=0.13u
MP8975 (n8973 n8967 vdd vdd) p12 w=2.4u l=0.13u
MN8978 (n8976 n8964 vss vss) n12 w=0.8u l=0.13u
MN8979 (n8976 n8973 vss vss) n12 w=0.8u l=0.13u
MP8980 (n8976 n8964 n8977 vdd) p12 w=4.8u l=0.13u
MP8981 (n8977 n8973 vdd vdd) p12 w=4.8u l=0.13u
MN8983 (n8982 n8976 vss vss) n12 w=0.8u l=0.13u
MP8984 (n8982 n8976 vdd vdd) p12 w=2.4u l=0.13u
MN8987 (n8985 n8919 vss vss) n12 w=0.8u l=0.13u
MN8988 (n8985 n8937 vss vss) n12 w=0.8u l=0.13u
MP8989 (n8985 n8919 n8986 vdd) p12 w=4.8u l=0.13u
MP8990 (n8986 n8937 vdd vdd) p12 w=4.8u l=0.13u
MN8992 (n8991 n8985 vss vss) n12 w=0.8u l=0.13u
MP8993 (n8991 n8985 vdd vdd) p12 w=2.4u l=0.13u
MN8996 (n8994 n8955 vss vss) n12 w=0.8u l=0.13u
MN8997 (n8994 step8 vss vss) n12 w=0.8u l=0.13u
MP8998 (n8994 n8955 n8995 vdd) p12 w=4.8u l=0.13u
MP8999 (n8995 step8 vdd vdd) p12 w=4.8u l=0.13u
MN9001 (n9000 n8994 vss vss) n12 w=0.8u l=0.13u
MP9002 (n9000 n8994 vdd vdd) p12 w=2.4u l=0.13u
MN9005 (n9003 n8991 vss vss) n12 w=0.8u l=0.13u
MN9006 (n9003 n9000 vss vss) n12 w=0.8u l=0.13u
MP9007 (n9003 n8991 n9004 vdd) p12 w=4.8u l=0.13u
MP9008 (n9004 n9000 vdd vdd) p12 w=4.8u l=0.13u
MN9010 (n9009 n9003 vss vss) n12 w=0.8u l=0.13u
MP9011 (n9009 n9003 vdd vdd) p12 w=2.4u l=0.13u
MN9014 (n9012 n8982 n9013 vss) n12 w=1.6u l=0.13u
MN9015 (n9013 was_fast vss vss) n12 w=1.6u l=0.13u
MP9016 (n9012 n8982 vdd vdd) p12 w=2.4u l=0.13u
MP9017 (n9012 was_fast vdd vdd) p12 w=2.4u l=0.13u
MN9020 (n9018 n8651 n9019 vss) n12 w=1.6u l=0.13u
MN9021 (n9019 n9009 vss vss) n12 w=1.6u l=0.13u
MP9022 (n9018 n8651 vdd vdd) p12 w=2.4u l=0.13u
MP9023 (n9018 n9009 vdd vdd) p12 w=2.4u l=0.13u
MN9026 (n9024 n9012 n9025 vss) n12 w=1.6u l=0.13u
MN9027 (n9025 n9018 vss vss) n12 w=1.6u l=0.13u
MP9028 (n9024 n9012 vdd vdd) p12 w=2.4u l=0.13u
MP9029 (n9024 n9018 vdd vdd) p12 w=2.4u l=0.13u
MN9032 (n9030 n9024 n9031 vss) n12 w=1.6u l=0.13u
MN9033 (n9031 s3 vss vss) n12 w=1.6u l=0.13u
MP9034 (n9030 n9024 vdd vdd) p12 w=2.4u l=0.13u
MP9035 (n9030 s3 vdd vdd) p12 w=2.4u l=0.13u
MN9038 (n9036 n9024 n9037 vss) n12 w=1.6u l=0.13u
MN9039 (n9037 n9030 vss vss) n12 w=1.6u l=0.13u
MP9040 (n9036 n9024 vdd vdd) p12 w=2.4u l=0.13u
MP9041 (n9036 n9030 vdd vdd) p12 w=2.4u l=0.13u
MN9044 (n9042 n9030 n9043 vss) n12 w=1.6u l=0.13u
MN9045 (n9043 s3 vss vss) n12 w=1.6u l=0.13u
MP9046 (n9042 n9030 vdd vdd) p12 w=2.4u l=0.13u
MP9047 (n9042 s3 vdd vdd) p12 w=2.4u l=0.13u
MN9050 (n9048 n9036 n9049 vss) n12 w=1.6u l=0.13u
MN9051 (n9049 n9042 vss vss) n12 w=1.6u l=0.13u
MP9052 (n9048 n9036 vdd vdd) p12 w=2.4u l=0.13u
MP9053 (n9048 n9042 vdd vdd) p12 w=2.4u l=0.13u
MN9056 (n9054 n8541 n9055 vss) n12 w=1.6u l=0.13u
MN9057 (n9055 n9048 vss vss) n12 w=1.6u l=0.13u
MP9058 (n9054 n8541 vdd vdd) p12 w=2.4u l=0.13u
MP9059 (n9054 n9048 vdd vdd) p12 w=2.4u l=0.13u
MN9062 (n9060 n8574 n9061 vss) n12 w=1.6u l=0.13u
MN9063 (n9061 s3 vss vss) n12 w=1.6u l=0.13u
MP9064 (n9060 n8574 vdd vdd) p12 w=2.4u l=0.13u
MP9065 (n9060 s3 vdd vdd) p12 w=2.4u l=0.13u
MN9068 (n9066 n9054 n9067 vss) n12 w=1.6u l=0.13u
MN9069 (n9067 n9060 vss vss) n12 w=1.6u l=0.13u
MP9070 (n9066 n9054 vdd vdd) p12 w=2.4u l=0.13u
MP9071 (n9066 n9060 vdd vdd) p12 w=2.4u l=0.13u
MN9076 (n9066 n93 storage9075 vss) n12 w=1.2u l=0.13u
MP9077 (n9066 n105 storage9075 vdd) p12 w=3.6u l=0.13u
MN9078 (qm9072 n102 storage9075 vss) n12 w=1.2u l=0.13u
MP9079 (qm9072 n108 storage9075 vdd) p12 w=3.6u l=0.13u
MN9080 (qmb9073 storage9075 vss vss) n12 w=0.5u l=0.13u
MP9081 (qmb9073 storage9075 vdd vdd) p12 w=1.5u l=0.13u
MN9082 (qm9072 qmb9073 vss vss) n12 w=0.5u l=0.13u
MP9083 (qm9072 qmb9073 vdd vdd) p12 w=1.5u l=0.13u
MN9084 (storage9075 rst vss vss) n12 w=2u l=0.13u
MN9086 (qm9072 n102 storage9085 vss) n12 w=1.2u l=0.13u
MP9087 (qm9072 n108 storage9085 vdd) p12 w=3.6u l=0.13u
MN9088 (s3 n93 storage9085 vss) n12 w=1.2u l=0.13u
MP9089 (s3 n105 storage9085 vdd) p12 w=3.6u l=0.13u
MN9090 (qb9074 storage9085 vss vss) n12 w=0.5u l=0.13u
MP9091 (qb9074 storage9085 vdd vdd) p12 w=1.5u l=0.13u
MN9092 (s3 qb9074 vss vss) n12 w=0.5u l=0.13u
MP9093 (s3 qb9074 vdd vdd) p12 w=1.5u l=0.13u
MN9094 (storage9085 rst vss vss) n12 w=2u l=0.13u
MN9097 (n9095 n8202 n9096 vss) n12 w=1.6u l=0.13u
MN9098 (n9096 n8901 vss vss) n12 w=1.6u l=0.13u
MP9099 (n9095 n8202 vdd vdd) p12 w=2.4u l=0.13u
MP9100 (n9095 n8901 vdd vdd) p12 w=2.4u l=0.13u
MN9102 (n9101 n9095 vss vss) n12 w=0.8u l=0.13u
MP9103 (n9101 n9095 vdd vdd) p12 w=2.4u l=0.13u
MN9106 (n9104 n8919 n9105 vss) n12 w=1.6u l=0.13u
MN9107 (n9105 s3 vss vss) n12 w=1.6u l=0.13u
MP9108 (n9104 n8919 vdd vdd) p12 w=2.4u l=0.13u
MP9109 (n9104 s3 vdd vdd) p12 w=2.4u l=0.13u
MN9111 (n9110 n9104 vss vss) n12 w=0.8u l=0.13u
MP9112 (n9110 n9104 vdd vdd) p12 w=2.4u l=0.13u
MN9115 (n9113 n8223 n9114 vss) n12 w=1.6u l=0.13u
MN9116 (n9114 n8755 vss vss) n12 w=1.6u l=0.13u
MP9117 (n9113 n8223 vdd vdd) p12 w=2.4u l=0.13u
MP9118 (n9113 n8755 vdd vdd) p12 w=2.4u l=0.13u
MN9120 (n9119 n9113 vss vss) n12 w=0.8u l=0.13u
MP9121 (n9119 n9113 vdd vdd) p12 w=2.4u l=0.13u
MN9124 (n9122 n8259 n9123 vss) n12 w=1.6u l=0.13u
MN9125 (n9123 n8764 vss vss) n12 w=1.6u l=0.13u
MP9126 (n9122 n8259 vdd vdd) p12 w=2.4u l=0.13u
MP9127 (n9122 n8764 vdd vdd) p12 w=2.4u l=0.13u
MN9129 (n9128 n9122 vss vss) n12 w=0.8u l=0.13u
MP9130 (n9128 n9122 vdd vdd) p12 w=2.4u l=0.13u
MN9133 (n9131 n8202 n9132 vss) n12 w=1.6u l=0.13u
MN9134 (n9132 n8946 vss vss) n12 w=1.6u l=0.13u
MP9135 (n9131 n8202 vdd vdd) p12 w=2.4u l=0.13u
MP9136 (n9131 n8946 vdd vdd) p12 w=2.4u l=0.13u
MN9138 (n9137 n9131 vss vss) n12 w=0.8u l=0.13u
MP9139 (n9137 n9131 vdd vdd) p12 w=2.4u l=0.13u
MN9142 (n9140 n8955 n9141 vss) n12 w=1.6u l=0.13u
MN9143 (n9141 s3 vss vss) n12 w=1.6u l=0.13u
MP9144 (n9140 n8955 vdd vdd) p12 w=2.4u l=0.13u
MP9145 (n9140 s3 vdd vdd) p12 w=2.4u l=0.13u
MN9147 (n9146 n9140 vss vss) n12 w=0.8u l=0.13u
MP9148 (n9146 n9140 vdd vdd) p12 w=2.4u l=0.13u
MN9151 (n9149 n8202 n9150 vss) n12 w=1.6u l=0.13u
MN9152 (n9150 step8 vss vss) n12 w=1.6u l=0.13u
MP9153 (n9149 n8202 vdd vdd) p12 w=2.4u l=0.13u
MP9154 (n9149 step8 vdd vdd) p12 w=2.4u l=0.13u
MN9156 (n9155 n9149 vss vss) n12 w=0.8u l=0.13u
MP9157 (n9155 n9149 vdd vdd) p12 w=2.4u l=0.13u
MN9160 (n9158 s3 n9159 vss) n12 w=1.6u l=0.13u
MN9161 (n9159 step8 vss vss) n12 w=1.6u l=0.13u
MP9162 (n9158 s3 vdd vdd) p12 w=2.4u l=0.13u
MP9163 (n9158 step8 vdd vdd) p12 w=2.4u l=0.13u
MN9165 (n9164 n9158 vss vss) n12 w=0.8u l=0.13u
MP9166 (n9164 n9158 vdd vdd) p12 w=2.4u l=0.13u
MN9169 (n9167 n9101 vss vss) n12 w=0.8u l=0.13u
MN9170 (n9167 n9119 vss vss) n12 w=0.8u l=0.13u
MP9171 (n9167 n9101 n9168 vdd) p12 w=4.8u l=0.13u
MP9172 (n9168 n9119 vdd vdd) p12 w=4.8u l=0.13u
MN9174 (n9173 n9167 vss vss) n12 w=0.8u l=0.13u
MP9175 (n9173 n9167 vdd vdd) p12 w=2.4u l=0.13u
MN9178 (n9176 n9137 vss vss) n12 w=0.8u l=0.13u
MN9179 (n9176 n9155 vss vss) n12 w=0.8u l=0.13u
MP9180 (n9176 n9137 n9177 vdd) p12 w=4.8u l=0.13u
MP9181 (n9177 n9155 vdd vdd) p12 w=4.8u l=0.13u
MN9183 (n9182 n9176 vss vss) n12 w=0.8u l=0.13u
MP9184 (n9182 n9176 vdd vdd) p12 w=2.4u l=0.13u
MN9187 (n9185 n9173 vss vss) n12 w=0.8u l=0.13u
MN9188 (n9185 n9182 vss vss) n12 w=0.8u l=0.13u
MP9189 (n9185 n9173 n9186 vdd) p12 w=4.8u l=0.13u
MP9190 (n9186 n9182 vdd vdd) p12 w=4.8u l=0.13u
MN9192 (n9191 n9185 vss vss) n12 w=0.8u l=0.13u
MP9193 (n9191 n9185 vdd vdd) p12 w=2.4u l=0.13u
MN9196 (n9194 n9110 vss vss) n12 w=0.8u l=0.13u
MN9197 (n9194 n9128 vss vss) n12 w=0.8u l=0.13u
MP9198 (n9194 n9110 n9195 vdd) p12 w=4.8u l=0.13u
MP9199 (n9195 n9128 vdd vdd) p12 w=4.8u l=0.13u
MN9201 (n9200 n9194 vss vss) n12 w=0.8u l=0.13u
MP9202 (n9200 n9194 vdd vdd) p12 w=2.4u l=0.13u
MN9205 (n9203 n9146 vss vss) n12 w=0.8u l=0.13u
MN9206 (n9203 n9164 vss vss) n12 w=0.8u l=0.13u
MP9207 (n9203 n9146 n9204 vdd) p12 w=4.8u l=0.13u
MP9208 (n9204 n9164 vdd vdd) p12 w=4.8u l=0.13u
MN9210 (n9209 n9203 vss vss) n12 w=0.8u l=0.13u
MP9211 (n9209 n9203 vdd vdd) p12 w=2.4u l=0.13u
MN9214 (n9212 n9200 vss vss) n12 w=0.8u l=0.13u
MN9215 (n9212 n9209 vss vss) n12 w=0.8u l=0.13u
MP9216 (n9212 n9200 n9213 vdd) p12 w=4.8u l=0.13u
MP9217 (n9213 n9209 vdd vdd) p12 w=4.8u l=0.13u
MN9219 (n9218 n9212 vss vss) n12 w=0.8u l=0.13u
MP9220 (n9218 n9212 vdd vdd) p12 w=2.4u l=0.13u
MN9223 (n9221 n9191 n9222 vss) n12 w=1.6u l=0.13u
MN9224 (n9222 was_fast vss vss) n12 w=1.6u l=0.13u
MP9225 (n9221 n9191 vdd vdd) p12 w=2.4u l=0.13u
MP9226 (n9221 was_fast vdd vdd) p12 w=2.4u l=0.13u
MN9229 (n9227 n8651 n9228 vss) n12 w=1.6u l=0.13u
MN9230 (n9228 n9218 vss vss) n12 w=1.6u l=0.13u
MP9231 (n9227 n8651 vdd vdd) p12 w=2.4u l=0.13u
MP9232 (n9227 n9218 vdd vdd) p12 w=2.4u l=0.13u
MN9235 (n9233 n9221 n9234 vss) n12 w=1.6u l=0.13u
MN9236 (n9234 n9227 vss vss) n12 w=1.6u l=0.13u
MP9237 (n9233 n9221 vdd vdd) p12 w=2.4u l=0.13u
MP9238 (n9233 n9227 vdd vdd) p12 w=2.4u l=0.13u
MN9241 (n9239 n9233 n9240 vss) n12 w=1.6u l=0.13u
MN9242 (n9240 s4 vss vss) n12 w=1.6u l=0.13u
MP9243 (n9239 n9233 vdd vdd) p12 w=2.4u l=0.13u
MP9244 (n9239 s4 vdd vdd) p12 w=2.4u l=0.13u
MN9247 (n9245 n9233 n9246 vss) n12 w=1.6u l=0.13u
MN9248 (n9246 n9239 vss vss) n12 w=1.6u l=0.13u
MP9249 (n9245 n9233 vdd vdd) p12 w=2.4u l=0.13u
MP9250 (n9245 n9239 vdd vdd) p12 w=2.4u l=0.13u
MN9253 (n9251 n9239 n9252 vss) n12 w=1.6u l=0.13u
MN9254 (n9252 s4 vss vss) n12 w=1.6u l=0.13u
MP9255 (n9251 n9239 vdd vdd) p12 w=2.4u l=0.13u
MP9256 (n9251 s4 vdd vdd) p12 w=2.4u l=0.13u
MN9259 (n9257 n9245 n9258 vss) n12 w=1.6u l=0.13u
MN9260 (n9258 n9251 vss vss) n12 w=1.6u l=0.13u
MP9261 (n9257 n9245 vdd vdd) p12 w=2.4u l=0.13u
MP9262 (n9257 n9251 vdd vdd) p12 w=2.4u l=0.13u
MN9265 (n9263 n8541 n9264 vss) n12 w=1.6u l=0.13u
MN9266 (n9264 n9257 vss vss) n12 w=1.6u l=0.13u
MP9267 (n9263 n8541 vdd vdd) p12 w=2.4u l=0.13u
MP9268 (n9263 n9257 vdd vdd) p12 w=2.4u l=0.13u
MN9271 (n9269 n8574 n9270 vss) n12 w=1.6u l=0.13u
MN9272 (n9270 s4 vss vss) n12 w=1.6u l=0.13u
MP9273 (n9269 n8574 vdd vdd) p12 w=2.4u l=0.13u
MP9274 (n9269 s4 vdd vdd) p12 w=2.4u l=0.13u
MN9277 (n9275 n9263 n9276 vss) n12 w=1.6u l=0.13u
MN9278 (n9276 n9269 vss vss) n12 w=1.6u l=0.13u
MP9279 (n9275 n9263 vdd vdd) p12 w=2.4u l=0.13u
MP9280 (n9275 n9269 vdd vdd) p12 w=2.4u l=0.13u
MN9284 (n9283 n9275 vss vss) n12 w=0.8u l=0.13u
MP9285 (n9283 n9275 vdd vdd) p12 w=2.4u l=0.13u
MN9288 (n9283 n93 storage9287 vss) n12 w=1.2u l=0.13u
MP9289 (n9283 n105 storage9287 vdd) p12 w=3.6u l=0.13u
MN9290 (qm9281 n102 storage9287 vss) n12 w=1.2u l=0.13u
MP9291 (qm9281 n108 storage9287 vdd) p12 w=3.6u l=0.13u
MN9292 (qmb9282 storage9287 vss vss) n12 w=0.5u l=0.13u
MP9293 (qmb9282 storage9287 vdd vdd) p12 w=1.5u l=0.13u
MN9294 (qm9281 qmb9282 vss vss) n12 w=0.5u l=0.13u
MP9295 (qm9281 qmb9282 vdd vdd) p12 w=1.5u l=0.13u
MN9296 (storage9287 rst vss vss) n12 w=2u l=0.13u
MN9298 (qm9281 n102 storage9297 vss) n12 w=1.2u l=0.13u
MP9299 (qm9281 n108 storage9297 vdd) p12 w=3.6u l=0.13u
MN9300 (qneg9286 n93 storage9297 vss) n12 w=1.2u l=0.13u
MP9301 (qneg9286 n105 storage9297 vdd) p12 w=3.6u l=0.13u
MN9302 (s4 storage9297 vss vss) n12 w=0.5u l=0.13u
MP9303 (s4 storage9297 vdd vdd) p12 w=1.5u l=0.13u
MN9304 (qneg9286 s4 vss vss) n12 w=0.5u l=0.13u
MP9305 (qneg9286 s4 vdd vdd) p12 w=1.5u l=0.13u
MN9306 (storage9297 rst vss vss) n12 w=2u l=0.13u
MN9309 (n9307 n8541 n9308 vss) n12 w=1.6u l=0.13u
MN9310 (n9308 step2 vss vss) n12 w=1.6u l=0.13u
MP9311 (n9307 n8541 vdd vdd) p12 w=2.4u l=0.13u
MP9312 (n9307 step2 vdd vdd) p12 w=2.4u l=0.13u
MN9315 (n9313 n8574 n9314 vss) n12 w=1.6u l=0.13u
MN9316 (n9314 step1 vss vss) n12 w=1.6u l=0.13u
MP9317 (n9313 n8574 vdd vdd) p12 w=2.4u l=0.13u
MP9318 (n9313 step1 vdd vdd) p12 w=2.4u l=0.13u
MN9321 (n9319 n9307 n9320 vss) n12 w=1.6u l=0.13u
MN9322 (n9320 n9313 vss vss) n12 w=1.6u l=0.13u
MP9323 (n9319 n9307 vdd vdd) p12 w=2.4u l=0.13u
MP9324 (n9319 n9313 vdd vdd) p12 w=2.4u l=0.13u
MN9329 (n9319 n93 storage9328 vss) n12 w=1.2u l=0.13u
MP9330 (n9319 n105 storage9328 vdd) p12 w=3.6u l=0.13u
MN9331 (qm9325 n102 storage9328 vss) n12 w=1.2u l=0.13u
MP9332 (qm9325 n108 storage9328 vdd) p12 w=3.6u l=0.13u
MN9333 (qmb9326 storage9328 vss vss) n12 w=0.5u l=0.13u
MP9334 (qmb9326 storage9328 vdd vdd) p12 w=1.5u l=0.13u
MN9335 (qm9325 qmb9326 vss vss) n12 w=0.5u l=0.13u
MP9336 (qm9325 qmb9326 vdd vdd) p12 w=1.5u l=0.13u
MN9337 (storage9328 rst vss vss) n12 w=2u l=0.13u
MN9339 (qm9325 n102 storage9338 vss) n12 w=1.2u l=0.13u
MP9340 (qm9325 n108 storage9338 vdd) p12 w=3.6u l=0.13u
MN9341 (step1 n93 storage9338 vss) n12 w=1.2u l=0.13u
MP9342 (step1 n105 storage9338 vdd) p12 w=3.6u l=0.13u
MN9343 (qb9327 storage9338 vss vss) n12 w=0.5u l=0.13u
MP9344 (qb9327 storage9338 vdd vdd) p12 w=1.5u l=0.13u
MN9345 (step1 qb9327 vss vss) n12 w=0.5u l=0.13u
MP9346 (step1 qb9327 vdd vdd) p12 w=1.5u l=0.13u
MN9347 (storage9338 rst vss vss) n12 w=2u l=0.13u
MN9350 (n9348 n8541 n9349 vss) n12 w=1.6u l=0.13u
MN9351 (n9349 step4 vss vss) n12 w=1.6u l=0.13u
MP9352 (n9348 n8541 vdd vdd) p12 w=2.4u l=0.13u
MP9353 (n9348 step4 vdd vdd) p12 w=2.4u l=0.13u
MN9356 (n9354 n8574 n9355 vss) n12 w=1.6u l=0.13u
MN9357 (n9355 step2 vss vss) n12 w=1.6u l=0.13u
MP9358 (n9354 n8574 vdd vdd) p12 w=2.4u l=0.13u
MP9359 (n9354 step2 vdd vdd) p12 w=2.4u l=0.13u
MN9362 (n9360 n9348 n9361 vss) n12 w=1.6u l=0.13u
MN9363 (n9361 n9354 vss vss) n12 w=1.6u l=0.13u
MP9364 (n9360 n9348 vdd vdd) p12 w=2.4u l=0.13u
MP9365 (n9360 n9354 vdd vdd) p12 w=2.4u l=0.13u
MN9370 (n9360 n93 storage9369 vss) n12 w=1.2u l=0.13u
MP9371 (n9360 n105 storage9369 vdd) p12 w=3.6u l=0.13u
MN9372 (qm9366 n102 storage9369 vss) n12 w=1.2u l=0.13u
MP9373 (qm9366 n108 storage9369 vdd) p12 w=3.6u l=0.13u
MN9374 (qmb9367 storage9369 vss vss) n12 w=0.5u l=0.13u
MP9375 (qmb9367 storage9369 vdd vdd) p12 w=1.5u l=0.13u
MN9376 (qm9366 qmb9367 vss vss) n12 w=0.5u l=0.13u
MP9377 (qm9366 qmb9367 vdd vdd) p12 w=1.5u l=0.13u
MN9378 (storage9369 rst vss vss) n12 w=2u l=0.13u
MN9380 (qm9366 n102 storage9379 vss) n12 w=1.2u l=0.13u
MP9381 (qm9366 n108 storage9379 vdd) p12 w=3.6u l=0.13u
MN9382 (step2 n93 storage9379 vss) n12 w=1.2u l=0.13u
MP9383 (step2 n105 storage9379 vdd) p12 w=3.6u l=0.13u
MN9384 (qb9368 storage9379 vss vss) n12 w=0.5u l=0.13u
MP9385 (qb9368 storage9379 vdd vdd) p12 w=1.5u l=0.13u
MN9386 (step2 qb9368 vss vss) n12 w=0.5u l=0.13u
MP9387 (step2 qb9368 vdd vdd) p12 w=1.5u l=0.13u
MN9388 (storage9379 rst vss vss) n12 w=2u l=0.13u
MN9391 (n9389 n8541 n9390 vss) n12 w=1.6u l=0.13u
MN9392 (n9390 step8 vss vss) n12 w=1.6u l=0.13u
MP9393 (n9389 n8541 vdd vdd) p12 w=2.4u l=0.13u
MP9394 (n9389 step8 vdd vdd) p12 w=2.4u l=0.13u
MN9397 (n9395 n8574 n9396 vss) n12 w=1.6u l=0.13u
MN9398 (n9396 step4 vss vss) n12 w=1.6u l=0.13u
MP9399 (n9395 n8574 vdd vdd) p12 w=2.4u l=0.13u
MP9400 (n9395 step4 vdd vdd) p12 w=2.4u l=0.13u
MN9403 (n9401 n9389 n9402 vss) n12 w=1.6u l=0.13u
MN9404 (n9402 n9395 vss vss) n12 w=1.6u l=0.13u
MP9405 (n9401 n9389 vdd vdd) p12 w=2.4u l=0.13u
MP9406 (n9401 n9395 vdd vdd) p12 w=2.4u l=0.13u
MN9411 (n9401 n93 storage9410 vss) n12 w=1.2u l=0.13u
MP9412 (n9401 n105 storage9410 vdd) p12 w=3.6u l=0.13u
MN9413 (qm9407 n102 storage9410 vss) n12 w=1.2u l=0.13u
MP9414 (qm9407 n108 storage9410 vdd) p12 w=3.6u l=0.13u
MN9415 (qmb9408 storage9410 vss vss) n12 w=0.5u l=0.13u
MP9416 (qmb9408 storage9410 vdd vdd) p12 w=1.5u l=0.13u
MN9417 (qm9407 qmb9408 vss vss) n12 w=0.5u l=0.13u
MP9418 (qm9407 qmb9408 vdd vdd) p12 w=1.5u l=0.13u
MN9419 (storage9410 rst vss vss) n12 w=2u l=0.13u
MN9421 (qm9407 n102 storage9420 vss) n12 w=1.2u l=0.13u
MP9422 (qm9407 n108 storage9420 vdd) p12 w=3.6u l=0.13u
MN9423 (step4 n93 storage9420 vss) n12 w=1.2u l=0.13u
MP9424 (step4 n105 storage9420 vdd) p12 w=3.6u l=0.13u
MN9425 (qb9409 storage9420 vss vss) n12 w=0.5u l=0.13u
MP9426 (qb9409 storage9420 vdd vdd) p12 w=1.5u l=0.13u
MN9427 (step4 qb9409 vss vss) n12 w=0.5u l=0.13u
MP9428 (step4 qb9409 vdd vdd) p12 w=1.5u l=0.13u
MN9429 (storage9420 rst vss vss) n12 w=2u l=0.13u
MN9432 (n9430 n8574 n9431 vss) n12 w=1.6u l=0.13u
MN9433 (n9431 step8 vss vss) n12 w=1.6u l=0.13u
MP9434 (n9430 n8574 vdd vdd) p12 w=2.4u l=0.13u
MP9435 (n9430 step8 vdd vdd) p12 w=2.4u l=0.13u
MN9437 (n9436 n9430 vss vss) n12 w=0.8u l=0.13u
MP9438 (n9436 n9430 vdd vdd) p12 w=2.4u l=0.13u
MN9442 (n9441 n9436 vss vss) n12 w=0.8u l=0.13u
MP9443 (n9441 n9436 vdd vdd) p12 w=2.4u l=0.13u
MN9446 (n9441 n93 storage9445 vss) n12 w=1.2u l=0.13u
MP9447 (n9441 n105 storage9445 vdd) p12 w=3.6u l=0.13u
MN9448 (qm9439 n102 storage9445 vss) n12 w=1.2u l=0.13u
MP9449 (qm9439 n108 storage9445 vdd) p12 w=3.6u l=0.13u
MN9450 (qmb9440 storage9445 vss vss) n12 w=0.5u l=0.13u
MP9451 (qmb9440 storage9445 vdd vdd) p12 w=1.5u l=0.13u
MN9452 (qm9439 qmb9440 vss vss) n12 w=0.5u l=0.13u
MP9453 (qm9439 qmb9440 vdd vdd) p12 w=1.5u l=0.13u
MN9454 (storage9445 rst vss vss) n12 w=2u l=0.13u
MN9456 (qm9439 n102 storage9455 vss) n12 w=1.2u l=0.13u
MP9457 (qm9439 n108 storage9455 vdd) p12 w=3.6u l=0.13u
MN9458 (qneg9444 n93 storage9455 vss) n12 w=1.2u l=0.13u
MP9459 (qneg9444 n105 storage9455 vdd) p12 w=3.6u l=0.13u
MN9460 (step8 storage9455 vss vss) n12 w=0.5u l=0.13u
MP9461 (step8 storage9455 vdd vdd) p12 w=1.5u l=0.13u
MN9462 (qneg9444 step8 vss vss) n12 w=0.5u l=0.13u
MP9463 (qneg9444 step8 vdd vdd) p12 w=1.5u l=0.13u
MN9464 (storage9455 rst vss vss) n12 w=2u l=0.13u
MN9466 (n9465 n7289 vss vss) n12 w=0.8u l=0.13u
MP9467 (n9465 n7289 vdd vdd) p12 w=2.4u l=0.13u
MN9470 (n9468 n9465 n9469 vss) n12 w=1.6u l=0.13u
MN9471 (n9469 settle vss vss) n12 w=1.6u l=0.13u
MP9472 (n9468 n9465 vdd vdd) p12 w=2.4u l=0.13u
MP9473 (n9468 settle vdd vdd) p12 w=2.4u l=0.13u
MN9475 (n9474 n9468 vss vss) n12 w=0.8u l=0.13u
MP9476 (n9474 n9468 vdd vdd) p12 w=2.4u l=0.13u
MN9479 (n9477 n66 vss vss) n12 w=0.8u l=0.13u
MN9480 (n9477 n8541 vss vss) n12 w=0.8u l=0.13u
MP9481 (n9477 n66 n9478 vdd) p12 w=4.8u l=0.13u
MP9482 (n9478 n8541 vdd vdd) p12 w=4.8u l=0.13u
MN9484 (n9483 n9477 vss vss) n12 w=0.8u l=0.13u
MP9485 (n9483 n9477 vdd vdd) p12 w=2.4u l=0.13u
MN9488 (n9486 n9474 vss vss) n12 w=0.8u l=0.13u
MN9489 (n9486 n9483 vss vss) n12 w=0.8u l=0.13u
MP9490 (n9486 n9474 n9487 vdd) p12 w=4.8u l=0.13u
MP9491 (n9487 n9483 vdd vdd) p12 w=4.8u l=0.13u
MN9493 (n9492 n9486 vss vss) n12 w=0.8u l=0.13u
MP9494 (n9492 n9486 vdd vdd) p12 w=2.4u l=0.13u
MN9499 (n9492 n93 storage9498 vss) n12 w=1.2u l=0.13u
MP9500 (n9492 n105 storage9498 vdd) p12 w=3.6u l=0.13u
MN9501 (qm9495 n102 storage9498 vss) n12 w=1.2u l=0.13u
MP9502 (qm9495 n108 storage9498 vdd) p12 w=3.6u l=0.13u
MN9503 (qmb9496 storage9498 vss vss) n12 w=0.5u l=0.13u
MP9504 (qmb9496 storage9498 vdd vdd) p12 w=1.5u l=0.13u
MN9505 (qm9495 qmb9496 vss vss) n12 w=0.5u l=0.13u
MP9506 (qm9495 qmb9496 vdd vdd) p12 w=1.5u l=0.13u
MN9507 (storage9498 rst vss vss) n12 w=2u l=0.13u
MN9509 (qm9495 n102 storage9508 vss) n12 w=1.2u l=0.13u
MP9510 (qm9495 n108 storage9508 vdd) p12 w=3.6u l=0.13u
MN9511 (settle n93 storage9508 vss) n12 w=1.2u l=0.13u
MP9512 (settle n105 storage9508 vdd) p12 w=3.6u l=0.13u
MN9513 (qb9497 storage9508 vss vss) n12 w=0.5u l=0.13u
MP9514 (qb9497 storage9508 vdd vdd) p12 w=1.5u l=0.13u
MN9515 (settle qb9497 vss vss) n12 w=0.5u l=0.13u
MP9516 (settle qb9497 vdd vdd) p12 w=1.5u l=0.13u
MN9517 (storage9508 rst vss vss) n12 w=2u l=0.13u
MN9520 (n9518 n7613 vss vss) n12 w=0.8u l=0.13u
MN9521 (n9518 n7634 vss vss) n12 w=0.8u l=0.13u
MP9522 (n9518 n7613 n9519 vdd) p12 w=4.8u l=0.13u
MP9523 (n9519 n7634 vdd vdd) p12 w=4.8u l=0.13u
MN9525 (n9524 n9518 vss vss) n12 w=0.8u l=0.13u
MP9526 (n9524 n9518 vdd vdd) p12 w=2.4u l=0.13u
MN9528 (n9527 n9524 vss vss) n12 w=0.8u l=0.13u
MP9529 (n9527 n9524 vdd vdd) p12 w=2.4u l=0.13u
MN9532 (n9530 arm n9531 vss) n12 w=1.6u l=0.13u
MN9533 (n9531 n9527 vss vss) n12 w=1.6u l=0.13u
MP9534 (n9530 arm vdd vdd) p12 w=2.4u l=0.13u
MP9535 (n9530 n9527 vdd vdd) p12 w=2.4u l=0.13u
MN9537 (n9536 n9530 vss vss) n12 w=0.8u l=0.13u
MP9538 (n9536 n9530 vdd vdd) p12 w=2.4u l=0.13u
MN9541 (n9539 n7289 vss vss) n12 w=0.8u l=0.13u
MN9542 (n9539 n9536 vss vss) n12 w=0.8u l=0.13u
MP9543 (n9539 n7289 n9540 vdd) p12 w=4.8u l=0.13u
MP9544 (n9540 n9536 vdd vdd) p12 w=4.8u l=0.13u
MN9546 (n9545 n9539 vss vss) n12 w=0.8u l=0.13u
MP9547 (n9545 n9539 vdd vdd) p12 w=2.4u l=0.13u
MN9552 (n9545 n93 storage9551 vss) n12 w=1.2u l=0.13u
MP9553 (n9545 n105 storage9551 vdd) p12 w=3.6u l=0.13u
MN9554 (qm9548 n102 storage9551 vss) n12 w=1.2u l=0.13u
MP9555 (qm9548 n108 storage9551 vdd) p12 w=3.6u l=0.13u
MN9556 (qmb9549 storage9551 vss vss) n12 w=0.5u l=0.13u
MP9557 (qmb9549 storage9551 vdd vdd) p12 w=1.5u l=0.13u
MN9558 (qm9548 qmb9549 vss vss) n12 w=0.5u l=0.13u
MP9559 (qm9548 qmb9549 vdd vdd) p12 w=1.5u l=0.13u
MN9560 (storage9551 rst vss vss) n12 w=2u l=0.13u
MN9562 (qm9548 n102 storage9561 vss) n12 w=1.2u l=0.13u
MP9563 (qm9548 n108 storage9561 vdd) p12 w=3.6u l=0.13u
MN9564 (arm n93 storage9561 vss) n12 w=1.2u l=0.13u
MP9565 (arm n105 storage9561 vdd) p12 w=3.6u l=0.13u
MN9566 (qb9550 storage9561 vss vss) n12 w=0.5u l=0.13u
MP9567 (qb9550 storage9561 vdd vdd) p12 w=1.5u l=0.13u
MN9568 (arm qb9550 vss vss) n12 w=0.5u l=0.13u
MP9569 (arm qb9550 vdd vdd) p12 w=1.5u l=0.13u
MN9570 (storage9561 rst vss vss) n12 w=2u l=0.13u
MN9573 (n9571 measure n9572 vss) n12 w=1.6u l=0.13u
MN9574 (n9572 n8391 vss vss) n12 w=1.6u l=0.13u
MP9575 (n9571 measure vdd vdd) p12 w=2.4u l=0.13u
MP9576 (n9571 n8391 vdd vdd) p12 w=2.4u l=0.13u
MN9578 (n9577 n9571 vss vss) n12 w=0.8u l=0.13u
MP9579 (n9577 n9571 vdd vdd) p12 w=2.4u l=0.13u
MN9582 (n9580 n7613 vss vss) n12 w=0.8u l=0.13u
MN9583 (n9580 n9577 vss vss) n12 w=0.8u l=0.13u
MP9584 (n9580 n7613 n9581 vdd) p12 w=4.8u l=0.13u
MP9585 (n9581 n9577 vdd vdd) p12 w=4.8u l=0.13u
MN9587 (n9586 n9580 vss vss) n12 w=0.8u l=0.13u
MP9588 (n9586 n9580 vdd vdd) p12 w=2.4u l=0.13u
MN9593 (n9586 n93 storage9592 vss) n12 w=1.2u l=0.13u
MP9594 (n9586 n105 storage9592 vdd) p12 w=3.6u l=0.13u
MN9595 (qm9589 n102 storage9592 vss) n12 w=1.2u l=0.13u
MP9596 (qm9589 n108 storage9592 vdd) p12 w=3.6u l=0.13u
MN9597 (qmb9590 storage9592 vss vss) n12 w=0.5u l=0.13u
MP9598 (qmb9590 storage9592 vdd vdd) p12 w=1.5u l=0.13u
MN9599 (qm9589 qmb9590 vss vss) n12 w=0.5u l=0.13u
MP9600 (qm9589 qmb9590 vdd vdd) p12 w=1.5u l=0.13u
MN9601 (storage9592 rst vss vss) n12 w=2u l=0.13u
MN9603 (qm9589 n102 storage9602 vss) n12 w=1.2u l=0.13u
MP9604 (qm9589 n108 storage9602 vdd) p12 w=3.6u l=0.13u
MN9605 (measure n93 storage9602 vss) n12 w=1.2u l=0.13u
MP9606 (measure n105 storage9602 vdd) p12 w=3.6u l=0.13u
MN9607 (qb9591 storage9602 vss vss) n12 w=0.5u l=0.13u
MP9608 (qb9591 storage9602 vdd vdd) p12 w=1.5u l=0.13u
MN9609 (measure qb9591 vss vss) n12 w=0.5u l=0.13u
MP9610 (measure qb9591 vdd vdd) p12 w=1.5u l=0.13u
MN9611 (storage9602 rst vss vss) n12 w=2u l=0.13u
MN9613 (n9612 n7758 vss vss) n12 w=0.8u l=0.13u
MP9614 (n9612 n7758 vdd vdd) p12 w=2.4u l=0.13u
MN9617 (n9615 drain n9616 vss) n12 w=1.6u l=0.13u
MN9618 (n9616 n9612 vss vss) n12 w=1.6u l=0.13u
MP9619 (n9615 drain vdd vdd) p12 w=2.4u l=0.13u
MP9620 (n9615 n9612 vdd vdd) p12 w=2.4u l=0.13u
MN9622 (n9621 n9615 vss vss) n12 w=0.8u l=0.13u
MP9623 (n9621 n9615 vdd vdd) p12 w=2.4u l=0.13u
MN9626 (n9624 n5964 vss vss) n12 w=0.8u l=0.13u
MN9627 (n9624 n9621 vss vss) n12 w=0.8u l=0.13u
MP9628 (n9624 n5964 n9625 vdd) p12 w=4.8u l=0.13u
MP9629 (n9625 n9621 vdd vdd) p12 w=4.8u l=0.13u
MN9631 (n9630 n9624 vss vss) n12 w=0.8u l=0.13u
MP9632 (n9630 n9624 vdd vdd) p12 w=2.4u l=0.13u
MN9637 (n9630 n93 storage9636 vss) n12 w=1.2u l=0.13u
MP9638 (n9630 n105 storage9636 vdd) p12 w=3.6u l=0.13u
MN9639 (qm9633 n102 storage9636 vss) n12 w=1.2u l=0.13u
MP9640 (qm9633 n108 storage9636 vdd) p12 w=3.6u l=0.13u
MN9641 (qmb9634 storage9636 vss vss) n12 w=0.5u l=0.13u
MP9642 (qmb9634 storage9636 vdd vdd) p12 w=1.5u l=0.13u
MN9643 (qm9633 qmb9634 vss vss) n12 w=0.5u l=0.13u
MP9644 (qm9633 qmb9634 vdd vdd) p12 w=1.5u l=0.13u
MN9645 (storage9636 rst vss vss) n12 w=2u l=0.13u
MN9647 (qm9633 n102 storage9646 vss) n12 w=1.2u l=0.13u
MP9648 (qm9633 n108 storage9646 vdd) p12 w=3.6u l=0.13u
MN9649 (drain n93 storage9646 vss) n12 w=1.2u l=0.13u
MP9650 (drain n105 storage9646 vdd) p12 w=3.6u l=0.13u
MN9651 (qb9635 storage9646 vss vss) n12 w=0.5u l=0.13u
MP9652 (qb9635 storage9646 vdd vdd) p12 w=1.5u l=0.13u
MN9653 (drain qb9635 vss vss) n12 w=0.5u l=0.13u
MP9654 (drain qb9635 vdd vdd) p12 w=1.5u l=0.13u
MN9655 (storage9646 rst vss vss) n12 w=2u l=0.13u
MN9660 (done n93 storage9659 vss) n12 w=1.2u l=0.13u
MP9661 (done n105 storage9659 vdd) p12 w=3.6u l=0.13u
MN9662 (qm9656 n102 storage9659 vss) n12 w=1.2u l=0.13u
MP9663 (qm9656 n108 storage9659 vdd) p12 w=3.6u l=0.13u
MN9664 (qmb9657 storage9659 vss vss) n12 w=0.5u l=0.13u
MP9665 (qmb9657 storage9659 vdd vdd) p12 w=1.5u l=0.13u
MN9666 (qm9656 qmb9657 vss vss) n12 w=0.5u l=0.13u
MP9667 (qm9656 qmb9657 vdd vdd) p12 w=1.5u l=0.13u
MN9668 (storage9659 rst vss vss) n12 w=2u l=0.13u
MN9670 (qm9656 n102 storage9669 vss) n12 w=1.2u l=0.13u
MP9671 (qm9656 n108 storage9669 vdd) p12 w=3.6u l=0.13u
MN9672 (done_delay1 n93 storage9669 vss) n12 w=1.2u l=0.13u
MP9673 (done_delay1 n105 storage9669 vdd) p12 w=3.6u l=0.13u
MN9674 (qb9658 storage9669 vss vss) n12 w=0.5u l=0.13u
MP9675 (qb9658 storage9669 vdd vdd) p12 w=1.5u l=0.13u
MN9676 (done_delay1 qb9658 vss vss) n12 w=0.5u l=0.13u
MP9677 (done_delay1 qb9658 vdd vdd) p12 w=1.5u l=0.13u
MN9678 (storage9669 rst vss vss) n12 w=2u l=0.13u
MN9681 (n9679 done_delay1 n9680 vss) n12 w=1.6u l=0.13u
MN9682 (n9680 n39 vss vss) n12 w=1.6u l=0.13u
MP9683 (n9679 done_delay1 vdd vdd) p12 w=2.4u l=0.13u
MP9684 (n9679 n39 vdd vdd) p12 w=2.4u l=0.13u
MN9686 (n9685 n9679 vss vss) n12 w=0.8u l=0.13u
MP9687 (n9685 n9679 vdd vdd) p12 w=2.4u l=0.13u
MN9692 (n9685 n93 storage9691 vss) n12 w=1.2u l=0.13u
MP9693 (n9685 n105 storage9691 vdd) p12 w=3.6u l=0.13u
MN9694 (qm9688 n102 storage9691 vss) n12 w=1.2u l=0.13u
MP9695 (qm9688 n108 storage9691 vdd) p12 w=3.6u l=0.13u
MN9696 (qmb9689 storage9691 vss vss) n12 w=0.5u l=0.13u
MP9697 (qmb9689 storage9691 vdd vdd) p12 w=1.5u l=0.13u
MN9698 (qm9688 qmb9689 vss vss) n12 w=0.5u l=0.13u
MP9699 (qm9688 qmb9689 vdd vdd) p12 w=1.5u l=0.13u
MN9700 (storage9691 rst vss vss) n12 w=2u l=0.13u
MN9702 (qm9688 n102 storage9701 vss) n12 w=1.2u l=0.13u
MP9703 (qm9688 n108 storage9701 vdd) p12 w=3.6u l=0.13u
MN9704 (fine_enable n93 storage9701 vss) n12 w=1.2u l=0.13u
MP9705 (fine_enable n105 storage9701 vdd) p12 w=3.6u l=0.13u
MN9706 (qb9690 storage9701 vss vss) n12 w=0.5u l=0.13u
MP9707 (qb9690 storage9701 vdd vdd) p12 w=1.5u l=0.13u
MN9708 (fine_enable qb9690 vss vss) n12 w=0.5u l=0.13u
MP9709 (fine_enable qb9690 vdd vdd) p12 w=1.5u l=0.13u
MN9710 (storage9701 rst vss vss) n12 w=2u l=0.13u
MN9712 (n9711 fine_enable vss vss) n12 w=0.8u l=0.13u
MP9713 (n9711 fine_enable vdd vdd) p12 w=2.4u l=0.13u
MN9715 (n9714 n9711 vss vss) n12 w=0.8u l=0.13u
MP9716 (n9714 n9711 vdd vdd) p12 w=2.4u l=0.13u
MN9718 (n9717 n9714 vss vss) n12 w=0.8u l=0.13u
MP9719 (n9717 n9714 vdd vdd) p12 w=2.4u l=0.13u
MN9721 (n9720 n9717 vss vss) n12 w=0.8u l=0.13u
MP9722 (n9720 n9717 vdd vdd) p12 w=2.4u l=0.13u
MN9723 (hold n9720 vss vss) n12 w=0.8u l=0.13u
MP9724 (hold n9720 vdd vdd) p12 w=2.4u l=0.13u
MN9727 (n9725 n9711 vss vss) n12 w=0.8u l=0.13u
MN9728 (n9725 rst vss vss) n12 w=0.8u l=0.13u
MP9729 (n9725 n9711 n9726 vdd) p12 w=4.8u l=0.13u
MP9730 (n9726 rst vdd vdd) p12 w=4.8u l=0.13u
MN9732 (n9731 n9725 vss vss) n12 w=0.8u l=0.13u
MP9733 (n9731 n9725 vdd vdd) p12 w=2.4u l=0.13u
MN9735 (n9734 n9731 vss vss) n12 w=0.8u l=0.13u
MP9736 (n9734 n9731 vdd vdd) p12 w=2.4u l=0.13u
MN9738 (n9737 n9734 vss vss) n12 w=0.8u l=0.13u
MP9739 (n9737 n9734 vdd vdd) p12 w=2.4u l=0.13u
MN9741 (n9740 n9737 vss vss) n12 w=0.8u l=0.13u
MP9742 (n9740 n9737 vdd vdd) p12 w=2.4u l=0.13u
MN9743 (pfd_reset n9740 vss vss) n12 w=0.8u l=0.13u
MP9744 (pfd_reset n9740 vdd vdd) p12 w=2.4u l=0.13u
ends afc2009_mos
