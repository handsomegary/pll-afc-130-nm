// Prepared-only light-load subset, actual R2 MOS primitives.
// Native9-bit registeredGray initial0/1, matched2-stage9-bitCDC.
// No behavioral counter; this is not complete-AFC CDC signoff.
simulator lang=spectre
subckt counter9_gray_cdc_mos (vdd vss clk ref rst)
MN3 (n1 zero_g7 n2 vss) n12 w=1.6u l=0.13u
MN4 (n2 zero_g8 vss vss) n12 w=1.6u l=0.13u
MP5 (n1 zero_g7 vdd vdd) p12 w=2.4u l=0.13u
MP6 (n1 zero_g8 vdd vdd) p12 w=2.4u l=0.13u
MN9 (n7 n1 n8 vss) n12 w=1.6u l=0.13u
MN10 (n8 zero_g7 vss vss) n12 w=1.6u l=0.13u
MP11 (n7 n1 vdd vdd) p12 w=2.4u l=0.13u
MP12 (n7 zero_g7 vdd vdd) p12 w=2.4u l=0.13u
MN15 (n13 n1 n14 vss) n12 w=1.6u l=0.13u
MN16 (n14 zero_g8 vss vss) n12 w=1.6u l=0.13u
MP17 (n13 n1 vdd vdd) p12 w=2.4u l=0.13u
MP18 (n13 zero_g8 vdd vdd) p12 w=2.4u l=0.13u
MN21 (n19 n13 n20 vss) n12 w=1.6u l=0.13u
MN22 (n20 n7 vss vss) n12 w=1.6u l=0.13u
MP23 (n19 n13 vdd vdd) p12 w=2.4u l=0.13u
MP24 (n19 n7 vdd vdd) p12 w=2.4u l=0.13u
MN27 (n25 n19 n26 vss) n12 w=1.6u l=0.13u
MN28 (n26 zero_g6 vss vss) n12 w=1.6u l=0.13u
MP29 (n25 n19 vdd vdd) p12 w=2.4u l=0.13u
MP30 (n25 zero_g6 vdd vdd) p12 w=2.4u l=0.13u
MN33 (n31 n19 n32 vss) n12 w=1.6u l=0.13u
MN34 (n32 n25 vss vss) n12 w=1.6u l=0.13u
MP35 (n31 n19 vdd vdd) p12 w=2.4u l=0.13u
MP36 (n31 n25 vdd vdd) p12 w=2.4u l=0.13u
MN39 (n37 n25 n38 vss) n12 w=1.6u l=0.13u
MN40 (n38 zero_g6 vss vss) n12 w=1.6u l=0.13u
MP41 (n37 n25 vdd vdd) p12 w=2.4u l=0.13u
MP42 (n37 zero_g6 vdd vdd) p12 w=2.4u l=0.13u
MN45 (n43 n31 n44 vss) n12 w=1.6u l=0.13u
MN46 (n44 n37 vss vss) n12 w=1.6u l=0.13u
MP47 (n43 n31 vdd vdd) p12 w=2.4u l=0.13u
MP48 (n43 n37 vdd vdd) p12 w=2.4u l=0.13u
MN51 (n49 n43 n50 vss) n12 w=1.6u l=0.13u
MN52 (n50 zero_g5 vss vss) n12 w=1.6u l=0.13u
MP53 (n49 n43 vdd vdd) p12 w=2.4u l=0.13u
MP54 (n49 zero_g5 vdd vdd) p12 w=2.4u l=0.13u
MN57 (n55 n43 n56 vss) n12 w=1.6u l=0.13u
MN58 (n56 n49 vss vss) n12 w=1.6u l=0.13u
MP59 (n55 n43 vdd vdd) p12 w=2.4u l=0.13u
MP60 (n55 n49 vdd vdd) p12 w=2.4u l=0.13u
MN63 (n61 n49 n62 vss) n12 w=1.6u l=0.13u
MN64 (n62 zero_g5 vss vss) n12 w=1.6u l=0.13u
MP65 (n61 n49 vdd vdd) p12 w=2.4u l=0.13u
MP66 (n61 zero_g5 vdd vdd) p12 w=2.4u l=0.13u
MN69 (n67 n55 n68 vss) n12 w=1.6u l=0.13u
MN70 (n68 n61 vss vss) n12 w=1.6u l=0.13u
MP71 (n67 n55 vdd vdd) p12 w=2.4u l=0.13u
MP72 (n67 n61 vdd vdd) p12 w=2.4u l=0.13u
MN75 (n73 n67 n74 vss) n12 w=1.6u l=0.13u
MN76 (n74 zero_g4 vss vss) n12 w=1.6u l=0.13u
MP77 (n73 n67 vdd vdd) p12 w=2.4u l=0.13u
MP78 (n73 zero_g4 vdd vdd) p12 w=2.4u l=0.13u
MN81 (n79 n67 n80 vss) n12 w=1.6u l=0.13u
MN82 (n80 n73 vss vss) n12 w=1.6u l=0.13u
MP83 (n79 n67 vdd vdd) p12 w=2.4u l=0.13u
MP84 (n79 n73 vdd vdd) p12 w=2.4u l=0.13u
MN87 (n85 n73 n86 vss) n12 w=1.6u l=0.13u
MN88 (n86 zero_g4 vss vss) n12 w=1.6u l=0.13u
MP89 (n85 n73 vdd vdd) p12 w=2.4u l=0.13u
MP90 (n85 zero_g4 vdd vdd) p12 w=2.4u l=0.13u
MN93 (n91 n79 n92 vss) n12 w=1.6u l=0.13u
MN94 (n92 n85 vss vss) n12 w=1.6u l=0.13u
MP95 (n91 n79 vdd vdd) p12 w=2.4u l=0.13u
MP96 (n91 n85 vdd vdd) p12 w=2.4u l=0.13u
MN99 (n97 n91 n98 vss) n12 w=1.6u l=0.13u
MN100 (n98 zero_g3 vss vss) n12 w=1.6u l=0.13u
MP101 (n97 n91 vdd vdd) p12 w=2.4u l=0.13u
MP102 (n97 zero_g3 vdd vdd) p12 w=2.4u l=0.13u
MN105 (n103 n91 n104 vss) n12 w=1.6u l=0.13u
MN106 (n104 n97 vss vss) n12 w=1.6u l=0.13u
MP107 (n103 n91 vdd vdd) p12 w=2.4u l=0.13u
MP108 (n103 n97 vdd vdd) p12 w=2.4u l=0.13u
MN111 (n109 n97 n110 vss) n12 w=1.6u l=0.13u
MN112 (n110 zero_g3 vss vss) n12 w=1.6u l=0.13u
MP113 (n109 n97 vdd vdd) p12 w=2.4u l=0.13u
MP114 (n109 zero_g3 vdd vdd) p12 w=2.4u l=0.13u
MN117 (n115 n103 n116 vss) n12 w=1.6u l=0.13u
MN118 (n116 n109 vss vss) n12 w=1.6u l=0.13u
MP119 (n115 n103 vdd vdd) p12 w=2.4u l=0.13u
MP120 (n115 n109 vdd vdd) p12 w=2.4u l=0.13u
MN123 (n121 n115 n122 vss) n12 w=1.6u l=0.13u
MN124 (n122 zero_g2 vss vss) n12 w=1.6u l=0.13u
MP125 (n121 n115 vdd vdd) p12 w=2.4u l=0.13u
MP126 (n121 zero_g2 vdd vdd) p12 w=2.4u l=0.13u
MN129 (n127 n115 n128 vss) n12 w=1.6u l=0.13u
MN130 (n128 n121 vss vss) n12 w=1.6u l=0.13u
MP131 (n127 n115 vdd vdd) p12 w=2.4u l=0.13u
MP132 (n127 n121 vdd vdd) p12 w=2.4u l=0.13u
MN135 (n133 n121 n134 vss) n12 w=1.6u l=0.13u
MN136 (n134 zero_g2 vss vss) n12 w=1.6u l=0.13u
MP137 (n133 n121 vdd vdd) p12 w=2.4u l=0.13u
MP138 (n133 zero_g2 vdd vdd) p12 w=2.4u l=0.13u
MN141 (n139 n127 n140 vss) n12 w=1.6u l=0.13u
MN142 (n140 n133 vss vss) n12 w=1.6u l=0.13u
MP143 (n139 n127 vdd vdd) p12 w=2.4u l=0.13u
MP144 (n139 n133 vdd vdd) p12 w=2.4u l=0.13u
MN147 (n145 n139 n146 vss) n12 w=1.6u l=0.13u
MN148 (n146 zero_g1 vss vss) n12 w=1.6u l=0.13u
MP149 (n145 n139 vdd vdd) p12 w=2.4u l=0.13u
MP150 (n145 zero_g1 vdd vdd) p12 w=2.4u l=0.13u
MN153 (n151 n139 n152 vss) n12 w=1.6u l=0.13u
MN154 (n152 n145 vss vss) n12 w=1.6u l=0.13u
MP155 (n151 n139 vdd vdd) p12 w=2.4u l=0.13u
MP156 (n151 n145 vdd vdd) p12 w=2.4u l=0.13u
MN159 (n157 n145 n158 vss) n12 w=1.6u l=0.13u
MN160 (n158 zero_g1 vss vss) n12 w=1.6u l=0.13u
MP161 (n157 n145 vdd vdd) p12 w=2.4u l=0.13u
MP162 (n157 zero_g1 vdd vdd) p12 w=2.4u l=0.13u
MN165 (n163 n151 n164 vss) n12 w=1.6u l=0.13u
MN166 (n164 n157 vss vss) n12 w=1.6u l=0.13u
MP167 (n163 n151 vdd vdd) p12 w=2.4u l=0.13u
MP168 (n163 n157 vdd vdd) p12 w=2.4u l=0.13u
MN171 (n169 n163 n170 vss) n12 w=1.6u l=0.13u
MN172 (n170 zero_g0 vss vss) n12 w=1.6u l=0.13u
MP173 (n169 n163 vdd vdd) p12 w=2.4u l=0.13u
MP174 (n169 zero_g0 vdd vdd) p12 w=2.4u l=0.13u
MN177 (n175 n163 n176 vss) n12 w=1.6u l=0.13u
MN178 (n176 n169 vss vss) n12 w=1.6u l=0.13u
MP179 (n175 n163 vdd vdd) p12 w=2.4u l=0.13u
MP180 (n175 n169 vdd vdd) p12 w=2.4u l=0.13u
MN183 (n181 n169 n182 vss) n12 w=1.6u l=0.13u
MN184 (n182 zero_g0 vss vss) n12 w=1.6u l=0.13u
MP185 (n181 n169 vdd vdd) p12 w=2.4u l=0.13u
MP186 (n181 zero_g0 vdd vdd) p12 w=2.4u l=0.13u
MN189 (n187 n175 n188 vss) n12 w=1.6u l=0.13u
MN190 (n188 n181 vss vss) n12 w=1.6u l=0.13u
MP191 (n187 n175 vdd vdd) p12 w=2.4u l=0.13u
MP192 (n187 n181 vdd vdd) p12 w=2.4u l=0.13u
MN194 (n193 n187 vss vss) n12 w=0.8u l=0.13u
MP195 (n193 n187 vdd vdd) p12 w=2.4u l=0.13u
MN198 (n196 n163 n197 vss) n12 w=1.6u l=0.13u
MN199 (n197 n187 vss vss) n12 w=1.6u l=0.13u
MP200 (n196 n163 vdd vdd) p12 w=2.4u l=0.13u
MP201 (n196 n187 vdd vdd) p12 w=2.4u l=0.13u
MN204 (n202 n163 n203 vss) n12 w=1.6u l=0.13u
MN205 (n203 n196 vss vss) n12 w=1.6u l=0.13u
MP206 (n202 n163 vdd vdd) p12 w=2.4u l=0.13u
MP207 (n202 n196 vdd vdd) p12 w=2.4u l=0.13u
MN210 (n208 n187 n209 vss) n12 w=1.6u l=0.13u
MN211 (n209 n196 vss vss) n12 w=1.6u l=0.13u
MP212 (n208 n187 vdd vdd) p12 w=2.4u l=0.13u
MP213 (n208 n196 vdd vdd) p12 w=2.4u l=0.13u
MN216 (n214 n202 n215 vss) n12 w=1.6u l=0.13u
MN217 (n215 n208 vss vss) n12 w=1.6u l=0.13u
MP218 (n214 n202 vdd vdd) p12 w=2.4u l=0.13u
MP219 (n214 n208 vdd vdd) p12 w=2.4u l=0.13u
MN221 (n220 n196 vss vss) n12 w=0.8u l=0.13u
MP222 (n220 n196 vdd vdd) p12 w=2.4u l=0.13u
MN225 (n223 n139 n224 vss) n12 w=1.6u l=0.13u
MN226 (n224 n220 vss vss) n12 w=1.6u l=0.13u
MP227 (n223 n139 vdd vdd) p12 w=2.4u l=0.13u
MP228 (n223 n220 vdd vdd) p12 w=2.4u l=0.13u
MN231 (n229 n139 n230 vss) n12 w=1.6u l=0.13u
MN232 (n230 n223 vss vss) n12 w=1.6u l=0.13u
MP233 (n229 n139 vdd vdd) p12 w=2.4u l=0.13u
MP234 (n229 n223 vdd vdd) p12 w=2.4u l=0.13u
MN237 (n235 n220 n236 vss) n12 w=1.6u l=0.13u
MN238 (n236 n223 vss vss) n12 w=1.6u l=0.13u
MP239 (n235 n220 vdd vdd) p12 w=2.4u l=0.13u
MP240 (n235 n223 vdd vdd) p12 w=2.4u l=0.13u
MN243 (n241 n229 n242 vss) n12 w=1.6u l=0.13u
MN244 (n242 n235 vss vss) n12 w=1.6u l=0.13u
MP245 (n241 n229 vdd vdd) p12 w=2.4u l=0.13u
MP246 (n241 n235 vdd vdd) p12 w=2.4u l=0.13u
MN248 (n247 n223 vss vss) n12 w=0.8u l=0.13u
MP249 (n247 n223 vdd vdd) p12 w=2.4u l=0.13u
MN252 (n250 n115 n251 vss) n12 w=1.6u l=0.13u
MN253 (n251 n247 vss vss) n12 w=1.6u l=0.13u
MP254 (n250 n115 vdd vdd) p12 w=2.4u l=0.13u
MP255 (n250 n247 vdd vdd) p12 w=2.4u l=0.13u
MN258 (n256 n115 n257 vss) n12 w=1.6u l=0.13u
MN259 (n257 n250 vss vss) n12 w=1.6u l=0.13u
MP260 (n256 n115 vdd vdd) p12 w=2.4u l=0.13u
MP261 (n256 n250 vdd vdd) p12 w=2.4u l=0.13u
MN264 (n262 n247 n263 vss) n12 w=1.6u l=0.13u
MN265 (n263 n250 vss vss) n12 w=1.6u l=0.13u
MP266 (n262 n247 vdd vdd) p12 w=2.4u l=0.13u
MP267 (n262 n250 vdd vdd) p12 w=2.4u l=0.13u
MN270 (n268 n256 n269 vss) n12 w=1.6u l=0.13u
MN271 (n269 n262 vss vss) n12 w=1.6u l=0.13u
MP272 (n268 n256 vdd vdd) p12 w=2.4u l=0.13u
MP273 (n268 n262 vdd vdd) p12 w=2.4u l=0.13u
MN275 (n274 n250 vss vss) n12 w=0.8u l=0.13u
MP276 (n274 n250 vdd vdd) p12 w=2.4u l=0.13u
MN279 (n277 n274 n278 vss) n12 w=1.6u l=0.13u
MN280 (n278 n91 vss vss) n12 w=1.6u l=0.13u
MP281 (n277 n274 vdd vdd) p12 w=2.4u l=0.13u
MP282 (n277 n91 vdd vdd) p12 w=2.4u l=0.13u
MN285 (n283 n274 n284 vss) n12 w=1.6u l=0.13u
MN286 (n284 n277 vss vss) n12 w=1.6u l=0.13u
MP287 (n283 n274 vdd vdd) p12 w=2.4u l=0.13u
MP288 (n283 n277 vdd vdd) p12 w=2.4u l=0.13u
MN291 (n289 n277 n290 vss) n12 w=1.6u l=0.13u
MN292 (n290 n91 vss vss) n12 w=1.6u l=0.13u
MP293 (n289 n277 vdd vdd) p12 w=2.4u l=0.13u
MP294 (n289 n91 vdd vdd) p12 w=2.4u l=0.13u
MN297 (n295 n283 n296 vss) n12 w=1.6u l=0.13u
MN298 (n296 n289 vss vss) n12 w=1.6u l=0.13u
MP299 (n295 n283 vdd vdd) p12 w=2.4u l=0.13u
MP300 (n295 n289 vdd vdd) p12 w=2.4u l=0.13u
MN302 (n301 n277 vss vss) n12 w=0.8u l=0.13u
MP303 (n301 n277 vdd vdd) p12 w=2.4u l=0.13u
MN306 (n304 n301 n305 vss) n12 w=1.6u l=0.13u
MN307 (n305 n67 vss vss) n12 w=1.6u l=0.13u
MP308 (n304 n301 vdd vdd) p12 w=2.4u l=0.13u
MP309 (n304 n67 vdd vdd) p12 w=2.4u l=0.13u
MN312 (n310 n301 n311 vss) n12 w=1.6u l=0.13u
MN313 (n311 n304 vss vss) n12 w=1.6u l=0.13u
MP314 (n310 n301 vdd vdd) p12 w=2.4u l=0.13u
MP315 (n310 n304 vdd vdd) p12 w=2.4u l=0.13u
MN318 (n316 n304 n317 vss) n12 w=1.6u l=0.13u
MN319 (n317 n67 vss vss) n12 w=1.6u l=0.13u
MP320 (n316 n304 vdd vdd) p12 w=2.4u l=0.13u
MP321 (n316 n67 vdd vdd) p12 w=2.4u l=0.13u
MN324 (n322 n310 n323 vss) n12 w=1.6u l=0.13u
MN325 (n323 n316 vss vss) n12 w=1.6u l=0.13u
MP326 (n322 n310 vdd vdd) p12 w=2.4u l=0.13u
MP327 (n322 n316 vdd vdd) p12 w=2.4u l=0.13u
MN329 (n328 n304 vss vss) n12 w=0.8u l=0.13u
MP330 (n328 n304 vdd vdd) p12 w=2.4u l=0.13u
MN333 (n331 n328 n332 vss) n12 w=1.6u l=0.13u
MN334 (n332 n43 vss vss) n12 w=1.6u l=0.13u
MP335 (n331 n328 vdd vdd) p12 w=2.4u l=0.13u
MP336 (n331 n43 vdd vdd) p12 w=2.4u l=0.13u
MN339 (n337 n328 n338 vss) n12 w=1.6u l=0.13u
MN340 (n338 n331 vss vss) n12 w=1.6u l=0.13u
MP341 (n337 n328 vdd vdd) p12 w=2.4u l=0.13u
MP342 (n337 n331 vdd vdd) p12 w=2.4u l=0.13u
MN345 (n343 n331 n344 vss) n12 w=1.6u l=0.13u
MN346 (n344 n43 vss vss) n12 w=1.6u l=0.13u
MP347 (n343 n331 vdd vdd) p12 w=2.4u l=0.13u
MP348 (n343 n43 vdd vdd) p12 w=2.4u l=0.13u
MN351 (n349 n337 n350 vss) n12 w=1.6u l=0.13u
MN352 (n350 n343 vss vss) n12 w=1.6u l=0.13u
MP353 (n349 n337 vdd vdd) p12 w=2.4u l=0.13u
MP354 (n349 n343 vdd vdd) p12 w=2.4u l=0.13u
MN356 (n355 n331 vss vss) n12 w=0.8u l=0.13u
MP357 (n355 n331 vdd vdd) p12 w=2.4u l=0.13u
MN360 (n358 n19 n359 vss) n12 w=1.6u l=0.13u
MN361 (n359 n355 vss vss) n12 w=1.6u l=0.13u
MP362 (n358 n19 vdd vdd) p12 w=2.4u l=0.13u
MP363 (n358 n355 vdd vdd) p12 w=2.4u l=0.13u
MN366 (n364 n19 n365 vss) n12 w=1.6u l=0.13u
MN367 (n365 n358 vss vss) n12 w=1.6u l=0.13u
MP368 (n364 n19 vdd vdd) p12 w=2.4u l=0.13u
MP369 (n364 n358 vdd vdd) p12 w=2.4u l=0.13u
MN372 (n370 n355 n371 vss) n12 w=1.6u l=0.13u
MN373 (n371 n358 vss vss) n12 w=1.6u l=0.13u
MP374 (n370 n355 vdd vdd) p12 w=2.4u l=0.13u
MP375 (n370 n358 vdd vdd) p12 w=2.4u l=0.13u
MN378 (n376 n364 n377 vss) n12 w=1.6u l=0.13u
MN379 (n377 n370 vss vss) n12 w=1.6u l=0.13u
MP380 (n376 n364 vdd vdd) p12 w=2.4u l=0.13u
MP381 (n376 n370 vdd vdd) p12 w=2.4u l=0.13u
MN383 (n382 n358 vss vss) n12 w=0.8u l=0.13u
MP384 (n382 n358 vdd vdd) p12 w=2.4u l=0.13u
MN387 (n385 n382 n386 vss) n12 w=1.6u l=0.13u
MN388 (n386 zero_g8 vss vss) n12 w=1.6u l=0.13u
MP389 (n385 n382 vdd vdd) p12 w=2.4u l=0.13u
MP390 (n385 zero_g8 vdd vdd) p12 w=2.4u l=0.13u
MN393 (n391 n382 n392 vss) n12 w=1.6u l=0.13u
MN394 (n392 n385 vss vss) n12 w=1.6u l=0.13u
MP395 (n391 n382 vdd vdd) p12 w=2.4u l=0.13u
MP396 (n391 n385 vdd vdd) p12 w=2.4u l=0.13u
MN399 (n397 n385 n398 vss) n12 w=1.6u l=0.13u
MN400 (n398 zero_g8 vss vss) n12 w=1.6u l=0.13u
MP401 (n397 n385 vdd vdd) p12 w=2.4u l=0.13u
MP402 (n397 zero_g8 vdd vdd) p12 w=2.4u l=0.13u
MN405 (n403 n391 n404 vss) n12 w=1.6u l=0.13u
MN406 (n404 n397 vss vss) n12 w=1.6u l=0.13u
MP407 (n403 n391 vdd vdd) p12 w=2.4u l=0.13u
MP408 (n403 n397 vdd vdd) p12 w=2.4u l=0.13u
MN410 (n409 n385 vss vss) n12 w=0.8u l=0.13u
MP411 (n409 n385 vdd vdd) p12 w=2.4u l=0.13u
MN414 (n412 n193 n413 vss) n12 w=1.6u l=0.13u
MN415 (n413 n214 vss vss) n12 w=1.6u l=0.13u
MP416 (n412 n193 vdd vdd) p12 w=2.4u l=0.13u
MP417 (n412 n214 vdd vdd) p12 w=2.4u l=0.13u
MN420 (n418 n193 n419 vss) n12 w=1.6u l=0.13u
MN421 (n419 n412 vss vss) n12 w=1.6u l=0.13u
MP422 (n418 n193 vdd vdd) p12 w=2.4u l=0.13u
MP423 (n418 n412 vdd vdd) p12 w=2.4u l=0.13u
MN426 (n424 n214 n425 vss) n12 w=1.6u l=0.13u
MN427 (n425 n412 vss vss) n12 w=1.6u l=0.13u
MP428 (n424 n214 vdd vdd) p12 w=2.4u l=0.13u
MP429 (n424 n412 vdd vdd) p12 w=2.4u l=0.13u
MN432 (n430 n418 n431 vss) n12 w=1.6u l=0.13u
MN433 (n431 n424 vss vss) n12 w=1.6u l=0.13u
MP434 (n430 n418 vdd vdd) p12 w=2.4u l=0.13u
MP435 (n430 n424 vdd vdd) p12 w=2.4u l=0.13u
MN438 (n436 n214 n437 vss) n12 w=1.6u l=0.13u
MN439 (n437 n241 vss vss) n12 w=1.6u l=0.13u
MP440 (n436 n214 vdd vdd) p12 w=2.4u l=0.13u
MP441 (n436 n241 vdd vdd) p12 w=2.4u l=0.13u
MN444 (n442 n214 n443 vss) n12 w=1.6u l=0.13u
MN445 (n443 n436 vss vss) n12 w=1.6u l=0.13u
MP446 (n442 n214 vdd vdd) p12 w=2.4u l=0.13u
MP447 (n442 n436 vdd vdd) p12 w=2.4u l=0.13u
MN450 (n448 n241 n449 vss) n12 w=1.6u l=0.13u
MN451 (n449 n436 vss vss) n12 w=1.6u l=0.13u
MP452 (n448 n241 vdd vdd) p12 w=2.4u l=0.13u
MP453 (n448 n436 vdd vdd) p12 w=2.4u l=0.13u
MN456 (n454 n442 n455 vss) n12 w=1.6u l=0.13u
MN457 (n455 n448 vss vss) n12 w=1.6u l=0.13u
MP458 (n454 n442 vdd vdd) p12 w=2.4u l=0.13u
MP459 (n454 n448 vdd vdd) p12 w=2.4u l=0.13u
MN462 (n460 n241 n461 vss) n12 w=1.6u l=0.13u
MN463 (n461 n268 vss vss) n12 w=1.6u l=0.13u
MP464 (n460 n241 vdd vdd) p12 w=2.4u l=0.13u
MP465 (n460 n268 vdd vdd) p12 w=2.4u l=0.13u
MN468 (n466 n241 n467 vss) n12 w=1.6u l=0.13u
MN469 (n467 n460 vss vss) n12 w=1.6u l=0.13u
MP470 (n466 n241 vdd vdd) p12 w=2.4u l=0.13u
MP471 (n466 n460 vdd vdd) p12 w=2.4u l=0.13u
MN474 (n472 n268 n473 vss) n12 w=1.6u l=0.13u
MN475 (n473 n460 vss vss) n12 w=1.6u l=0.13u
MP476 (n472 n268 vdd vdd) p12 w=2.4u l=0.13u
MP477 (n472 n460 vdd vdd) p12 w=2.4u l=0.13u
MN480 (n478 n466 n479 vss) n12 w=1.6u l=0.13u
MN481 (n479 n472 vss vss) n12 w=1.6u l=0.13u
MP482 (n478 n466 vdd vdd) p12 w=2.4u l=0.13u
MP483 (n478 n472 vdd vdd) p12 w=2.4u l=0.13u
MN486 (n484 n268 n485 vss) n12 w=1.6u l=0.13u
MN487 (n485 n295 vss vss) n12 w=1.6u l=0.13u
MP488 (n484 n268 vdd vdd) p12 w=2.4u l=0.13u
MP489 (n484 n295 vdd vdd) p12 w=2.4u l=0.13u
MN492 (n490 n268 n491 vss) n12 w=1.6u l=0.13u
MN493 (n491 n484 vss vss) n12 w=1.6u l=0.13u
MP494 (n490 n268 vdd vdd) p12 w=2.4u l=0.13u
MP495 (n490 n484 vdd vdd) p12 w=2.4u l=0.13u
MN498 (n496 n295 n497 vss) n12 w=1.6u l=0.13u
MN499 (n497 n484 vss vss) n12 w=1.6u l=0.13u
MP500 (n496 n295 vdd vdd) p12 w=2.4u l=0.13u
MP501 (n496 n484 vdd vdd) p12 w=2.4u l=0.13u
MN504 (n502 n490 n503 vss) n12 w=1.6u l=0.13u
MN505 (n503 n496 vss vss) n12 w=1.6u l=0.13u
MP506 (n502 n490 vdd vdd) p12 w=2.4u l=0.13u
MP507 (n502 n496 vdd vdd) p12 w=2.4u l=0.13u
MN510 (n508 n295 n509 vss) n12 w=1.6u l=0.13u
MN511 (n509 n322 vss vss) n12 w=1.6u l=0.13u
MP512 (n508 n295 vdd vdd) p12 w=2.4u l=0.13u
MP513 (n508 n322 vdd vdd) p12 w=2.4u l=0.13u
MN516 (n514 n295 n515 vss) n12 w=1.6u l=0.13u
MN517 (n515 n508 vss vss) n12 w=1.6u l=0.13u
MP518 (n514 n295 vdd vdd) p12 w=2.4u l=0.13u
MP519 (n514 n508 vdd vdd) p12 w=2.4u l=0.13u
MN522 (n520 n322 n521 vss) n12 w=1.6u l=0.13u
MN523 (n521 n508 vss vss) n12 w=1.6u l=0.13u
MP524 (n520 n322 vdd vdd) p12 w=2.4u l=0.13u
MP525 (n520 n508 vdd vdd) p12 w=2.4u l=0.13u
MN528 (n526 n514 n527 vss) n12 w=1.6u l=0.13u
MN529 (n527 n520 vss vss) n12 w=1.6u l=0.13u
MP530 (n526 n514 vdd vdd) p12 w=2.4u l=0.13u
MP531 (n526 n520 vdd vdd) p12 w=2.4u l=0.13u
MN534 (n532 n322 n533 vss) n12 w=1.6u l=0.13u
MN535 (n533 n349 vss vss) n12 w=1.6u l=0.13u
MP536 (n532 n322 vdd vdd) p12 w=2.4u l=0.13u
MP537 (n532 n349 vdd vdd) p12 w=2.4u l=0.13u
MN540 (n538 n322 n539 vss) n12 w=1.6u l=0.13u
MN541 (n539 n532 vss vss) n12 w=1.6u l=0.13u
MP542 (n538 n322 vdd vdd) p12 w=2.4u l=0.13u
MP543 (n538 n532 vdd vdd) p12 w=2.4u l=0.13u
MN546 (n544 n349 n545 vss) n12 w=1.6u l=0.13u
MN547 (n545 n532 vss vss) n12 w=1.6u l=0.13u
MP548 (n544 n349 vdd vdd) p12 w=2.4u l=0.13u
MP549 (n544 n532 vdd vdd) p12 w=2.4u l=0.13u
MN552 (n550 n538 n551 vss) n12 w=1.6u l=0.13u
MN553 (n551 n544 vss vss) n12 w=1.6u l=0.13u
MP554 (n550 n538 vdd vdd) p12 w=2.4u l=0.13u
MP555 (n550 n544 vdd vdd) p12 w=2.4u l=0.13u
MN558 (n556 n349 n557 vss) n12 w=1.6u l=0.13u
MN559 (n557 n376 vss vss) n12 w=1.6u l=0.13u
MP560 (n556 n349 vdd vdd) p12 w=2.4u l=0.13u
MP561 (n556 n376 vdd vdd) p12 w=2.4u l=0.13u
MN564 (n562 n349 n563 vss) n12 w=1.6u l=0.13u
MN565 (n563 n556 vss vss) n12 w=1.6u l=0.13u
MP566 (n562 n349 vdd vdd) p12 w=2.4u l=0.13u
MP567 (n562 n556 vdd vdd) p12 w=2.4u l=0.13u
MN570 (n568 n376 n569 vss) n12 w=1.6u l=0.13u
MN571 (n569 n556 vss vss) n12 w=1.6u l=0.13u
MP572 (n568 n376 vdd vdd) p12 w=2.4u l=0.13u
MP573 (n568 n556 vdd vdd) p12 w=2.4u l=0.13u
MN576 (n574 n562 n575 vss) n12 w=1.6u l=0.13u
MN577 (n575 n568 vss vss) n12 w=1.6u l=0.13u
MP578 (n574 n562 vdd vdd) p12 w=2.4u l=0.13u
MP579 (n574 n568 vdd vdd) p12 w=2.4u l=0.13u
MN582 (n580 n376 n581 vss) n12 w=1.6u l=0.13u
MN583 (n581 n403 vss vss) n12 w=1.6u l=0.13u
MP584 (n580 n376 vdd vdd) p12 w=2.4u l=0.13u
MP585 (n580 n403 vdd vdd) p12 w=2.4u l=0.13u
MN588 (n586 n376 n587 vss) n12 w=1.6u l=0.13u
MN589 (n587 n580 vss vss) n12 w=1.6u l=0.13u
MP590 (n586 n376 vdd vdd) p12 w=2.4u l=0.13u
MP591 (n586 n580 vdd vdd) p12 w=2.4u l=0.13u
MN594 (n592 n403 n593 vss) n12 w=1.6u l=0.13u
MN595 (n593 n580 vss vss) n12 w=1.6u l=0.13u
MP596 (n592 n403 vdd vdd) p12 w=2.4u l=0.13u
MP597 (n592 n580 vdd vdd) p12 w=2.4u l=0.13u
MN600 (n598 n586 n599 vss) n12 w=1.6u l=0.13u
MN601 (n599 n592 vss vss) n12 w=1.6u l=0.13u
MP602 (n598 n586 vdd vdd) p12 w=2.4u l=0.13u
MP603 (n598 n592 vdd vdd) p12 w=2.4u l=0.13u
MN605 (delay604 clk vss vss) n12 w=0.8u l=0.13u
MP606 (delay604 clk vdd vdd) p12 w=2.4u l=0.13u
MN608 (delay607 delay604 vss vss) n12 w=0.8u l=0.13u
MP609 (delay607 delay604 vdd vdd) p12 w=2.4u l=0.13u
MN611 (delay610 delay607 vss vss) n12 w=0.8u l=0.13u
MP612 (delay610 delay607 vdd vdd) p12 w=2.4u l=0.13u
MN614 (delay613 delay610 vss vss) n12 w=0.8u l=0.13u
MP615 (delay613 delay610 vdd vdd) p12 w=2.4u l=0.13u
MN617 (delay616 delay613 vss vss) n12 w=0.8u l=0.13u
MP618 (delay616 delay613 vdd vdd) p12 w=2.4u l=0.13u
MN620 (delay619 delay616 vss vss) n12 w=0.8u l=0.13u
MP621 (delay619 delay616 vdd vdd) p12 w=2.4u l=0.13u
MN623 (n622 clk vss vss) n12 w=0.8u l=0.13u
MP624 (n622 clk vdd vdd) p12 w=2.4u l=0.13u
MN626 (n625 delay619 vss vss) n12 w=0.8u l=0.13u
MP627 (n625 delay619 vdd vdd) p12 w=2.4u l=0.13u
MN629 (n628 rst vss vss) n12 w=0.8u l=0.13u
MP630 (n628 rst vdd vdd) p12 w=2.4u l=0.13u
MN639 (n635 n622 n636 vss) n12 w=3.2u l=0.13u
MP640 (n635 n622 vdd vdd) p12 w=2.4u l=0.13u
MN641 (n636 n625 n637 vss) n12 w=3.2u l=0.13u
MP642 (n635 n625 vdd vdd) p12 w=2.4u l=0.13u
MN643 (n637 clk_highb634 n638 vss) n12 w=3.2u l=0.13u
MP644 (n635 clk_highb634 vdd vdd) p12 w=2.4u l=0.13u
MN645 (n638 n628 vss vss) n12 w=3.2u l=0.13u
MP646 (n635 n628 vdd vdd) p12 w=2.4u l=0.13u
MN651 (n647 clk n648 vss) n12 w=3.2u l=0.13u
MP652 (n647 clk vdd vdd) p12 w=2.4u l=0.13u
MN653 (n648 delay619 n649 vss) n12 w=3.2u l=0.13u
MP654 (n647 delay619 vdd vdd) p12 w=2.4u l=0.13u
MN655 (n649 clk_lowb632 n650 vss) n12 w=3.2u l=0.13u
MP656 (n647 clk_lowb632 vdd vdd) p12 w=2.4u l=0.13u
MN657 (n650 n628 vss vss) n12 w=3.2u l=0.13u
MP658 (n647 n628 vdd vdd) p12 w=2.4u l=0.13u
MN659 (clk_low631 n635 vss vss) n12 w=8u l=0.13u
MP660 (clk_low631 n635 vdd vdd) p12 w=24u l=0.13u
MN661 (clk_lowb632 clk_low631 vss vss) n12 w=8u l=0.13u
MP662 (clk_lowb632 clk_low631 vdd vdd) p12 w=24u l=0.13u
MN663 (clk_high633 n647 vss vss) n12 w=8u l=0.13u
MP664 (clk_high633 n647 vdd vdd) p12 w=24u l=0.13u
MN665 (clk_highb634 clk_high633 vss vss) n12 w=8u l=0.13u
MP666 (clk_highb634 clk_high633 vdd vdd) p12 w=24u l=0.13u
MN671 (n430 clk_low631 storage670 vss) n12 w=1.2u l=0.13u
MP672 (n430 clk_lowb632 storage670 vdd) p12 w=3.6u l=0.13u
MN673 (qm667 clk_high633 storage670 vss) n12 w=1.2u l=0.13u
MP674 (qm667 clk_highb634 storage670 vdd) p12 w=3.6u l=0.13u
MN675 (qmb668 storage670 vss vss) n12 w=0.5u l=0.13u
MP676 (qmb668 storage670 vdd vdd) p12 w=1.5u l=0.13u
MN677 (qm667 qmb668 vss vss) n12 w=0.5u l=0.13u
MP678 (qm667 qmb668 vdd vdd) p12 w=1.5u l=0.13u
MN679 (storage670 rst vss vss) n12 w=2u l=0.13u
MN681 (qm667 clk_high633 storage680 vss) n12 w=1.2u l=0.13u
MP682 (qm667 clk_highb634 storage680 vdd) p12 w=3.6u l=0.13u
MN683 (zero_g0 clk_low631 storage680 vss) n12 w=1.2u l=0.13u
MP684 (zero_g0 clk_lowb632 storage680 vdd) p12 w=3.6u l=0.13u
MN685 (qb669 storage680 vss vss) n12 w=0.5u l=0.13u
MP686 (qb669 storage680 vdd vdd) p12 w=1.5u l=0.13u
MN687 (zero_g0 qb669 vss vss) n12 w=0.5u l=0.13u
MP688 (zero_g0 qb669 vdd vdd) p12 w=1.5u l=0.13u
MN689 (storage680 rst vss vss) n12 w=2u l=0.13u
MN694 (n454 clk_low631 storage693 vss) n12 w=1.2u l=0.13u
MP695 (n454 clk_lowb632 storage693 vdd) p12 w=3.6u l=0.13u
MN696 (qm690 clk_high633 storage693 vss) n12 w=1.2u l=0.13u
MP697 (qm690 clk_highb634 storage693 vdd) p12 w=3.6u l=0.13u
MN698 (qmb691 storage693 vss vss) n12 w=0.5u l=0.13u
MP699 (qmb691 storage693 vdd vdd) p12 w=1.5u l=0.13u
MN700 (qm690 qmb691 vss vss) n12 w=0.5u l=0.13u
MP701 (qm690 qmb691 vdd vdd) p12 w=1.5u l=0.13u
MN702 (storage693 rst vss vss) n12 w=2u l=0.13u
MN704 (qm690 clk_high633 storage703 vss) n12 w=1.2u l=0.13u
MP705 (qm690 clk_highb634 storage703 vdd) p12 w=3.6u l=0.13u
MN706 (zero_g1 clk_low631 storage703 vss) n12 w=1.2u l=0.13u
MP707 (zero_g1 clk_lowb632 storage703 vdd) p12 w=3.6u l=0.13u
MN708 (qb692 storage703 vss vss) n12 w=0.5u l=0.13u
MP709 (qb692 storage703 vdd vdd) p12 w=1.5u l=0.13u
MN710 (zero_g1 qb692 vss vss) n12 w=0.5u l=0.13u
MP711 (zero_g1 qb692 vdd vdd) p12 w=1.5u l=0.13u
MN712 (storage703 rst vss vss) n12 w=2u l=0.13u
MN717 (n478 clk_low631 storage716 vss) n12 w=1.2u l=0.13u
MP718 (n478 clk_lowb632 storage716 vdd) p12 w=3.6u l=0.13u
MN719 (qm713 clk_high633 storage716 vss) n12 w=1.2u l=0.13u
MP720 (qm713 clk_highb634 storage716 vdd) p12 w=3.6u l=0.13u
MN721 (qmb714 storage716 vss vss) n12 w=0.5u l=0.13u
MP722 (qmb714 storage716 vdd vdd) p12 w=1.5u l=0.13u
MN723 (qm713 qmb714 vss vss) n12 w=0.5u l=0.13u
MP724 (qm713 qmb714 vdd vdd) p12 w=1.5u l=0.13u
MN725 (storage716 rst vss vss) n12 w=2u l=0.13u
MN727 (qm713 clk_high633 storage726 vss) n12 w=1.2u l=0.13u
MP728 (qm713 clk_highb634 storage726 vdd) p12 w=3.6u l=0.13u
MN729 (zero_g2 clk_low631 storage726 vss) n12 w=1.2u l=0.13u
MP730 (zero_g2 clk_lowb632 storage726 vdd) p12 w=3.6u l=0.13u
MN731 (qb715 storage726 vss vss) n12 w=0.5u l=0.13u
MP732 (qb715 storage726 vdd vdd) p12 w=1.5u l=0.13u
MN733 (zero_g2 qb715 vss vss) n12 w=0.5u l=0.13u
MP734 (zero_g2 qb715 vdd vdd) p12 w=1.5u l=0.13u
MN735 (storage726 rst vss vss) n12 w=2u l=0.13u
MN740 (n502 clk_low631 storage739 vss) n12 w=1.2u l=0.13u
MP741 (n502 clk_lowb632 storage739 vdd) p12 w=3.6u l=0.13u
MN742 (qm736 clk_high633 storage739 vss) n12 w=1.2u l=0.13u
MP743 (qm736 clk_highb634 storage739 vdd) p12 w=3.6u l=0.13u
MN744 (qmb737 storage739 vss vss) n12 w=0.5u l=0.13u
MP745 (qmb737 storage739 vdd vdd) p12 w=1.5u l=0.13u
MN746 (qm736 qmb737 vss vss) n12 w=0.5u l=0.13u
MP747 (qm736 qmb737 vdd vdd) p12 w=1.5u l=0.13u
MN748 (storage739 rst vss vss) n12 w=2u l=0.13u
MN750 (qm736 clk_high633 storage749 vss) n12 w=1.2u l=0.13u
MP751 (qm736 clk_highb634 storage749 vdd) p12 w=3.6u l=0.13u
MN752 (zero_g3 clk_low631 storage749 vss) n12 w=1.2u l=0.13u
MP753 (zero_g3 clk_lowb632 storage749 vdd) p12 w=3.6u l=0.13u
MN754 (qb738 storage749 vss vss) n12 w=0.5u l=0.13u
MP755 (qb738 storage749 vdd vdd) p12 w=1.5u l=0.13u
MN756 (zero_g3 qb738 vss vss) n12 w=0.5u l=0.13u
MP757 (zero_g3 qb738 vdd vdd) p12 w=1.5u l=0.13u
MN758 (storage749 rst vss vss) n12 w=2u l=0.13u
MN763 (n526 clk_low631 storage762 vss) n12 w=1.2u l=0.13u
MP764 (n526 clk_lowb632 storage762 vdd) p12 w=3.6u l=0.13u
MN765 (qm759 clk_high633 storage762 vss) n12 w=1.2u l=0.13u
MP766 (qm759 clk_highb634 storage762 vdd) p12 w=3.6u l=0.13u
MN767 (qmb760 storage762 vss vss) n12 w=0.5u l=0.13u
MP768 (qmb760 storage762 vdd vdd) p12 w=1.5u l=0.13u
MN769 (qm759 qmb760 vss vss) n12 w=0.5u l=0.13u
MP770 (qm759 qmb760 vdd vdd) p12 w=1.5u l=0.13u
MN771 (storage762 rst vss vss) n12 w=2u l=0.13u
MN773 (qm759 clk_high633 storage772 vss) n12 w=1.2u l=0.13u
MP774 (qm759 clk_highb634 storage772 vdd) p12 w=3.6u l=0.13u
MN775 (zero_g4 clk_low631 storage772 vss) n12 w=1.2u l=0.13u
MP776 (zero_g4 clk_lowb632 storage772 vdd) p12 w=3.6u l=0.13u
MN777 (qb761 storage772 vss vss) n12 w=0.5u l=0.13u
MP778 (qb761 storage772 vdd vdd) p12 w=1.5u l=0.13u
MN779 (zero_g4 qb761 vss vss) n12 w=0.5u l=0.13u
MP780 (zero_g4 qb761 vdd vdd) p12 w=1.5u l=0.13u
MN781 (storage772 rst vss vss) n12 w=2u l=0.13u
MN786 (n550 clk_low631 storage785 vss) n12 w=1.2u l=0.13u
MP787 (n550 clk_lowb632 storage785 vdd) p12 w=3.6u l=0.13u
MN788 (qm782 clk_high633 storage785 vss) n12 w=1.2u l=0.13u
MP789 (qm782 clk_highb634 storage785 vdd) p12 w=3.6u l=0.13u
MN790 (qmb783 storage785 vss vss) n12 w=0.5u l=0.13u
MP791 (qmb783 storage785 vdd vdd) p12 w=1.5u l=0.13u
MN792 (qm782 qmb783 vss vss) n12 w=0.5u l=0.13u
MP793 (qm782 qmb783 vdd vdd) p12 w=1.5u l=0.13u
MN794 (storage785 rst vss vss) n12 w=2u l=0.13u
MN796 (qm782 clk_high633 storage795 vss) n12 w=1.2u l=0.13u
MP797 (qm782 clk_highb634 storage795 vdd) p12 w=3.6u l=0.13u
MN798 (zero_g5 clk_low631 storage795 vss) n12 w=1.2u l=0.13u
MP799 (zero_g5 clk_lowb632 storage795 vdd) p12 w=3.6u l=0.13u
MN800 (qb784 storage795 vss vss) n12 w=0.5u l=0.13u
MP801 (qb784 storage795 vdd vdd) p12 w=1.5u l=0.13u
MN802 (zero_g5 qb784 vss vss) n12 w=0.5u l=0.13u
MP803 (zero_g5 qb784 vdd vdd) p12 w=1.5u l=0.13u
MN804 (storage795 rst vss vss) n12 w=2u l=0.13u
MN809 (n574 clk_low631 storage808 vss) n12 w=1.2u l=0.13u
MP810 (n574 clk_lowb632 storage808 vdd) p12 w=3.6u l=0.13u
MN811 (qm805 clk_high633 storage808 vss) n12 w=1.2u l=0.13u
MP812 (qm805 clk_highb634 storage808 vdd) p12 w=3.6u l=0.13u
MN813 (qmb806 storage808 vss vss) n12 w=0.5u l=0.13u
MP814 (qmb806 storage808 vdd vdd) p12 w=1.5u l=0.13u
MN815 (qm805 qmb806 vss vss) n12 w=0.5u l=0.13u
MP816 (qm805 qmb806 vdd vdd) p12 w=1.5u l=0.13u
MN817 (storage808 rst vss vss) n12 w=2u l=0.13u
MN819 (qm805 clk_high633 storage818 vss) n12 w=1.2u l=0.13u
MP820 (qm805 clk_highb634 storage818 vdd) p12 w=3.6u l=0.13u
MN821 (zero_g6 clk_low631 storage818 vss) n12 w=1.2u l=0.13u
MP822 (zero_g6 clk_lowb632 storage818 vdd) p12 w=3.6u l=0.13u
MN823 (qb807 storage818 vss vss) n12 w=0.5u l=0.13u
MP824 (qb807 storage818 vdd vdd) p12 w=1.5u l=0.13u
MN825 (zero_g6 qb807 vss vss) n12 w=0.5u l=0.13u
MP826 (zero_g6 qb807 vdd vdd) p12 w=1.5u l=0.13u
MN827 (storage818 rst vss vss) n12 w=2u l=0.13u
MN832 (n598 clk_low631 storage831 vss) n12 w=1.2u l=0.13u
MP833 (n598 clk_lowb632 storage831 vdd) p12 w=3.6u l=0.13u
MN834 (qm828 clk_high633 storage831 vss) n12 w=1.2u l=0.13u
MP835 (qm828 clk_highb634 storage831 vdd) p12 w=3.6u l=0.13u
MN836 (qmb829 storage831 vss vss) n12 w=0.5u l=0.13u
MP837 (qmb829 storage831 vdd vdd) p12 w=1.5u l=0.13u
MN838 (qm828 qmb829 vss vss) n12 w=0.5u l=0.13u
MP839 (qm828 qmb829 vdd vdd) p12 w=1.5u l=0.13u
MN840 (storage831 rst vss vss) n12 w=2u l=0.13u
MN842 (qm828 clk_high633 storage841 vss) n12 w=1.2u l=0.13u
MP843 (qm828 clk_highb634 storage841 vdd) p12 w=3.6u l=0.13u
MN844 (zero_g7 clk_low631 storage841 vss) n12 w=1.2u l=0.13u
MP845 (zero_g7 clk_lowb632 storage841 vdd) p12 w=3.6u l=0.13u
MN846 (qb830 storage841 vss vss) n12 w=0.5u l=0.13u
MP847 (qb830 storage841 vdd vdd) p12 w=1.5u l=0.13u
MN848 (zero_g7 qb830 vss vss) n12 w=0.5u l=0.13u
MP849 (zero_g7 qb830 vdd vdd) p12 w=1.5u l=0.13u
MN850 (storage841 rst vss vss) n12 w=2u l=0.13u
MN855 (n403 clk_low631 storage854 vss) n12 w=1.2u l=0.13u
MP856 (n403 clk_lowb632 storage854 vdd) p12 w=3.6u l=0.13u
MN857 (qm851 clk_high633 storage854 vss) n12 w=1.2u l=0.13u
MP858 (qm851 clk_highb634 storage854 vdd) p12 w=3.6u l=0.13u
MN859 (qmb852 storage854 vss vss) n12 w=0.5u l=0.13u
MP860 (qmb852 storage854 vdd vdd) p12 w=1.5u l=0.13u
MN861 (qm851 qmb852 vss vss) n12 w=0.5u l=0.13u
MP862 (qm851 qmb852 vdd vdd) p12 w=1.5u l=0.13u
MN863 (storage854 rst vss vss) n12 w=2u l=0.13u
MN865 (qm851 clk_high633 storage864 vss) n12 w=1.2u l=0.13u
MP866 (qm851 clk_highb634 storage864 vdd) p12 w=3.6u l=0.13u
MN867 (zero_g8 clk_low631 storage864 vss) n12 w=1.2u l=0.13u
MP868 (zero_g8 clk_lowb632 storage864 vdd) p12 w=3.6u l=0.13u
MN869 (qb853 storage864 vss vss) n12 w=0.5u l=0.13u
MP870 (qb853 storage864 vdd vdd) p12 w=1.5u l=0.13u
MN871 (zero_g8 qb853 vss vss) n12 w=0.5u l=0.13u
MP872 (zero_g8 qb853 vdd vdd) p12 w=1.5u l=0.13u
MN873 (storage864 rst vss vss) n12 w=2u l=0.13u
MN875 (delay874 ref vss vss) n12 w=0.8u l=0.13u
MP876 (delay874 ref vdd vdd) p12 w=2.4u l=0.13u
MN878 (delay877 delay874 vss vss) n12 w=0.8u l=0.13u
MP879 (delay877 delay874 vdd vdd) p12 w=2.4u l=0.13u
MN881 (delay880 delay877 vss vss) n12 w=0.8u l=0.13u
MP882 (delay880 delay877 vdd vdd) p12 w=2.4u l=0.13u
MN884 (delay883 delay880 vss vss) n12 w=0.8u l=0.13u
MP885 (delay883 delay880 vdd vdd) p12 w=2.4u l=0.13u
MN887 (delay886 delay883 vss vss) n12 w=0.8u l=0.13u
MP888 (delay886 delay883 vdd vdd) p12 w=2.4u l=0.13u
MN890 (delay889 delay886 vss vss) n12 w=0.8u l=0.13u
MP891 (delay889 delay886 vdd vdd) p12 w=2.4u l=0.13u
MN893 (n892 ref vss vss) n12 w=0.8u l=0.13u
MP894 (n892 ref vdd vdd) p12 w=2.4u l=0.13u
MN896 (n895 delay889 vss vss) n12 w=0.8u l=0.13u
MP897 (n895 delay889 vdd vdd) p12 w=2.4u l=0.13u
MN906 (n902 n892 n903 vss) n12 w=3.2u l=0.13u
MP907 (n902 n892 vdd vdd) p12 w=2.4u l=0.13u
MN908 (n903 n895 n904 vss) n12 w=3.2u l=0.13u
MP909 (n902 n895 vdd vdd) p12 w=2.4u l=0.13u
MN910 (n904 clk_highb901 n905 vss) n12 w=3.2u l=0.13u
MP911 (n902 clk_highb901 vdd vdd) p12 w=2.4u l=0.13u
MN912 (n905 n628 vss vss) n12 w=3.2u l=0.13u
MP913 (n902 n628 vdd vdd) p12 w=2.4u l=0.13u
MN918 (n914 ref n915 vss) n12 w=3.2u l=0.13u
MP919 (n914 ref vdd vdd) p12 w=2.4u l=0.13u
MN920 (n915 delay889 n916 vss) n12 w=3.2u l=0.13u
MP921 (n914 delay889 vdd vdd) p12 w=2.4u l=0.13u
MN922 (n916 clk_lowb899 n917 vss) n12 w=3.2u l=0.13u
MP923 (n914 clk_lowb899 vdd vdd) p12 w=2.4u l=0.13u
MN924 (n917 n628 vss vss) n12 w=3.2u l=0.13u
MP925 (n914 n628 vdd vdd) p12 w=2.4u l=0.13u
MN926 (clk_low898 n902 vss vss) n12 w=8u l=0.13u
MP927 (clk_low898 n902 vdd vdd) p12 w=24u l=0.13u
MN928 (clk_lowb899 clk_low898 vss vss) n12 w=8u l=0.13u
MP929 (clk_lowb899 clk_low898 vdd vdd) p12 w=24u l=0.13u
MN930 (clk_high900 n914 vss vss) n12 w=8u l=0.13u
MP931 (clk_high900 n914 vdd vdd) p12 w=24u l=0.13u
MN932 (clk_highb901 clk_high900 vss vss) n12 w=8u l=0.13u
MP933 (clk_highb901 clk_high900 vdd vdd) p12 w=24u l=0.13u
MN938 (zero_g0 clk_low898 storage937 vss) n12 w=1.2u l=0.13u
MP939 (zero_g0 clk_lowb899 storage937 vdd) p12 w=3.6u l=0.13u
MN940 (qm934 clk_high900 storage937 vss) n12 w=1.2u l=0.13u
MP941 (qm934 clk_highb901 storage937 vdd) p12 w=3.6u l=0.13u
MN942 (qmb935 storage937 vss vss) n12 w=0.5u l=0.13u
MP943 (qmb935 storage937 vdd vdd) p12 w=1.5u l=0.13u
MN944 (qm934 qmb935 vss vss) n12 w=0.5u l=0.13u
MP945 (qm934 qmb935 vdd vdd) p12 w=1.5u l=0.13u
MN946 (storage937 rst vss vss) n12 w=2u l=0.13u
MN948 (qm934 clk_high900 storage947 vss) n12 w=1.2u l=0.13u
MP949 (qm934 clk_highb901 storage947 vdd) p12 w=3.6u l=0.13u
MN950 (zero_sync1_0 clk_low898 storage947 vss) n12 w=1.2u l=0.13u
MP951 (zero_sync1_0 clk_lowb899 storage947 vdd) p12 w=3.6u l=0.13u
MN952 (qb936 storage947 vss vss) n12 w=0.5u l=0.13u
MP953 (qb936 storage947 vdd vdd) p12 w=1.5u l=0.13u
MN954 (zero_sync1_0 qb936 vss vss) n12 w=0.5u l=0.13u
MP955 (zero_sync1_0 qb936 vdd vdd) p12 w=1.5u l=0.13u
MN956 (storage947 rst vss vss) n12 w=2u l=0.13u
MN961 (zero_sync1_0 clk_low898 storage960 vss) n12 w=1.2u l=0.13u
MP962 (zero_sync1_0 clk_lowb899 storage960 vdd) p12 w=3.6u l=0.13u
MN963 (qm957 clk_high900 storage960 vss) n12 w=1.2u l=0.13u
MP964 (qm957 clk_highb901 storage960 vdd) p12 w=3.6u l=0.13u
MN965 (qmb958 storage960 vss vss) n12 w=0.5u l=0.13u
MP966 (qmb958 storage960 vdd vdd) p12 w=1.5u l=0.13u
MN967 (qm957 qmb958 vss vss) n12 w=0.5u l=0.13u
MP968 (qm957 qmb958 vdd vdd) p12 w=1.5u l=0.13u
MN969 (storage960 rst vss vss) n12 w=2u l=0.13u
MN971 (qm957 clk_high900 storage970 vss) n12 w=1.2u l=0.13u
MP972 (qm957 clk_highb901 storage970 vdd) p12 w=3.6u l=0.13u
MN973 (zero_sync2_0 clk_low898 storage970 vss) n12 w=1.2u l=0.13u
MP974 (zero_sync2_0 clk_lowb899 storage970 vdd) p12 w=3.6u l=0.13u
MN975 (qb959 storage970 vss vss) n12 w=0.5u l=0.13u
MP976 (qb959 storage970 vdd vdd) p12 w=1.5u l=0.13u
MN977 (zero_sync2_0 qb959 vss vss) n12 w=0.5u l=0.13u
MP978 (zero_sync2_0 qb959 vdd vdd) p12 w=1.5u l=0.13u
MN979 (storage970 rst vss vss) n12 w=2u l=0.13u
MN984 (zero_g1 clk_low898 storage983 vss) n12 w=1.2u l=0.13u
MP985 (zero_g1 clk_lowb899 storage983 vdd) p12 w=3.6u l=0.13u
MN986 (qm980 clk_high900 storage983 vss) n12 w=1.2u l=0.13u
MP987 (qm980 clk_highb901 storage983 vdd) p12 w=3.6u l=0.13u
MN988 (qmb981 storage983 vss vss) n12 w=0.5u l=0.13u
MP989 (qmb981 storage983 vdd vdd) p12 w=1.5u l=0.13u
MN990 (qm980 qmb981 vss vss) n12 w=0.5u l=0.13u
MP991 (qm980 qmb981 vdd vdd) p12 w=1.5u l=0.13u
MN992 (storage983 rst vss vss) n12 w=2u l=0.13u
MN994 (qm980 clk_high900 storage993 vss) n12 w=1.2u l=0.13u
MP995 (qm980 clk_highb901 storage993 vdd) p12 w=3.6u l=0.13u
MN996 (zero_sync1_1 clk_low898 storage993 vss) n12 w=1.2u l=0.13u
MP997 (zero_sync1_1 clk_lowb899 storage993 vdd) p12 w=3.6u l=0.13u
MN998 (qb982 storage993 vss vss) n12 w=0.5u l=0.13u
MP999 (qb982 storage993 vdd vdd) p12 w=1.5u l=0.13u
MN1000 (zero_sync1_1 qb982 vss vss) n12 w=0.5u l=0.13u
MP1001 (zero_sync1_1 qb982 vdd vdd) p12 w=1.5u l=0.13u
MN1002 (storage993 rst vss vss) n12 w=2u l=0.13u
MN1007 (zero_sync1_1 clk_low898 storage1006 vss) n12 w=1.2u l=0.13u
MP1008 (zero_sync1_1 clk_lowb899 storage1006 vdd) p12 w=3.6u l=0.13u
MN1009 (qm1003 clk_high900 storage1006 vss) n12 w=1.2u l=0.13u
MP1010 (qm1003 clk_highb901 storage1006 vdd) p12 w=3.6u l=0.13u
MN1011 (qmb1004 storage1006 vss vss) n12 w=0.5u l=0.13u
MP1012 (qmb1004 storage1006 vdd vdd) p12 w=1.5u l=0.13u
MN1013 (qm1003 qmb1004 vss vss) n12 w=0.5u l=0.13u
MP1014 (qm1003 qmb1004 vdd vdd) p12 w=1.5u l=0.13u
MN1015 (storage1006 rst vss vss) n12 w=2u l=0.13u
MN1017 (qm1003 clk_high900 storage1016 vss) n12 w=1.2u l=0.13u
MP1018 (qm1003 clk_highb901 storage1016 vdd) p12 w=3.6u l=0.13u
MN1019 (zero_sync2_1 clk_low898 storage1016 vss) n12 w=1.2u l=0.13u
MP1020 (zero_sync2_1 clk_lowb899 storage1016 vdd) p12 w=3.6u l=0.13u
MN1021 (qb1005 storage1016 vss vss) n12 w=0.5u l=0.13u
MP1022 (qb1005 storage1016 vdd vdd) p12 w=1.5u l=0.13u
MN1023 (zero_sync2_1 qb1005 vss vss) n12 w=0.5u l=0.13u
MP1024 (zero_sync2_1 qb1005 vdd vdd) p12 w=1.5u l=0.13u
MN1025 (storage1016 rst vss vss) n12 w=2u l=0.13u
MN1030 (zero_g2 clk_low898 storage1029 vss) n12 w=1.2u l=0.13u
MP1031 (zero_g2 clk_lowb899 storage1029 vdd) p12 w=3.6u l=0.13u
MN1032 (qm1026 clk_high900 storage1029 vss) n12 w=1.2u l=0.13u
MP1033 (qm1026 clk_highb901 storage1029 vdd) p12 w=3.6u l=0.13u
MN1034 (qmb1027 storage1029 vss vss) n12 w=0.5u l=0.13u
MP1035 (qmb1027 storage1029 vdd vdd) p12 w=1.5u l=0.13u
MN1036 (qm1026 qmb1027 vss vss) n12 w=0.5u l=0.13u
MP1037 (qm1026 qmb1027 vdd vdd) p12 w=1.5u l=0.13u
MN1038 (storage1029 rst vss vss) n12 w=2u l=0.13u
MN1040 (qm1026 clk_high900 storage1039 vss) n12 w=1.2u l=0.13u
MP1041 (qm1026 clk_highb901 storage1039 vdd) p12 w=3.6u l=0.13u
MN1042 (zero_sync1_2 clk_low898 storage1039 vss) n12 w=1.2u l=0.13u
MP1043 (zero_sync1_2 clk_lowb899 storage1039 vdd) p12 w=3.6u l=0.13u
MN1044 (qb1028 storage1039 vss vss) n12 w=0.5u l=0.13u
MP1045 (qb1028 storage1039 vdd vdd) p12 w=1.5u l=0.13u
MN1046 (zero_sync1_2 qb1028 vss vss) n12 w=0.5u l=0.13u
MP1047 (zero_sync1_2 qb1028 vdd vdd) p12 w=1.5u l=0.13u
MN1048 (storage1039 rst vss vss) n12 w=2u l=0.13u
MN1053 (zero_sync1_2 clk_low898 storage1052 vss) n12 w=1.2u l=0.13u
MP1054 (zero_sync1_2 clk_lowb899 storage1052 vdd) p12 w=3.6u l=0.13u
MN1055 (qm1049 clk_high900 storage1052 vss) n12 w=1.2u l=0.13u
MP1056 (qm1049 clk_highb901 storage1052 vdd) p12 w=3.6u l=0.13u
MN1057 (qmb1050 storage1052 vss vss) n12 w=0.5u l=0.13u
MP1058 (qmb1050 storage1052 vdd vdd) p12 w=1.5u l=0.13u
MN1059 (qm1049 qmb1050 vss vss) n12 w=0.5u l=0.13u
MP1060 (qm1049 qmb1050 vdd vdd) p12 w=1.5u l=0.13u
MN1061 (storage1052 rst vss vss) n12 w=2u l=0.13u
MN1063 (qm1049 clk_high900 storage1062 vss) n12 w=1.2u l=0.13u
MP1064 (qm1049 clk_highb901 storage1062 vdd) p12 w=3.6u l=0.13u
MN1065 (zero_sync2_2 clk_low898 storage1062 vss) n12 w=1.2u l=0.13u
MP1066 (zero_sync2_2 clk_lowb899 storage1062 vdd) p12 w=3.6u l=0.13u
MN1067 (qb1051 storage1062 vss vss) n12 w=0.5u l=0.13u
MP1068 (qb1051 storage1062 vdd vdd) p12 w=1.5u l=0.13u
MN1069 (zero_sync2_2 qb1051 vss vss) n12 w=0.5u l=0.13u
MP1070 (zero_sync2_2 qb1051 vdd vdd) p12 w=1.5u l=0.13u
MN1071 (storage1062 rst vss vss) n12 w=2u l=0.13u
MN1076 (zero_g3 clk_low898 storage1075 vss) n12 w=1.2u l=0.13u
MP1077 (zero_g3 clk_lowb899 storage1075 vdd) p12 w=3.6u l=0.13u
MN1078 (qm1072 clk_high900 storage1075 vss) n12 w=1.2u l=0.13u
MP1079 (qm1072 clk_highb901 storage1075 vdd) p12 w=3.6u l=0.13u
MN1080 (qmb1073 storage1075 vss vss) n12 w=0.5u l=0.13u
MP1081 (qmb1073 storage1075 vdd vdd) p12 w=1.5u l=0.13u
MN1082 (qm1072 qmb1073 vss vss) n12 w=0.5u l=0.13u
MP1083 (qm1072 qmb1073 vdd vdd) p12 w=1.5u l=0.13u
MN1084 (storage1075 rst vss vss) n12 w=2u l=0.13u
MN1086 (qm1072 clk_high900 storage1085 vss) n12 w=1.2u l=0.13u
MP1087 (qm1072 clk_highb901 storage1085 vdd) p12 w=3.6u l=0.13u
MN1088 (zero_sync1_3 clk_low898 storage1085 vss) n12 w=1.2u l=0.13u
MP1089 (zero_sync1_3 clk_lowb899 storage1085 vdd) p12 w=3.6u l=0.13u
MN1090 (qb1074 storage1085 vss vss) n12 w=0.5u l=0.13u
MP1091 (qb1074 storage1085 vdd vdd) p12 w=1.5u l=0.13u
MN1092 (zero_sync1_3 qb1074 vss vss) n12 w=0.5u l=0.13u
MP1093 (zero_sync1_3 qb1074 vdd vdd) p12 w=1.5u l=0.13u
MN1094 (storage1085 rst vss vss) n12 w=2u l=0.13u
MN1099 (zero_sync1_3 clk_low898 storage1098 vss) n12 w=1.2u l=0.13u
MP1100 (zero_sync1_3 clk_lowb899 storage1098 vdd) p12 w=3.6u l=0.13u
MN1101 (qm1095 clk_high900 storage1098 vss) n12 w=1.2u l=0.13u
MP1102 (qm1095 clk_highb901 storage1098 vdd) p12 w=3.6u l=0.13u
MN1103 (qmb1096 storage1098 vss vss) n12 w=0.5u l=0.13u
MP1104 (qmb1096 storage1098 vdd vdd) p12 w=1.5u l=0.13u
MN1105 (qm1095 qmb1096 vss vss) n12 w=0.5u l=0.13u
MP1106 (qm1095 qmb1096 vdd vdd) p12 w=1.5u l=0.13u
MN1107 (storage1098 rst vss vss) n12 w=2u l=0.13u
MN1109 (qm1095 clk_high900 storage1108 vss) n12 w=1.2u l=0.13u
MP1110 (qm1095 clk_highb901 storage1108 vdd) p12 w=3.6u l=0.13u
MN1111 (zero_sync2_3 clk_low898 storage1108 vss) n12 w=1.2u l=0.13u
MP1112 (zero_sync2_3 clk_lowb899 storage1108 vdd) p12 w=3.6u l=0.13u
MN1113 (qb1097 storage1108 vss vss) n12 w=0.5u l=0.13u
MP1114 (qb1097 storage1108 vdd vdd) p12 w=1.5u l=0.13u
MN1115 (zero_sync2_3 qb1097 vss vss) n12 w=0.5u l=0.13u
MP1116 (zero_sync2_3 qb1097 vdd vdd) p12 w=1.5u l=0.13u
MN1117 (storage1108 rst vss vss) n12 w=2u l=0.13u
MN1122 (zero_g4 clk_low898 storage1121 vss) n12 w=1.2u l=0.13u
MP1123 (zero_g4 clk_lowb899 storage1121 vdd) p12 w=3.6u l=0.13u
MN1124 (qm1118 clk_high900 storage1121 vss) n12 w=1.2u l=0.13u
MP1125 (qm1118 clk_highb901 storage1121 vdd) p12 w=3.6u l=0.13u
MN1126 (qmb1119 storage1121 vss vss) n12 w=0.5u l=0.13u
MP1127 (qmb1119 storage1121 vdd vdd) p12 w=1.5u l=0.13u
MN1128 (qm1118 qmb1119 vss vss) n12 w=0.5u l=0.13u
MP1129 (qm1118 qmb1119 vdd vdd) p12 w=1.5u l=0.13u
MN1130 (storage1121 rst vss vss) n12 w=2u l=0.13u
MN1132 (qm1118 clk_high900 storage1131 vss) n12 w=1.2u l=0.13u
MP1133 (qm1118 clk_highb901 storage1131 vdd) p12 w=3.6u l=0.13u
MN1134 (zero_sync1_4 clk_low898 storage1131 vss) n12 w=1.2u l=0.13u
MP1135 (zero_sync1_4 clk_lowb899 storage1131 vdd) p12 w=3.6u l=0.13u
MN1136 (qb1120 storage1131 vss vss) n12 w=0.5u l=0.13u
MP1137 (qb1120 storage1131 vdd vdd) p12 w=1.5u l=0.13u
MN1138 (zero_sync1_4 qb1120 vss vss) n12 w=0.5u l=0.13u
MP1139 (zero_sync1_4 qb1120 vdd vdd) p12 w=1.5u l=0.13u
MN1140 (storage1131 rst vss vss) n12 w=2u l=0.13u
MN1145 (zero_sync1_4 clk_low898 storage1144 vss) n12 w=1.2u l=0.13u
MP1146 (zero_sync1_4 clk_lowb899 storage1144 vdd) p12 w=3.6u l=0.13u
MN1147 (qm1141 clk_high900 storage1144 vss) n12 w=1.2u l=0.13u
MP1148 (qm1141 clk_highb901 storage1144 vdd) p12 w=3.6u l=0.13u
MN1149 (qmb1142 storage1144 vss vss) n12 w=0.5u l=0.13u
MP1150 (qmb1142 storage1144 vdd vdd) p12 w=1.5u l=0.13u
MN1151 (qm1141 qmb1142 vss vss) n12 w=0.5u l=0.13u
MP1152 (qm1141 qmb1142 vdd vdd) p12 w=1.5u l=0.13u
MN1153 (storage1144 rst vss vss) n12 w=2u l=0.13u
MN1155 (qm1141 clk_high900 storage1154 vss) n12 w=1.2u l=0.13u
MP1156 (qm1141 clk_highb901 storage1154 vdd) p12 w=3.6u l=0.13u
MN1157 (zero_sync2_4 clk_low898 storage1154 vss) n12 w=1.2u l=0.13u
MP1158 (zero_sync2_4 clk_lowb899 storage1154 vdd) p12 w=3.6u l=0.13u
MN1159 (qb1143 storage1154 vss vss) n12 w=0.5u l=0.13u
MP1160 (qb1143 storage1154 vdd vdd) p12 w=1.5u l=0.13u
MN1161 (zero_sync2_4 qb1143 vss vss) n12 w=0.5u l=0.13u
MP1162 (zero_sync2_4 qb1143 vdd vdd) p12 w=1.5u l=0.13u
MN1163 (storage1154 rst vss vss) n12 w=2u l=0.13u
MN1168 (zero_g5 clk_low898 storage1167 vss) n12 w=1.2u l=0.13u
MP1169 (zero_g5 clk_lowb899 storage1167 vdd) p12 w=3.6u l=0.13u
MN1170 (qm1164 clk_high900 storage1167 vss) n12 w=1.2u l=0.13u
MP1171 (qm1164 clk_highb901 storage1167 vdd) p12 w=3.6u l=0.13u
MN1172 (qmb1165 storage1167 vss vss) n12 w=0.5u l=0.13u
MP1173 (qmb1165 storage1167 vdd vdd) p12 w=1.5u l=0.13u
MN1174 (qm1164 qmb1165 vss vss) n12 w=0.5u l=0.13u
MP1175 (qm1164 qmb1165 vdd vdd) p12 w=1.5u l=0.13u
MN1176 (storage1167 rst vss vss) n12 w=2u l=0.13u
MN1178 (qm1164 clk_high900 storage1177 vss) n12 w=1.2u l=0.13u
MP1179 (qm1164 clk_highb901 storage1177 vdd) p12 w=3.6u l=0.13u
MN1180 (zero_sync1_5 clk_low898 storage1177 vss) n12 w=1.2u l=0.13u
MP1181 (zero_sync1_5 clk_lowb899 storage1177 vdd) p12 w=3.6u l=0.13u
MN1182 (qb1166 storage1177 vss vss) n12 w=0.5u l=0.13u
MP1183 (qb1166 storage1177 vdd vdd) p12 w=1.5u l=0.13u
MN1184 (zero_sync1_5 qb1166 vss vss) n12 w=0.5u l=0.13u
MP1185 (zero_sync1_5 qb1166 vdd vdd) p12 w=1.5u l=0.13u
MN1186 (storage1177 rst vss vss) n12 w=2u l=0.13u
MN1191 (zero_sync1_5 clk_low898 storage1190 vss) n12 w=1.2u l=0.13u
MP1192 (zero_sync1_5 clk_lowb899 storage1190 vdd) p12 w=3.6u l=0.13u
MN1193 (qm1187 clk_high900 storage1190 vss) n12 w=1.2u l=0.13u
MP1194 (qm1187 clk_highb901 storage1190 vdd) p12 w=3.6u l=0.13u
MN1195 (qmb1188 storage1190 vss vss) n12 w=0.5u l=0.13u
MP1196 (qmb1188 storage1190 vdd vdd) p12 w=1.5u l=0.13u
MN1197 (qm1187 qmb1188 vss vss) n12 w=0.5u l=0.13u
MP1198 (qm1187 qmb1188 vdd vdd) p12 w=1.5u l=0.13u
MN1199 (storage1190 rst vss vss) n12 w=2u l=0.13u
MN1201 (qm1187 clk_high900 storage1200 vss) n12 w=1.2u l=0.13u
MP1202 (qm1187 clk_highb901 storage1200 vdd) p12 w=3.6u l=0.13u
MN1203 (zero_sync2_5 clk_low898 storage1200 vss) n12 w=1.2u l=0.13u
MP1204 (zero_sync2_5 clk_lowb899 storage1200 vdd) p12 w=3.6u l=0.13u
MN1205 (qb1189 storage1200 vss vss) n12 w=0.5u l=0.13u
MP1206 (qb1189 storage1200 vdd vdd) p12 w=1.5u l=0.13u
MN1207 (zero_sync2_5 qb1189 vss vss) n12 w=0.5u l=0.13u
MP1208 (zero_sync2_5 qb1189 vdd vdd) p12 w=1.5u l=0.13u
MN1209 (storage1200 rst vss vss) n12 w=2u l=0.13u
MN1214 (zero_g6 clk_low898 storage1213 vss) n12 w=1.2u l=0.13u
MP1215 (zero_g6 clk_lowb899 storage1213 vdd) p12 w=3.6u l=0.13u
MN1216 (qm1210 clk_high900 storage1213 vss) n12 w=1.2u l=0.13u
MP1217 (qm1210 clk_highb901 storage1213 vdd) p12 w=3.6u l=0.13u
MN1218 (qmb1211 storage1213 vss vss) n12 w=0.5u l=0.13u
MP1219 (qmb1211 storage1213 vdd vdd) p12 w=1.5u l=0.13u
MN1220 (qm1210 qmb1211 vss vss) n12 w=0.5u l=0.13u
MP1221 (qm1210 qmb1211 vdd vdd) p12 w=1.5u l=0.13u
MN1222 (storage1213 rst vss vss) n12 w=2u l=0.13u
MN1224 (qm1210 clk_high900 storage1223 vss) n12 w=1.2u l=0.13u
MP1225 (qm1210 clk_highb901 storage1223 vdd) p12 w=3.6u l=0.13u
MN1226 (zero_sync1_6 clk_low898 storage1223 vss) n12 w=1.2u l=0.13u
MP1227 (zero_sync1_6 clk_lowb899 storage1223 vdd) p12 w=3.6u l=0.13u
MN1228 (qb1212 storage1223 vss vss) n12 w=0.5u l=0.13u
MP1229 (qb1212 storage1223 vdd vdd) p12 w=1.5u l=0.13u
MN1230 (zero_sync1_6 qb1212 vss vss) n12 w=0.5u l=0.13u
MP1231 (zero_sync1_6 qb1212 vdd vdd) p12 w=1.5u l=0.13u
MN1232 (storage1223 rst vss vss) n12 w=2u l=0.13u
MN1237 (zero_sync1_6 clk_low898 storage1236 vss) n12 w=1.2u l=0.13u
MP1238 (zero_sync1_6 clk_lowb899 storage1236 vdd) p12 w=3.6u l=0.13u
MN1239 (qm1233 clk_high900 storage1236 vss) n12 w=1.2u l=0.13u
MP1240 (qm1233 clk_highb901 storage1236 vdd) p12 w=3.6u l=0.13u
MN1241 (qmb1234 storage1236 vss vss) n12 w=0.5u l=0.13u
MP1242 (qmb1234 storage1236 vdd vdd) p12 w=1.5u l=0.13u
MN1243 (qm1233 qmb1234 vss vss) n12 w=0.5u l=0.13u
MP1244 (qm1233 qmb1234 vdd vdd) p12 w=1.5u l=0.13u
MN1245 (storage1236 rst vss vss) n12 w=2u l=0.13u
MN1247 (qm1233 clk_high900 storage1246 vss) n12 w=1.2u l=0.13u
MP1248 (qm1233 clk_highb901 storage1246 vdd) p12 w=3.6u l=0.13u
MN1249 (zero_sync2_6 clk_low898 storage1246 vss) n12 w=1.2u l=0.13u
MP1250 (zero_sync2_6 clk_lowb899 storage1246 vdd) p12 w=3.6u l=0.13u
MN1251 (qb1235 storage1246 vss vss) n12 w=0.5u l=0.13u
MP1252 (qb1235 storage1246 vdd vdd) p12 w=1.5u l=0.13u
MN1253 (zero_sync2_6 qb1235 vss vss) n12 w=0.5u l=0.13u
MP1254 (zero_sync2_6 qb1235 vdd vdd) p12 w=1.5u l=0.13u
MN1255 (storage1246 rst vss vss) n12 w=2u l=0.13u
MN1260 (zero_g7 clk_low898 storage1259 vss) n12 w=1.2u l=0.13u
MP1261 (zero_g7 clk_lowb899 storage1259 vdd) p12 w=3.6u l=0.13u
MN1262 (qm1256 clk_high900 storage1259 vss) n12 w=1.2u l=0.13u
MP1263 (qm1256 clk_highb901 storage1259 vdd) p12 w=3.6u l=0.13u
MN1264 (qmb1257 storage1259 vss vss) n12 w=0.5u l=0.13u
MP1265 (qmb1257 storage1259 vdd vdd) p12 w=1.5u l=0.13u
MN1266 (qm1256 qmb1257 vss vss) n12 w=0.5u l=0.13u
MP1267 (qm1256 qmb1257 vdd vdd) p12 w=1.5u l=0.13u
MN1268 (storage1259 rst vss vss) n12 w=2u l=0.13u
MN1270 (qm1256 clk_high900 storage1269 vss) n12 w=1.2u l=0.13u
MP1271 (qm1256 clk_highb901 storage1269 vdd) p12 w=3.6u l=0.13u
MN1272 (zero_sync1_7 clk_low898 storage1269 vss) n12 w=1.2u l=0.13u
MP1273 (zero_sync1_7 clk_lowb899 storage1269 vdd) p12 w=3.6u l=0.13u
MN1274 (qb1258 storage1269 vss vss) n12 w=0.5u l=0.13u
MP1275 (qb1258 storage1269 vdd vdd) p12 w=1.5u l=0.13u
MN1276 (zero_sync1_7 qb1258 vss vss) n12 w=0.5u l=0.13u
MP1277 (zero_sync1_7 qb1258 vdd vdd) p12 w=1.5u l=0.13u
MN1278 (storage1269 rst vss vss) n12 w=2u l=0.13u
MN1283 (zero_sync1_7 clk_low898 storage1282 vss) n12 w=1.2u l=0.13u
MP1284 (zero_sync1_7 clk_lowb899 storage1282 vdd) p12 w=3.6u l=0.13u
MN1285 (qm1279 clk_high900 storage1282 vss) n12 w=1.2u l=0.13u
MP1286 (qm1279 clk_highb901 storage1282 vdd) p12 w=3.6u l=0.13u
MN1287 (qmb1280 storage1282 vss vss) n12 w=0.5u l=0.13u
MP1288 (qmb1280 storage1282 vdd vdd) p12 w=1.5u l=0.13u
MN1289 (qm1279 qmb1280 vss vss) n12 w=0.5u l=0.13u
MP1290 (qm1279 qmb1280 vdd vdd) p12 w=1.5u l=0.13u
MN1291 (storage1282 rst vss vss) n12 w=2u l=0.13u
MN1293 (qm1279 clk_high900 storage1292 vss) n12 w=1.2u l=0.13u
MP1294 (qm1279 clk_highb901 storage1292 vdd) p12 w=3.6u l=0.13u
MN1295 (zero_sync2_7 clk_low898 storage1292 vss) n12 w=1.2u l=0.13u
MP1296 (zero_sync2_7 clk_lowb899 storage1292 vdd) p12 w=3.6u l=0.13u
MN1297 (qb1281 storage1292 vss vss) n12 w=0.5u l=0.13u
MP1298 (qb1281 storage1292 vdd vdd) p12 w=1.5u l=0.13u
MN1299 (zero_sync2_7 qb1281 vss vss) n12 w=0.5u l=0.13u
MP1300 (zero_sync2_7 qb1281 vdd vdd) p12 w=1.5u l=0.13u
MN1301 (storage1292 rst vss vss) n12 w=2u l=0.13u
MN1306 (zero_g8 clk_low898 storage1305 vss) n12 w=1.2u l=0.13u
MP1307 (zero_g8 clk_lowb899 storage1305 vdd) p12 w=3.6u l=0.13u
MN1308 (qm1302 clk_high900 storage1305 vss) n12 w=1.2u l=0.13u
MP1309 (qm1302 clk_highb901 storage1305 vdd) p12 w=3.6u l=0.13u
MN1310 (qmb1303 storage1305 vss vss) n12 w=0.5u l=0.13u
MP1311 (qmb1303 storage1305 vdd vdd) p12 w=1.5u l=0.13u
MN1312 (qm1302 qmb1303 vss vss) n12 w=0.5u l=0.13u
MP1313 (qm1302 qmb1303 vdd vdd) p12 w=1.5u l=0.13u
MN1314 (storage1305 rst vss vss) n12 w=2u l=0.13u
MN1316 (qm1302 clk_high900 storage1315 vss) n12 w=1.2u l=0.13u
MP1317 (qm1302 clk_highb901 storage1315 vdd) p12 w=3.6u l=0.13u
MN1318 (zero_sync1_8 clk_low898 storage1315 vss) n12 w=1.2u l=0.13u
MP1319 (zero_sync1_8 clk_lowb899 storage1315 vdd) p12 w=3.6u l=0.13u
MN1320 (qb1304 storage1315 vss vss) n12 w=0.5u l=0.13u
MP1321 (qb1304 storage1315 vdd vdd) p12 w=1.5u l=0.13u
MN1322 (zero_sync1_8 qb1304 vss vss) n12 w=0.5u l=0.13u
MP1323 (zero_sync1_8 qb1304 vdd vdd) p12 w=1.5u l=0.13u
MN1324 (storage1315 rst vss vss) n12 w=2u l=0.13u
MN1329 (zero_sync1_8 clk_low898 storage1328 vss) n12 w=1.2u l=0.13u
MP1330 (zero_sync1_8 clk_lowb899 storage1328 vdd) p12 w=3.6u l=0.13u
MN1331 (qm1325 clk_high900 storage1328 vss) n12 w=1.2u l=0.13u
MP1332 (qm1325 clk_highb901 storage1328 vdd) p12 w=3.6u l=0.13u
MN1333 (qmb1326 storage1328 vss vss) n12 w=0.5u l=0.13u
MP1334 (qmb1326 storage1328 vdd vdd) p12 w=1.5u l=0.13u
MN1335 (qm1325 qmb1326 vss vss) n12 w=0.5u l=0.13u
MP1336 (qm1325 qmb1326 vdd vdd) p12 w=1.5u l=0.13u
MN1337 (storage1328 rst vss vss) n12 w=2u l=0.13u
MN1339 (qm1325 clk_high900 storage1338 vss) n12 w=1.2u l=0.13u
MP1340 (qm1325 clk_highb901 storage1338 vdd) p12 w=3.6u l=0.13u
MN1341 (zero_sync2_8 clk_low898 storage1338 vss) n12 w=1.2u l=0.13u
MP1342 (zero_sync2_8 clk_lowb899 storage1338 vdd) p12 w=3.6u l=0.13u
MN1343 (qb1327 storage1338 vss vss) n12 w=0.5u l=0.13u
MP1344 (qb1327 storage1338 vdd vdd) p12 w=1.5u l=0.13u
MN1345 (zero_sync2_8 qb1327 vss vss) n12 w=0.5u l=0.13u
MP1346 (zero_sync2_8 qb1327 vdd vdd) p12 w=1.5u l=0.13u
MN1347 (storage1338 rst vss vss) n12 w=2u l=0.13u
MN1349 (n1348 n193 vss vss) n12 w=0.8u l=0.13u
MP1350 (n1348 n193 vdd vdd) p12 w=2.4u l=0.13u
MN1352 (n1351 n1348 vss vss) n12 w=0.8u l=0.13u
MP1353 (n1351 n1348 vdd vdd) p12 w=2.4u l=0.13u
MN1354 (zero_native_b0 n1351 vss vss) n12 w=0.8u l=0.13u
MP1355 (zero_native_b0 n1351 vdd vdd) p12 w=2.4u l=0.13u
MN1357 (n1356 n163 vss vss) n12 w=0.8u l=0.13u
MP1358 (n1356 n163 vdd vdd) p12 w=2.4u l=0.13u
MN1360 (n1359 n1356 vss vss) n12 w=0.8u l=0.13u
MP1361 (n1359 n1356 vdd vdd) p12 w=2.4u l=0.13u
MN1363 (n1362 n1359 vss vss) n12 w=0.8u l=0.13u
MP1364 (n1362 n1359 vdd vdd) p12 w=2.4u l=0.13u
MN1365 (zero_native_b1 n1362 vss vss) n12 w=0.8u l=0.13u
MP1366 (zero_native_b1 n1362 vdd vdd) p12 w=2.4u l=0.13u
MN1368 (n1367 n139 vss vss) n12 w=0.8u l=0.13u
MP1369 (n1367 n139 vdd vdd) p12 w=2.4u l=0.13u
MN1371 (n1370 n1367 vss vss) n12 w=0.8u l=0.13u
MP1372 (n1370 n1367 vdd vdd) p12 w=2.4u l=0.13u
MN1374 (n1373 n1370 vss vss) n12 w=0.8u l=0.13u
MP1375 (n1373 n1370 vdd vdd) p12 w=2.4u l=0.13u
MN1376 (zero_native_b2 n1373 vss vss) n12 w=0.8u l=0.13u
MP1377 (zero_native_b2 n1373 vdd vdd) p12 w=2.4u l=0.13u
MN1379 (n1378 n115 vss vss) n12 w=0.8u l=0.13u
MP1380 (n1378 n115 vdd vdd) p12 w=2.4u l=0.13u
MN1382 (n1381 n1378 vss vss) n12 w=0.8u l=0.13u
MP1383 (n1381 n1378 vdd vdd) p12 w=2.4u l=0.13u
MN1385 (n1384 n1381 vss vss) n12 w=0.8u l=0.13u
MP1386 (n1384 n1381 vdd vdd) p12 w=2.4u l=0.13u
MN1387 (zero_native_b3 n1384 vss vss) n12 w=0.8u l=0.13u
MP1388 (zero_native_b3 n1384 vdd vdd) p12 w=2.4u l=0.13u
MN1390 (n1389 n91 vss vss) n12 w=0.8u l=0.13u
MP1391 (n1389 n91 vdd vdd) p12 w=2.4u l=0.13u
MN1393 (n1392 n1389 vss vss) n12 w=0.8u l=0.13u
MP1394 (n1392 n1389 vdd vdd) p12 w=2.4u l=0.13u
MN1396 (n1395 n1392 vss vss) n12 w=0.8u l=0.13u
MP1397 (n1395 n1392 vdd vdd) p12 w=2.4u l=0.13u
MN1398 (zero_native_b4 n1395 vss vss) n12 w=0.8u l=0.13u
MP1399 (zero_native_b4 n1395 vdd vdd) p12 w=2.4u l=0.13u
MN1401 (n1400 n67 vss vss) n12 w=0.8u l=0.13u
MP1402 (n1400 n67 vdd vdd) p12 w=2.4u l=0.13u
MN1404 (n1403 n1400 vss vss) n12 w=0.8u l=0.13u
MP1405 (n1403 n1400 vdd vdd) p12 w=2.4u l=0.13u
MN1407 (n1406 n1403 vss vss) n12 w=0.8u l=0.13u
MP1408 (n1406 n1403 vdd vdd) p12 w=2.4u l=0.13u
MN1409 (zero_native_b5 n1406 vss vss) n12 w=0.8u l=0.13u
MP1410 (zero_native_b5 n1406 vdd vdd) p12 w=2.4u l=0.13u
MN1412 (n1411 n43 vss vss) n12 w=0.8u l=0.13u
MP1413 (n1411 n43 vdd vdd) p12 w=2.4u l=0.13u
MN1415 (n1414 n1411 vss vss) n12 w=0.8u l=0.13u
MP1416 (n1414 n1411 vdd vdd) p12 w=2.4u l=0.13u
MN1418 (n1417 n1414 vss vss) n12 w=0.8u l=0.13u
MP1419 (n1417 n1414 vdd vdd) p12 w=2.4u l=0.13u
MN1420 (zero_native_b6 n1417 vss vss) n12 w=0.8u l=0.13u
MP1421 (zero_native_b6 n1417 vdd vdd) p12 w=2.4u l=0.13u
MN1423 (n1422 n19 vss vss) n12 w=0.8u l=0.13u
MP1424 (n1422 n19 vdd vdd) p12 w=2.4u l=0.13u
MN1426 (n1425 n1422 vss vss) n12 w=0.8u l=0.13u
MP1427 (n1425 n1422 vdd vdd) p12 w=2.4u l=0.13u
MN1429 (n1428 n1425 vss vss) n12 w=0.8u l=0.13u
MP1430 (n1428 n1425 vdd vdd) p12 w=2.4u l=0.13u
MN1431 (zero_native_b7 n1428 vss vss) n12 w=0.8u l=0.13u
MP1432 (zero_native_b7 n1428 vdd vdd) p12 w=2.4u l=0.13u
MN1434 (n1433 zero_g8 vss vss) n12 w=0.8u l=0.13u
MP1435 (n1433 zero_g8 vdd vdd) p12 w=2.4u l=0.13u
MN1437 (n1436 n1433 vss vss) n12 w=0.8u l=0.13u
MP1438 (n1436 n1433 vdd vdd) p12 w=2.4u l=0.13u
MN1440 (n1439 n1436 vss vss) n12 w=0.8u l=0.13u
MP1441 (n1439 n1436 vdd vdd) p12 w=2.4u l=0.13u
MN1442 (zero_native_b8 n1439 vss vss) n12 w=0.8u l=0.13u
MP1443 (zero_native_b8 n1439 vdd vdd) p12 w=2.4u l=0.13u
MN1446 (n1444 zero_sync2_7 n1445 vss) n12 w=1.6u l=0.13u
MN1447 (n1445 zero_sync2_8 vss vss) n12 w=1.6u l=0.13u
MP1448 (n1444 zero_sync2_7 vdd vdd) p12 w=2.4u l=0.13u
MP1449 (n1444 zero_sync2_8 vdd vdd) p12 w=2.4u l=0.13u
MN1452 (n1450 n1444 n1451 vss) n12 w=1.6u l=0.13u
MN1453 (n1451 zero_sync2_7 vss vss) n12 w=1.6u l=0.13u
MP1454 (n1450 n1444 vdd vdd) p12 w=2.4u l=0.13u
MP1455 (n1450 zero_sync2_7 vdd vdd) p12 w=2.4u l=0.13u
MN1458 (n1456 n1444 n1457 vss) n12 w=1.6u l=0.13u
MN1459 (n1457 zero_sync2_8 vss vss) n12 w=1.6u l=0.13u
MP1460 (n1456 n1444 vdd vdd) p12 w=2.4u l=0.13u
MP1461 (n1456 zero_sync2_8 vdd vdd) p12 w=2.4u l=0.13u
MN1464 (n1462 n1450 n1463 vss) n12 w=1.6u l=0.13u
MN1465 (n1463 n1456 vss vss) n12 w=1.6u l=0.13u
MP1466 (n1462 n1450 vdd vdd) p12 w=2.4u l=0.13u
MP1467 (n1462 n1456 vdd vdd) p12 w=2.4u l=0.13u
MN1470 (n1468 n1462 n1469 vss) n12 w=1.6u l=0.13u
MN1471 (n1469 zero_sync2_6 vss vss) n12 w=1.6u l=0.13u
MP1472 (n1468 n1462 vdd vdd) p12 w=2.4u l=0.13u
MP1473 (n1468 zero_sync2_6 vdd vdd) p12 w=2.4u l=0.13u
MN1476 (n1474 n1462 n1475 vss) n12 w=1.6u l=0.13u
MN1477 (n1475 n1468 vss vss) n12 w=1.6u l=0.13u
MP1478 (n1474 n1462 vdd vdd) p12 w=2.4u l=0.13u
MP1479 (n1474 n1468 vdd vdd) p12 w=2.4u l=0.13u
MN1482 (n1480 n1468 n1481 vss) n12 w=1.6u l=0.13u
MN1483 (n1481 zero_sync2_6 vss vss) n12 w=1.6u l=0.13u
MP1484 (n1480 n1468 vdd vdd) p12 w=2.4u l=0.13u
MP1485 (n1480 zero_sync2_6 vdd vdd) p12 w=2.4u l=0.13u
MN1488 (n1486 n1474 n1487 vss) n12 w=1.6u l=0.13u
MN1489 (n1487 n1480 vss vss) n12 w=1.6u l=0.13u
MP1490 (n1486 n1474 vdd vdd) p12 w=2.4u l=0.13u
MP1491 (n1486 n1480 vdd vdd) p12 w=2.4u l=0.13u
MN1494 (n1492 n1486 n1493 vss) n12 w=1.6u l=0.13u
MN1495 (n1493 zero_sync2_5 vss vss) n12 w=1.6u l=0.13u
MP1496 (n1492 n1486 vdd vdd) p12 w=2.4u l=0.13u
MP1497 (n1492 zero_sync2_5 vdd vdd) p12 w=2.4u l=0.13u
MN1500 (n1498 n1486 n1499 vss) n12 w=1.6u l=0.13u
MN1501 (n1499 n1492 vss vss) n12 w=1.6u l=0.13u
MP1502 (n1498 n1486 vdd vdd) p12 w=2.4u l=0.13u
MP1503 (n1498 n1492 vdd vdd) p12 w=2.4u l=0.13u
MN1506 (n1504 n1492 n1505 vss) n12 w=1.6u l=0.13u
MN1507 (n1505 zero_sync2_5 vss vss) n12 w=1.6u l=0.13u
MP1508 (n1504 n1492 vdd vdd) p12 w=2.4u l=0.13u
MP1509 (n1504 zero_sync2_5 vdd vdd) p12 w=2.4u l=0.13u
MN1512 (n1510 n1498 n1511 vss) n12 w=1.6u l=0.13u
MN1513 (n1511 n1504 vss vss) n12 w=1.6u l=0.13u
MP1514 (n1510 n1498 vdd vdd) p12 w=2.4u l=0.13u
MP1515 (n1510 n1504 vdd vdd) p12 w=2.4u l=0.13u
MN1518 (n1516 n1510 n1517 vss) n12 w=1.6u l=0.13u
MN1519 (n1517 zero_sync2_4 vss vss) n12 w=1.6u l=0.13u
MP1520 (n1516 n1510 vdd vdd) p12 w=2.4u l=0.13u
MP1521 (n1516 zero_sync2_4 vdd vdd) p12 w=2.4u l=0.13u
MN1524 (n1522 n1510 n1523 vss) n12 w=1.6u l=0.13u
MN1525 (n1523 n1516 vss vss) n12 w=1.6u l=0.13u
MP1526 (n1522 n1510 vdd vdd) p12 w=2.4u l=0.13u
MP1527 (n1522 n1516 vdd vdd) p12 w=2.4u l=0.13u
MN1530 (n1528 n1516 n1529 vss) n12 w=1.6u l=0.13u
MN1531 (n1529 zero_sync2_4 vss vss) n12 w=1.6u l=0.13u
MP1532 (n1528 n1516 vdd vdd) p12 w=2.4u l=0.13u
MP1533 (n1528 zero_sync2_4 vdd vdd) p12 w=2.4u l=0.13u
MN1536 (n1534 n1522 n1535 vss) n12 w=1.6u l=0.13u
MN1537 (n1535 n1528 vss vss) n12 w=1.6u l=0.13u
MP1538 (n1534 n1522 vdd vdd) p12 w=2.4u l=0.13u
MP1539 (n1534 n1528 vdd vdd) p12 w=2.4u l=0.13u
MN1542 (n1540 n1534 n1541 vss) n12 w=1.6u l=0.13u
MN1543 (n1541 zero_sync2_3 vss vss) n12 w=1.6u l=0.13u
MP1544 (n1540 n1534 vdd vdd) p12 w=2.4u l=0.13u
MP1545 (n1540 zero_sync2_3 vdd vdd) p12 w=2.4u l=0.13u
MN1548 (n1546 n1534 n1547 vss) n12 w=1.6u l=0.13u
MN1549 (n1547 n1540 vss vss) n12 w=1.6u l=0.13u
MP1550 (n1546 n1534 vdd vdd) p12 w=2.4u l=0.13u
MP1551 (n1546 n1540 vdd vdd) p12 w=2.4u l=0.13u
MN1554 (n1552 n1540 n1553 vss) n12 w=1.6u l=0.13u
MN1555 (n1553 zero_sync2_3 vss vss) n12 w=1.6u l=0.13u
MP1556 (n1552 n1540 vdd vdd) p12 w=2.4u l=0.13u
MP1557 (n1552 zero_sync2_3 vdd vdd) p12 w=2.4u l=0.13u
MN1560 (n1558 n1546 n1559 vss) n12 w=1.6u l=0.13u
MN1561 (n1559 n1552 vss vss) n12 w=1.6u l=0.13u
MP1562 (n1558 n1546 vdd vdd) p12 w=2.4u l=0.13u
MP1563 (n1558 n1552 vdd vdd) p12 w=2.4u l=0.13u
MN1566 (n1564 n1558 n1565 vss) n12 w=1.6u l=0.13u
MN1567 (n1565 zero_sync2_2 vss vss) n12 w=1.6u l=0.13u
MP1568 (n1564 n1558 vdd vdd) p12 w=2.4u l=0.13u
MP1569 (n1564 zero_sync2_2 vdd vdd) p12 w=2.4u l=0.13u
MN1572 (n1570 n1558 n1571 vss) n12 w=1.6u l=0.13u
MN1573 (n1571 n1564 vss vss) n12 w=1.6u l=0.13u
MP1574 (n1570 n1558 vdd vdd) p12 w=2.4u l=0.13u
MP1575 (n1570 n1564 vdd vdd) p12 w=2.4u l=0.13u
MN1578 (n1576 n1564 n1577 vss) n12 w=1.6u l=0.13u
MN1579 (n1577 zero_sync2_2 vss vss) n12 w=1.6u l=0.13u
MP1580 (n1576 n1564 vdd vdd) p12 w=2.4u l=0.13u
MP1581 (n1576 zero_sync2_2 vdd vdd) p12 w=2.4u l=0.13u
MN1584 (n1582 n1570 n1583 vss) n12 w=1.6u l=0.13u
MN1585 (n1583 n1576 vss vss) n12 w=1.6u l=0.13u
MP1586 (n1582 n1570 vdd vdd) p12 w=2.4u l=0.13u
MP1587 (n1582 n1576 vdd vdd) p12 w=2.4u l=0.13u
MN1590 (n1588 n1582 n1589 vss) n12 w=1.6u l=0.13u
MN1591 (n1589 zero_sync2_1 vss vss) n12 w=1.6u l=0.13u
MP1592 (n1588 n1582 vdd vdd) p12 w=2.4u l=0.13u
MP1593 (n1588 zero_sync2_1 vdd vdd) p12 w=2.4u l=0.13u
MN1596 (n1594 n1582 n1595 vss) n12 w=1.6u l=0.13u
MN1597 (n1595 n1588 vss vss) n12 w=1.6u l=0.13u
MP1598 (n1594 n1582 vdd vdd) p12 w=2.4u l=0.13u
MP1599 (n1594 n1588 vdd vdd) p12 w=2.4u l=0.13u
MN1602 (n1600 n1588 n1601 vss) n12 w=1.6u l=0.13u
MN1603 (n1601 zero_sync2_1 vss vss) n12 w=1.6u l=0.13u
MP1604 (n1600 n1588 vdd vdd) p12 w=2.4u l=0.13u
MP1605 (n1600 zero_sync2_1 vdd vdd) p12 w=2.4u l=0.13u
MN1608 (n1606 n1594 n1607 vss) n12 w=1.6u l=0.13u
MN1609 (n1607 n1600 vss vss) n12 w=1.6u l=0.13u
MP1610 (n1606 n1594 vdd vdd) p12 w=2.4u l=0.13u
MP1611 (n1606 n1600 vdd vdd) p12 w=2.4u l=0.13u
MN1614 (n1612 n1606 n1613 vss) n12 w=1.6u l=0.13u
MN1615 (n1613 zero_sync2_0 vss vss) n12 w=1.6u l=0.13u
MP1616 (n1612 n1606 vdd vdd) p12 w=2.4u l=0.13u
MP1617 (n1612 zero_sync2_0 vdd vdd) p12 w=2.4u l=0.13u
MN1620 (n1618 n1606 n1619 vss) n12 w=1.6u l=0.13u
MN1621 (n1619 n1612 vss vss) n12 w=1.6u l=0.13u
MP1622 (n1618 n1606 vdd vdd) p12 w=2.4u l=0.13u
MP1623 (n1618 n1612 vdd vdd) p12 w=2.4u l=0.13u
MN1626 (n1624 n1612 n1625 vss) n12 w=1.6u l=0.13u
MN1627 (n1625 zero_sync2_0 vss vss) n12 w=1.6u l=0.13u
MP1628 (n1624 n1612 vdd vdd) p12 w=2.4u l=0.13u
MP1629 (n1624 zero_sync2_0 vdd vdd) p12 w=2.4u l=0.13u
MN1632 (n1630 n1618 n1631 vss) n12 w=1.6u l=0.13u
MN1633 (n1631 n1624 vss vss) n12 w=1.6u l=0.13u
MP1634 (n1630 n1618 vdd vdd) p12 w=2.4u l=0.13u
MP1635 (n1630 n1624 vdd vdd) p12 w=2.4u l=0.13u
MN1637 (n1636 n1630 vss vss) n12 w=0.8u l=0.13u
MP1638 (n1636 n1630 vdd vdd) p12 w=2.4u l=0.13u
MN1640 (n1639 n1636 vss vss) n12 w=0.8u l=0.13u
MP1641 (n1639 n1636 vdd vdd) p12 w=2.4u l=0.13u
MN1643 (n1642 n1639 vss vss) n12 w=0.8u l=0.13u
MP1644 (n1642 n1639 vdd vdd) p12 w=2.4u l=0.13u
MN1645 (zero_sync_b0 n1642 vss vss) n12 w=0.8u l=0.13u
MP1646 (zero_sync_b0 n1642 vdd vdd) p12 w=2.4u l=0.13u
MN1648 (n1647 n1606 vss vss) n12 w=0.8u l=0.13u
MP1649 (n1647 n1606 vdd vdd) p12 w=2.4u l=0.13u
MN1651 (n1650 n1647 vss vss) n12 w=0.8u l=0.13u
MP1652 (n1650 n1647 vdd vdd) p12 w=2.4u l=0.13u
MN1654 (n1653 n1650 vss vss) n12 w=0.8u l=0.13u
MP1655 (n1653 n1650 vdd vdd) p12 w=2.4u l=0.13u
MN1656 (zero_sync_b1 n1653 vss vss) n12 w=0.8u l=0.13u
MP1657 (zero_sync_b1 n1653 vdd vdd) p12 w=2.4u l=0.13u
MN1659 (n1658 n1582 vss vss) n12 w=0.8u l=0.13u
MP1660 (n1658 n1582 vdd vdd) p12 w=2.4u l=0.13u
MN1662 (n1661 n1658 vss vss) n12 w=0.8u l=0.13u
MP1663 (n1661 n1658 vdd vdd) p12 w=2.4u l=0.13u
MN1665 (n1664 n1661 vss vss) n12 w=0.8u l=0.13u
MP1666 (n1664 n1661 vdd vdd) p12 w=2.4u l=0.13u
MN1667 (zero_sync_b2 n1664 vss vss) n12 w=0.8u l=0.13u
MP1668 (zero_sync_b2 n1664 vdd vdd) p12 w=2.4u l=0.13u
MN1670 (n1669 n1558 vss vss) n12 w=0.8u l=0.13u
MP1671 (n1669 n1558 vdd vdd) p12 w=2.4u l=0.13u
MN1673 (n1672 n1669 vss vss) n12 w=0.8u l=0.13u
MP1674 (n1672 n1669 vdd vdd) p12 w=2.4u l=0.13u
MN1676 (n1675 n1672 vss vss) n12 w=0.8u l=0.13u
MP1677 (n1675 n1672 vdd vdd) p12 w=2.4u l=0.13u
MN1678 (zero_sync_b3 n1675 vss vss) n12 w=0.8u l=0.13u
MP1679 (zero_sync_b3 n1675 vdd vdd) p12 w=2.4u l=0.13u
MN1681 (n1680 n1534 vss vss) n12 w=0.8u l=0.13u
MP1682 (n1680 n1534 vdd vdd) p12 w=2.4u l=0.13u
MN1684 (n1683 n1680 vss vss) n12 w=0.8u l=0.13u
MP1685 (n1683 n1680 vdd vdd) p12 w=2.4u l=0.13u
MN1687 (n1686 n1683 vss vss) n12 w=0.8u l=0.13u
MP1688 (n1686 n1683 vdd vdd) p12 w=2.4u l=0.13u
MN1689 (zero_sync_b4 n1686 vss vss) n12 w=0.8u l=0.13u
MP1690 (zero_sync_b4 n1686 vdd vdd) p12 w=2.4u l=0.13u
MN1692 (n1691 n1510 vss vss) n12 w=0.8u l=0.13u
MP1693 (n1691 n1510 vdd vdd) p12 w=2.4u l=0.13u
MN1695 (n1694 n1691 vss vss) n12 w=0.8u l=0.13u
MP1696 (n1694 n1691 vdd vdd) p12 w=2.4u l=0.13u
MN1698 (n1697 n1694 vss vss) n12 w=0.8u l=0.13u
MP1699 (n1697 n1694 vdd vdd) p12 w=2.4u l=0.13u
MN1700 (zero_sync_b5 n1697 vss vss) n12 w=0.8u l=0.13u
MP1701 (zero_sync_b5 n1697 vdd vdd) p12 w=2.4u l=0.13u
MN1703 (n1702 n1486 vss vss) n12 w=0.8u l=0.13u
MP1704 (n1702 n1486 vdd vdd) p12 w=2.4u l=0.13u
MN1706 (n1705 n1702 vss vss) n12 w=0.8u l=0.13u
MP1707 (n1705 n1702 vdd vdd) p12 w=2.4u l=0.13u
MN1709 (n1708 n1705 vss vss) n12 w=0.8u l=0.13u
MP1710 (n1708 n1705 vdd vdd) p12 w=2.4u l=0.13u
MN1711 (zero_sync_b6 n1708 vss vss) n12 w=0.8u l=0.13u
MP1712 (zero_sync_b6 n1708 vdd vdd) p12 w=2.4u l=0.13u
MN1714 (n1713 n1462 vss vss) n12 w=0.8u l=0.13u
MP1715 (n1713 n1462 vdd vdd) p12 w=2.4u l=0.13u
MN1717 (n1716 n1713 vss vss) n12 w=0.8u l=0.13u
MP1718 (n1716 n1713 vdd vdd) p12 w=2.4u l=0.13u
MN1720 (n1719 n1716 vss vss) n12 w=0.8u l=0.13u
MP1721 (n1719 n1716 vdd vdd) p12 w=2.4u l=0.13u
MN1722 (zero_sync_b7 n1719 vss vss) n12 w=0.8u l=0.13u
MP1723 (zero_sync_b7 n1719 vdd vdd) p12 w=2.4u l=0.13u
MN1725 (n1724 zero_sync2_8 vss vss) n12 w=0.8u l=0.13u
MP1726 (n1724 zero_sync2_8 vdd vdd) p12 w=2.4u l=0.13u
MN1728 (n1727 n1724 vss vss) n12 w=0.8u l=0.13u
MP1729 (n1727 n1724 vdd vdd) p12 w=2.4u l=0.13u
MN1731 (n1730 n1727 vss vss) n12 w=0.8u l=0.13u
MP1732 (n1730 n1727 vdd vdd) p12 w=2.4u l=0.13u
MN1733 (zero_sync_b8 n1730 vss vss) n12 w=0.8u l=0.13u
MP1734 (zero_sync_b8 n1730 vdd vdd) p12 w=2.4u l=0.13u
MN1737 (n1735 one_g7 n1736 vss) n12 w=1.6u l=0.13u
MN1738 (n1736 one_g8 vss vss) n12 w=1.6u l=0.13u
MP1739 (n1735 one_g7 vdd vdd) p12 w=2.4u l=0.13u
MP1740 (n1735 one_g8 vdd vdd) p12 w=2.4u l=0.13u
MN1743 (n1741 n1735 n1742 vss) n12 w=1.6u l=0.13u
MN1744 (n1742 one_g7 vss vss) n12 w=1.6u l=0.13u
MP1745 (n1741 n1735 vdd vdd) p12 w=2.4u l=0.13u
MP1746 (n1741 one_g7 vdd vdd) p12 w=2.4u l=0.13u
MN1749 (n1747 n1735 n1748 vss) n12 w=1.6u l=0.13u
MN1750 (n1748 one_g8 vss vss) n12 w=1.6u l=0.13u
MP1751 (n1747 n1735 vdd vdd) p12 w=2.4u l=0.13u
MP1752 (n1747 one_g8 vdd vdd) p12 w=2.4u l=0.13u
MN1755 (n1753 n1741 n1754 vss) n12 w=1.6u l=0.13u
MN1756 (n1754 n1747 vss vss) n12 w=1.6u l=0.13u
MP1757 (n1753 n1741 vdd vdd) p12 w=2.4u l=0.13u
MP1758 (n1753 n1747 vdd vdd) p12 w=2.4u l=0.13u
MN1761 (n1759 n1753 n1760 vss) n12 w=1.6u l=0.13u
MN1762 (n1760 one_g6 vss vss) n12 w=1.6u l=0.13u
MP1763 (n1759 n1753 vdd vdd) p12 w=2.4u l=0.13u
MP1764 (n1759 one_g6 vdd vdd) p12 w=2.4u l=0.13u
MN1767 (n1765 n1753 n1766 vss) n12 w=1.6u l=0.13u
MN1768 (n1766 n1759 vss vss) n12 w=1.6u l=0.13u
MP1769 (n1765 n1753 vdd vdd) p12 w=2.4u l=0.13u
MP1770 (n1765 n1759 vdd vdd) p12 w=2.4u l=0.13u
MN1773 (n1771 n1759 n1772 vss) n12 w=1.6u l=0.13u
MN1774 (n1772 one_g6 vss vss) n12 w=1.6u l=0.13u
MP1775 (n1771 n1759 vdd vdd) p12 w=2.4u l=0.13u
MP1776 (n1771 one_g6 vdd vdd) p12 w=2.4u l=0.13u
MN1779 (n1777 n1765 n1778 vss) n12 w=1.6u l=0.13u
MN1780 (n1778 n1771 vss vss) n12 w=1.6u l=0.13u
MP1781 (n1777 n1765 vdd vdd) p12 w=2.4u l=0.13u
MP1782 (n1777 n1771 vdd vdd) p12 w=2.4u l=0.13u
MN1785 (n1783 n1777 n1784 vss) n12 w=1.6u l=0.13u
MN1786 (n1784 one_g5 vss vss) n12 w=1.6u l=0.13u
MP1787 (n1783 n1777 vdd vdd) p12 w=2.4u l=0.13u
MP1788 (n1783 one_g5 vdd vdd) p12 w=2.4u l=0.13u
MN1791 (n1789 n1777 n1790 vss) n12 w=1.6u l=0.13u
MN1792 (n1790 n1783 vss vss) n12 w=1.6u l=0.13u
MP1793 (n1789 n1777 vdd vdd) p12 w=2.4u l=0.13u
MP1794 (n1789 n1783 vdd vdd) p12 w=2.4u l=0.13u
MN1797 (n1795 n1783 n1796 vss) n12 w=1.6u l=0.13u
MN1798 (n1796 one_g5 vss vss) n12 w=1.6u l=0.13u
MP1799 (n1795 n1783 vdd vdd) p12 w=2.4u l=0.13u
MP1800 (n1795 one_g5 vdd vdd) p12 w=2.4u l=0.13u
MN1803 (n1801 n1789 n1802 vss) n12 w=1.6u l=0.13u
MN1804 (n1802 n1795 vss vss) n12 w=1.6u l=0.13u
MP1805 (n1801 n1789 vdd vdd) p12 w=2.4u l=0.13u
MP1806 (n1801 n1795 vdd vdd) p12 w=2.4u l=0.13u
MN1809 (n1807 n1801 n1808 vss) n12 w=1.6u l=0.13u
MN1810 (n1808 one_g4 vss vss) n12 w=1.6u l=0.13u
MP1811 (n1807 n1801 vdd vdd) p12 w=2.4u l=0.13u
MP1812 (n1807 one_g4 vdd vdd) p12 w=2.4u l=0.13u
MN1815 (n1813 n1801 n1814 vss) n12 w=1.6u l=0.13u
MN1816 (n1814 n1807 vss vss) n12 w=1.6u l=0.13u
MP1817 (n1813 n1801 vdd vdd) p12 w=2.4u l=0.13u
MP1818 (n1813 n1807 vdd vdd) p12 w=2.4u l=0.13u
MN1821 (n1819 n1807 n1820 vss) n12 w=1.6u l=0.13u
MN1822 (n1820 one_g4 vss vss) n12 w=1.6u l=0.13u
MP1823 (n1819 n1807 vdd vdd) p12 w=2.4u l=0.13u
MP1824 (n1819 one_g4 vdd vdd) p12 w=2.4u l=0.13u
MN1827 (n1825 n1813 n1826 vss) n12 w=1.6u l=0.13u
MN1828 (n1826 n1819 vss vss) n12 w=1.6u l=0.13u
MP1829 (n1825 n1813 vdd vdd) p12 w=2.4u l=0.13u
MP1830 (n1825 n1819 vdd vdd) p12 w=2.4u l=0.13u
MN1833 (n1831 n1825 n1832 vss) n12 w=1.6u l=0.13u
MN1834 (n1832 one_g3 vss vss) n12 w=1.6u l=0.13u
MP1835 (n1831 n1825 vdd vdd) p12 w=2.4u l=0.13u
MP1836 (n1831 one_g3 vdd vdd) p12 w=2.4u l=0.13u
MN1839 (n1837 n1825 n1838 vss) n12 w=1.6u l=0.13u
MN1840 (n1838 n1831 vss vss) n12 w=1.6u l=0.13u
MP1841 (n1837 n1825 vdd vdd) p12 w=2.4u l=0.13u
MP1842 (n1837 n1831 vdd vdd) p12 w=2.4u l=0.13u
MN1845 (n1843 n1831 n1844 vss) n12 w=1.6u l=0.13u
MN1846 (n1844 one_g3 vss vss) n12 w=1.6u l=0.13u
MP1847 (n1843 n1831 vdd vdd) p12 w=2.4u l=0.13u
MP1848 (n1843 one_g3 vdd vdd) p12 w=2.4u l=0.13u
MN1851 (n1849 n1837 n1850 vss) n12 w=1.6u l=0.13u
MN1852 (n1850 n1843 vss vss) n12 w=1.6u l=0.13u
MP1853 (n1849 n1837 vdd vdd) p12 w=2.4u l=0.13u
MP1854 (n1849 n1843 vdd vdd) p12 w=2.4u l=0.13u
MN1857 (n1855 n1849 n1856 vss) n12 w=1.6u l=0.13u
MN1858 (n1856 one_g2 vss vss) n12 w=1.6u l=0.13u
MP1859 (n1855 n1849 vdd vdd) p12 w=2.4u l=0.13u
MP1860 (n1855 one_g2 vdd vdd) p12 w=2.4u l=0.13u
MN1863 (n1861 n1849 n1862 vss) n12 w=1.6u l=0.13u
MN1864 (n1862 n1855 vss vss) n12 w=1.6u l=0.13u
MP1865 (n1861 n1849 vdd vdd) p12 w=2.4u l=0.13u
MP1866 (n1861 n1855 vdd vdd) p12 w=2.4u l=0.13u
MN1869 (n1867 n1855 n1868 vss) n12 w=1.6u l=0.13u
MN1870 (n1868 one_g2 vss vss) n12 w=1.6u l=0.13u
MP1871 (n1867 n1855 vdd vdd) p12 w=2.4u l=0.13u
MP1872 (n1867 one_g2 vdd vdd) p12 w=2.4u l=0.13u
MN1875 (n1873 n1861 n1874 vss) n12 w=1.6u l=0.13u
MN1876 (n1874 n1867 vss vss) n12 w=1.6u l=0.13u
MP1877 (n1873 n1861 vdd vdd) p12 w=2.4u l=0.13u
MP1878 (n1873 n1867 vdd vdd) p12 w=2.4u l=0.13u
MN1881 (n1879 n1873 n1880 vss) n12 w=1.6u l=0.13u
MN1882 (n1880 one_g1 vss vss) n12 w=1.6u l=0.13u
MP1883 (n1879 n1873 vdd vdd) p12 w=2.4u l=0.13u
MP1884 (n1879 one_g1 vdd vdd) p12 w=2.4u l=0.13u
MN1887 (n1885 n1873 n1886 vss) n12 w=1.6u l=0.13u
MN1888 (n1886 n1879 vss vss) n12 w=1.6u l=0.13u
MP1889 (n1885 n1873 vdd vdd) p12 w=2.4u l=0.13u
MP1890 (n1885 n1879 vdd vdd) p12 w=2.4u l=0.13u
MN1893 (n1891 n1879 n1892 vss) n12 w=1.6u l=0.13u
MN1894 (n1892 one_g1 vss vss) n12 w=1.6u l=0.13u
MP1895 (n1891 n1879 vdd vdd) p12 w=2.4u l=0.13u
MP1896 (n1891 one_g1 vdd vdd) p12 w=2.4u l=0.13u
MN1899 (n1897 n1885 n1898 vss) n12 w=1.6u l=0.13u
MN1900 (n1898 n1891 vss vss) n12 w=1.6u l=0.13u
MP1901 (n1897 n1885 vdd vdd) p12 w=2.4u l=0.13u
MP1902 (n1897 n1891 vdd vdd) p12 w=2.4u l=0.13u
MN1905 (n1903 n1897 n1904 vss) n12 w=1.6u l=0.13u
MN1906 (n1904 one_g0 vss vss) n12 w=1.6u l=0.13u
MP1907 (n1903 n1897 vdd vdd) p12 w=2.4u l=0.13u
MP1908 (n1903 one_g0 vdd vdd) p12 w=2.4u l=0.13u
MN1911 (n1909 n1897 n1910 vss) n12 w=1.6u l=0.13u
MN1912 (n1910 n1903 vss vss) n12 w=1.6u l=0.13u
MP1913 (n1909 n1897 vdd vdd) p12 w=2.4u l=0.13u
MP1914 (n1909 n1903 vdd vdd) p12 w=2.4u l=0.13u
MN1917 (n1915 n1903 n1916 vss) n12 w=1.6u l=0.13u
MN1918 (n1916 one_g0 vss vss) n12 w=1.6u l=0.13u
MP1919 (n1915 n1903 vdd vdd) p12 w=2.4u l=0.13u
MP1920 (n1915 one_g0 vdd vdd) p12 w=2.4u l=0.13u
MN1923 (n1921 n1909 n1922 vss) n12 w=1.6u l=0.13u
MN1924 (n1922 n1915 vss vss) n12 w=1.6u l=0.13u
MP1925 (n1921 n1909 vdd vdd) p12 w=2.4u l=0.13u
MP1926 (n1921 n1915 vdd vdd) p12 w=2.4u l=0.13u
MN1928 (n1927 n1921 vss vss) n12 w=0.8u l=0.13u
MP1929 (n1927 n1921 vdd vdd) p12 w=2.4u l=0.13u
MN1932 (n1930 n1897 n1931 vss) n12 w=1.6u l=0.13u
MN1933 (n1931 n1921 vss vss) n12 w=1.6u l=0.13u
MP1934 (n1930 n1897 vdd vdd) p12 w=2.4u l=0.13u
MP1935 (n1930 n1921 vdd vdd) p12 w=2.4u l=0.13u
MN1938 (n1936 n1897 n1937 vss) n12 w=1.6u l=0.13u
MN1939 (n1937 n1930 vss vss) n12 w=1.6u l=0.13u
MP1940 (n1936 n1897 vdd vdd) p12 w=2.4u l=0.13u
MP1941 (n1936 n1930 vdd vdd) p12 w=2.4u l=0.13u
MN1944 (n1942 n1921 n1943 vss) n12 w=1.6u l=0.13u
MN1945 (n1943 n1930 vss vss) n12 w=1.6u l=0.13u
MP1946 (n1942 n1921 vdd vdd) p12 w=2.4u l=0.13u
MP1947 (n1942 n1930 vdd vdd) p12 w=2.4u l=0.13u
MN1950 (n1948 n1936 n1949 vss) n12 w=1.6u l=0.13u
MN1951 (n1949 n1942 vss vss) n12 w=1.6u l=0.13u
MP1952 (n1948 n1936 vdd vdd) p12 w=2.4u l=0.13u
MP1953 (n1948 n1942 vdd vdd) p12 w=2.4u l=0.13u
MN1955 (n1954 n1930 vss vss) n12 w=0.8u l=0.13u
MP1956 (n1954 n1930 vdd vdd) p12 w=2.4u l=0.13u
MN1959 (n1957 n1873 n1958 vss) n12 w=1.6u l=0.13u
MN1960 (n1958 n1954 vss vss) n12 w=1.6u l=0.13u
MP1961 (n1957 n1873 vdd vdd) p12 w=2.4u l=0.13u
MP1962 (n1957 n1954 vdd vdd) p12 w=2.4u l=0.13u
MN1965 (n1963 n1873 n1964 vss) n12 w=1.6u l=0.13u
MN1966 (n1964 n1957 vss vss) n12 w=1.6u l=0.13u
MP1967 (n1963 n1873 vdd vdd) p12 w=2.4u l=0.13u
MP1968 (n1963 n1957 vdd vdd) p12 w=2.4u l=0.13u
MN1971 (n1969 n1954 n1970 vss) n12 w=1.6u l=0.13u
MN1972 (n1970 n1957 vss vss) n12 w=1.6u l=0.13u
MP1973 (n1969 n1954 vdd vdd) p12 w=2.4u l=0.13u
MP1974 (n1969 n1957 vdd vdd) p12 w=2.4u l=0.13u
MN1977 (n1975 n1963 n1976 vss) n12 w=1.6u l=0.13u
MN1978 (n1976 n1969 vss vss) n12 w=1.6u l=0.13u
MP1979 (n1975 n1963 vdd vdd) p12 w=2.4u l=0.13u
MP1980 (n1975 n1969 vdd vdd) p12 w=2.4u l=0.13u
MN1982 (n1981 n1957 vss vss) n12 w=0.8u l=0.13u
MP1983 (n1981 n1957 vdd vdd) p12 w=2.4u l=0.13u
MN1986 (n1984 n1849 n1985 vss) n12 w=1.6u l=0.13u
MN1987 (n1985 n1981 vss vss) n12 w=1.6u l=0.13u
MP1988 (n1984 n1849 vdd vdd) p12 w=2.4u l=0.13u
MP1989 (n1984 n1981 vdd vdd) p12 w=2.4u l=0.13u
MN1992 (n1990 n1849 n1991 vss) n12 w=1.6u l=0.13u
MN1993 (n1991 n1984 vss vss) n12 w=1.6u l=0.13u
MP1994 (n1990 n1849 vdd vdd) p12 w=2.4u l=0.13u
MP1995 (n1990 n1984 vdd vdd) p12 w=2.4u l=0.13u
MN1998 (n1996 n1981 n1997 vss) n12 w=1.6u l=0.13u
MN1999 (n1997 n1984 vss vss) n12 w=1.6u l=0.13u
MP2000 (n1996 n1981 vdd vdd) p12 w=2.4u l=0.13u
MP2001 (n1996 n1984 vdd vdd) p12 w=2.4u l=0.13u
MN2004 (n2002 n1990 n2003 vss) n12 w=1.6u l=0.13u
MN2005 (n2003 n1996 vss vss) n12 w=1.6u l=0.13u
MP2006 (n2002 n1990 vdd vdd) p12 w=2.4u l=0.13u
MP2007 (n2002 n1996 vdd vdd) p12 w=2.4u l=0.13u
MN2009 (n2008 n1984 vss vss) n12 w=0.8u l=0.13u
MP2010 (n2008 n1984 vdd vdd) p12 w=2.4u l=0.13u
MN2013 (n2011 n1825 n2012 vss) n12 w=1.6u l=0.13u
MN2014 (n2012 n2008 vss vss) n12 w=1.6u l=0.13u
MP2015 (n2011 n1825 vdd vdd) p12 w=2.4u l=0.13u
MP2016 (n2011 n2008 vdd vdd) p12 w=2.4u l=0.13u
MN2019 (n2017 n1825 n2018 vss) n12 w=1.6u l=0.13u
MN2020 (n2018 n2011 vss vss) n12 w=1.6u l=0.13u
MP2021 (n2017 n1825 vdd vdd) p12 w=2.4u l=0.13u
MP2022 (n2017 n2011 vdd vdd) p12 w=2.4u l=0.13u
MN2025 (n2023 n2008 n2024 vss) n12 w=1.6u l=0.13u
MN2026 (n2024 n2011 vss vss) n12 w=1.6u l=0.13u
MP2027 (n2023 n2008 vdd vdd) p12 w=2.4u l=0.13u
MP2028 (n2023 n2011 vdd vdd) p12 w=2.4u l=0.13u
MN2031 (n2029 n2017 n2030 vss) n12 w=1.6u l=0.13u
MN2032 (n2030 n2023 vss vss) n12 w=1.6u l=0.13u
MP2033 (n2029 n2017 vdd vdd) p12 w=2.4u l=0.13u
MP2034 (n2029 n2023 vdd vdd) p12 w=2.4u l=0.13u
MN2036 (n2035 n2011 vss vss) n12 w=0.8u l=0.13u
MP2037 (n2035 n2011 vdd vdd) p12 w=2.4u l=0.13u
MN2040 (n2038 n1801 n2039 vss) n12 w=1.6u l=0.13u
MN2041 (n2039 n2035 vss vss) n12 w=1.6u l=0.13u
MP2042 (n2038 n1801 vdd vdd) p12 w=2.4u l=0.13u
MP2043 (n2038 n2035 vdd vdd) p12 w=2.4u l=0.13u
MN2046 (n2044 n1801 n2045 vss) n12 w=1.6u l=0.13u
MN2047 (n2045 n2038 vss vss) n12 w=1.6u l=0.13u
MP2048 (n2044 n1801 vdd vdd) p12 w=2.4u l=0.13u
MP2049 (n2044 n2038 vdd vdd) p12 w=2.4u l=0.13u
MN2052 (n2050 n2035 n2051 vss) n12 w=1.6u l=0.13u
MN2053 (n2051 n2038 vss vss) n12 w=1.6u l=0.13u
MP2054 (n2050 n2035 vdd vdd) p12 w=2.4u l=0.13u
MP2055 (n2050 n2038 vdd vdd) p12 w=2.4u l=0.13u
MN2058 (n2056 n2044 n2057 vss) n12 w=1.6u l=0.13u
MN2059 (n2057 n2050 vss vss) n12 w=1.6u l=0.13u
MP2060 (n2056 n2044 vdd vdd) p12 w=2.4u l=0.13u
MP2061 (n2056 n2050 vdd vdd) p12 w=2.4u l=0.13u
MN2063 (n2062 n2038 vss vss) n12 w=0.8u l=0.13u
MP2064 (n2062 n2038 vdd vdd) p12 w=2.4u l=0.13u
MN2067 (n2065 n1777 n2066 vss) n12 w=1.6u l=0.13u
MN2068 (n2066 n2062 vss vss) n12 w=1.6u l=0.13u
MP2069 (n2065 n1777 vdd vdd) p12 w=2.4u l=0.13u
MP2070 (n2065 n2062 vdd vdd) p12 w=2.4u l=0.13u
MN2073 (n2071 n1777 n2072 vss) n12 w=1.6u l=0.13u
MN2074 (n2072 n2065 vss vss) n12 w=1.6u l=0.13u
MP2075 (n2071 n1777 vdd vdd) p12 w=2.4u l=0.13u
MP2076 (n2071 n2065 vdd vdd) p12 w=2.4u l=0.13u
MN2079 (n2077 n2062 n2078 vss) n12 w=1.6u l=0.13u
MN2080 (n2078 n2065 vss vss) n12 w=1.6u l=0.13u
MP2081 (n2077 n2062 vdd vdd) p12 w=2.4u l=0.13u
MP2082 (n2077 n2065 vdd vdd) p12 w=2.4u l=0.13u
MN2085 (n2083 n2071 n2084 vss) n12 w=1.6u l=0.13u
MN2086 (n2084 n2077 vss vss) n12 w=1.6u l=0.13u
MP2087 (n2083 n2071 vdd vdd) p12 w=2.4u l=0.13u
MP2088 (n2083 n2077 vdd vdd) p12 w=2.4u l=0.13u
MN2090 (n2089 n2065 vss vss) n12 w=0.8u l=0.13u
MP2091 (n2089 n2065 vdd vdd) p12 w=2.4u l=0.13u
MN2094 (n2092 n1753 n2093 vss) n12 w=1.6u l=0.13u
MN2095 (n2093 n2089 vss vss) n12 w=1.6u l=0.13u
MP2096 (n2092 n1753 vdd vdd) p12 w=2.4u l=0.13u
MP2097 (n2092 n2089 vdd vdd) p12 w=2.4u l=0.13u
MN2100 (n2098 n1753 n2099 vss) n12 w=1.6u l=0.13u
MN2101 (n2099 n2092 vss vss) n12 w=1.6u l=0.13u
MP2102 (n2098 n1753 vdd vdd) p12 w=2.4u l=0.13u
MP2103 (n2098 n2092 vdd vdd) p12 w=2.4u l=0.13u
MN2106 (n2104 n2089 n2105 vss) n12 w=1.6u l=0.13u
MN2107 (n2105 n2092 vss vss) n12 w=1.6u l=0.13u
MP2108 (n2104 n2089 vdd vdd) p12 w=2.4u l=0.13u
MP2109 (n2104 n2092 vdd vdd) p12 w=2.4u l=0.13u
MN2112 (n2110 n2098 n2111 vss) n12 w=1.6u l=0.13u
MN2113 (n2111 n2104 vss vss) n12 w=1.6u l=0.13u
MP2114 (n2110 n2098 vdd vdd) p12 w=2.4u l=0.13u
MP2115 (n2110 n2104 vdd vdd) p12 w=2.4u l=0.13u
MN2117 (n2116 n2092 vss vss) n12 w=0.8u l=0.13u
MP2118 (n2116 n2092 vdd vdd) p12 w=2.4u l=0.13u
MN2121 (n2119 n2116 n2120 vss) n12 w=1.6u l=0.13u
MN2122 (n2120 one_g8 vss vss) n12 w=1.6u l=0.13u
MP2123 (n2119 n2116 vdd vdd) p12 w=2.4u l=0.13u
MP2124 (n2119 one_g8 vdd vdd) p12 w=2.4u l=0.13u
MN2127 (n2125 n2116 n2126 vss) n12 w=1.6u l=0.13u
MN2128 (n2126 n2119 vss vss) n12 w=1.6u l=0.13u
MP2129 (n2125 n2116 vdd vdd) p12 w=2.4u l=0.13u
MP2130 (n2125 n2119 vdd vdd) p12 w=2.4u l=0.13u
MN2133 (n2131 n2119 n2132 vss) n12 w=1.6u l=0.13u
MN2134 (n2132 one_g8 vss vss) n12 w=1.6u l=0.13u
MP2135 (n2131 n2119 vdd vdd) p12 w=2.4u l=0.13u
MP2136 (n2131 one_g8 vdd vdd) p12 w=2.4u l=0.13u
MN2139 (n2137 n2125 n2138 vss) n12 w=1.6u l=0.13u
MN2140 (n2138 n2131 vss vss) n12 w=1.6u l=0.13u
MP2141 (n2137 n2125 vdd vdd) p12 w=2.4u l=0.13u
MP2142 (n2137 n2131 vdd vdd) p12 w=2.4u l=0.13u
MN2144 (n2143 n2119 vss vss) n12 w=0.8u l=0.13u
MP2145 (n2143 n2119 vdd vdd) p12 w=2.4u l=0.13u
MN2148 (n2146 n1927 n2147 vss) n12 w=1.6u l=0.13u
MN2149 (n2147 n1948 vss vss) n12 w=1.6u l=0.13u
MP2150 (n2146 n1927 vdd vdd) p12 w=2.4u l=0.13u
MP2151 (n2146 n1948 vdd vdd) p12 w=2.4u l=0.13u
MN2154 (n2152 n1927 n2153 vss) n12 w=1.6u l=0.13u
MN2155 (n2153 n2146 vss vss) n12 w=1.6u l=0.13u
MP2156 (n2152 n1927 vdd vdd) p12 w=2.4u l=0.13u
MP2157 (n2152 n2146 vdd vdd) p12 w=2.4u l=0.13u
MN2160 (n2158 n1948 n2159 vss) n12 w=1.6u l=0.13u
MN2161 (n2159 n2146 vss vss) n12 w=1.6u l=0.13u
MP2162 (n2158 n1948 vdd vdd) p12 w=2.4u l=0.13u
MP2163 (n2158 n2146 vdd vdd) p12 w=2.4u l=0.13u
MN2166 (n2164 n2152 n2165 vss) n12 w=1.6u l=0.13u
MN2167 (n2165 n2158 vss vss) n12 w=1.6u l=0.13u
MP2168 (n2164 n2152 vdd vdd) p12 w=2.4u l=0.13u
MP2169 (n2164 n2158 vdd vdd) p12 w=2.4u l=0.13u
MN2172 (n2170 n1948 n2171 vss) n12 w=1.6u l=0.13u
MN2173 (n2171 n1975 vss vss) n12 w=1.6u l=0.13u
MP2174 (n2170 n1948 vdd vdd) p12 w=2.4u l=0.13u
MP2175 (n2170 n1975 vdd vdd) p12 w=2.4u l=0.13u
MN2178 (n2176 n1948 n2177 vss) n12 w=1.6u l=0.13u
MN2179 (n2177 n2170 vss vss) n12 w=1.6u l=0.13u
MP2180 (n2176 n1948 vdd vdd) p12 w=2.4u l=0.13u
MP2181 (n2176 n2170 vdd vdd) p12 w=2.4u l=0.13u
MN2184 (n2182 n1975 n2183 vss) n12 w=1.6u l=0.13u
MN2185 (n2183 n2170 vss vss) n12 w=1.6u l=0.13u
MP2186 (n2182 n1975 vdd vdd) p12 w=2.4u l=0.13u
MP2187 (n2182 n2170 vdd vdd) p12 w=2.4u l=0.13u
MN2190 (n2188 n2176 n2189 vss) n12 w=1.6u l=0.13u
MN2191 (n2189 n2182 vss vss) n12 w=1.6u l=0.13u
MP2192 (n2188 n2176 vdd vdd) p12 w=2.4u l=0.13u
MP2193 (n2188 n2182 vdd vdd) p12 w=2.4u l=0.13u
MN2196 (n2194 n1975 n2195 vss) n12 w=1.6u l=0.13u
MN2197 (n2195 n2002 vss vss) n12 w=1.6u l=0.13u
MP2198 (n2194 n1975 vdd vdd) p12 w=2.4u l=0.13u
MP2199 (n2194 n2002 vdd vdd) p12 w=2.4u l=0.13u
MN2202 (n2200 n1975 n2201 vss) n12 w=1.6u l=0.13u
MN2203 (n2201 n2194 vss vss) n12 w=1.6u l=0.13u
MP2204 (n2200 n1975 vdd vdd) p12 w=2.4u l=0.13u
MP2205 (n2200 n2194 vdd vdd) p12 w=2.4u l=0.13u
MN2208 (n2206 n2002 n2207 vss) n12 w=1.6u l=0.13u
MN2209 (n2207 n2194 vss vss) n12 w=1.6u l=0.13u
MP2210 (n2206 n2002 vdd vdd) p12 w=2.4u l=0.13u
MP2211 (n2206 n2194 vdd vdd) p12 w=2.4u l=0.13u
MN2214 (n2212 n2200 n2213 vss) n12 w=1.6u l=0.13u
MN2215 (n2213 n2206 vss vss) n12 w=1.6u l=0.13u
MP2216 (n2212 n2200 vdd vdd) p12 w=2.4u l=0.13u
MP2217 (n2212 n2206 vdd vdd) p12 w=2.4u l=0.13u
MN2220 (n2218 n2002 n2219 vss) n12 w=1.6u l=0.13u
MN2221 (n2219 n2029 vss vss) n12 w=1.6u l=0.13u
MP2222 (n2218 n2002 vdd vdd) p12 w=2.4u l=0.13u
MP2223 (n2218 n2029 vdd vdd) p12 w=2.4u l=0.13u
MN2226 (n2224 n2002 n2225 vss) n12 w=1.6u l=0.13u
MN2227 (n2225 n2218 vss vss) n12 w=1.6u l=0.13u
MP2228 (n2224 n2002 vdd vdd) p12 w=2.4u l=0.13u
MP2229 (n2224 n2218 vdd vdd) p12 w=2.4u l=0.13u
MN2232 (n2230 n2029 n2231 vss) n12 w=1.6u l=0.13u
MN2233 (n2231 n2218 vss vss) n12 w=1.6u l=0.13u
MP2234 (n2230 n2029 vdd vdd) p12 w=2.4u l=0.13u
MP2235 (n2230 n2218 vdd vdd) p12 w=2.4u l=0.13u
MN2238 (n2236 n2224 n2237 vss) n12 w=1.6u l=0.13u
MN2239 (n2237 n2230 vss vss) n12 w=1.6u l=0.13u
MP2240 (n2236 n2224 vdd vdd) p12 w=2.4u l=0.13u
MP2241 (n2236 n2230 vdd vdd) p12 w=2.4u l=0.13u
MN2244 (n2242 n2029 n2243 vss) n12 w=1.6u l=0.13u
MN2245 (n2243 n2056 vss vss) n12 w=1.6u l=0.13u
MP2246 (n2242 n2029 vdd vdd) p12 w=2.4u l=0.13u
MP2247 (n2242 n2056 vdd vdd) p12 w=2.4u l=0.13u
MN2250 (n2248 n2029 n2249 vss) n12 w=1.6u l=0.13u
MN2251 (n2249 n2242 vss vss) n12 w=1.6u l=0.13u
MP2252 (n2248 n2029 vdd vdd) p12 w=2.4u l=0.13u
MP2253 (n2248 n2242 vdd vdd) p12 w=2.4u l=0.13u
MN2256 (n2254 n2056 n2255 vss) n12 w=1.6u l=0.13u
MN2257 (n2255 n2242 vss vss) n12 w=1.6u l=0.13u
MP2258 (n2254 n2056 vdd vdd) p12 w=2.4u l=0.13u
MP2259 (n2254 n2242 vdd vdd) p12 w=2.4u l=0.13u
MN2262 (n2260 n2248 n2261 vss) n12 w=1.6u l=0.13u
MN2263 (n2261 n2254 vss vss) n12 w=1.6u l=0.13u
MP2264 (n2260 n2248 vdd vdd) p12 w=2.4u l=0.13u
MP2265 (n2260 n2254 vdd vdd) p12 w=2.4u l=0.13u
MN2268 (n2266 n2056 n2267 vss) n12 w=1.6u l=0.13u
MN2269 (n2267 n2083 vss vss) n12 w=1.6u l=0.13u
MP2270 (n2266 n2056 vdd vdd) p12 w=2.4u l=0.13u
MP2271 (n2266 n2083 vdd vdd) p12 w=2.4u l=0.13u
MN2274 (n2272 n2056 n2273 vss) n12 w=1.6u l=0.13u
MN2275 (n2273 n2266 vss vss) n12 w=1.6u l=0.13u
MP2276 (n2272 n2056 vdd vdd) p12 w=2.4u l=0.13u
MP2277 (n2272 n2266 vdd vdd) p12 w=2.4u l=0.13u
MN2280 (n2278 n2083 n2279 vss) n12 w=1.6u l=0.13u
MN2281 (n2279 n2266 vss vss) n12 w=1.6u l=0.13u
MP2282 (n2278 n2083 vdd vdd) p12 w=2.4u l=0.13u
MP2283 (n2278 n2266 vdd vdd) p12 w=2.4u l=0.13u
MN2286 (n2284 n2272 n2285 vss) n12 w=1.6u l=0.13u
MN2287 (n2285 n2278 vss vss) n12 w=1.6u l=0.13u
MP2288 (n2284 n2272 vdd vdd) p12 w=2.4u l=0.13u
MP2289 (n2284 n2278 vdd vdd) p12 w=2.4u l=0.13u
MN2292 (n2290 n2083 n2291 vss) n12 w=1.6u l=0.13u
MN2293 (n2291 n2110 vss vss) n12 w=1.6u l=0.13u
MP2294 (n2290 n2083 vdd vdd) p12 w=2.4u l=0.13u
MP2295 (n2290 n2110 vdd vdd) p12 w=2.4u l=0.13u
MN2298 (n2296 n2083 n2297 vss) n12 w=1.6u l=0.13u
MN2299 (n2297 n2290 vss vss) n12 w=1.6u l=0.13u
MP2300 (n2296 n2083 vdd vdd) p12 w=2.4u l=0.13u
MP2301 (n2296 n2290 vdd vdd) p12 w=2.4u l=0.13u
MN2304 (n2302 n2110 n2303 vss) n12 w=1.6u l=0.13u
MN2305 (n2303 n2290 vss vss) n12 w=1.6u l=0.13u
MP2306 (n2302 n2110 vdd vdd) p12 w=2.4u l=0.13u
MP2307 (n2302 n2290 vdd vdd) p12 w=2.4u l=0.13u
MN2310 (n2308 n2296 n2309 vss) n12 w=1.6u l=0.13u
MN2311 (n2309 n2302 vss vss) n12 w=1.6u l=0.13u
MP2312 (n2308 n2296 vdd vdd) p12 w=2.4u l=0.13u
MP2313 (n2308 n2302 vdd vdd) p12 w=2.4u l=0.13u
MN2316 (n2314 n2110 n2315 vss) n12 w=1.6u l=0.13u
MN2317 (n2315 n2137 vss vss) n12 w=1.6u l=0.13u
MP2318 (n2314 n2110 vdd vdd) p12 w=2.4u l=0.13u
MP2319 (n2314 n2137 vdd vdd) p12 w=2.4u l=0.13u
MN2322 (n2320 n2110 n2321 vss) n12 w=1.6u l=0.13u
MN2323 (n2321 n2314 vss vss) n12 w=1.6u l=0.13u
MP2324 (n2320 n2110 vdd vdd) p12 w=2.4u l=0.13u
MP2325 (n2320 n2314 vdd vdd) p12 w=2.4u l=0.13u
MN2328 (n2326 n2137 n2327 vss) n12 w=1.6u l=0.13u
MN2329 (n2327 n2314 vss vss) n12 w=1.6u l=0.13u
MP2330 (n2326 n2137 vdd vdd) p12 w=2.4u l=0.13u
MP2331 (n2326 n2314 vdd vdd) p12 w=2.4u l=0.13u
MN2334 (n2332 n2320 n2333 vss) n12 w=1.6u l=0.13u
MN2335 (n2333 n2326 vss vss) n12 w=1.6u l=0.13u
MP2336 (n2332 n2320 vdd vdd) p12 w=2.4u l=0.13u
MP2337 (n2332 n2326 vdd vdd) p12 w=2.4u l=0.13u
MN2341 (n2340 n2164 vss vss) n12 w=0.8u l=0.13u
MP2342 (n2340 n2164 vdd vdd) p12 w=2.4u l=0.13u
MN2345 (n2340 clk_low631 storage2344 vss) n12 w=1.2u l=0.13u
MP2346 (n2340 clk_lowb632 storage2344 vdd) p12 w=3.6u l=0.13u
MN2347 (qm2338 clk_high633 storage2344 vss) n12 w=1.2u l=0.13u
MP2348 (qm2338 clk_highb634 storage2344 vdd) p12 w=3.6u l=0.13u
MN2349 (qmb2339 storage2344 vss vss) n12 w=0.5u l=0.13u
MP2350 (qmb2339 storage2344 vdd vdd) p12 w=1.5u l=0.13u
MN2351 (qm2338 qmb2339 vss vss) n12 w=0.5u l=0.13u
MP2352 (qm2338 qmb2339 vdd vdd) p12 w=1.5u l=0.13u
MN2353 (storage2344 rst vss vss) n12 w=2u l=0.13u
MN2355 (qm2338 clk_high633 storage2354 vss) n12 w=1.2u l=0.13u
MP2356 (qm2338 clk_highb634 storage2354 vdd) p12 w=3.6u l=0.13u
MN2357 (qneg2343 clk_low631 storage2354 vss) n12 w=1.2u l=0.13u
MP2358 (qneg2343 clk_lowb632 storage2354 vdd) p12 w=3.6u l=0.13u
MN2359 (one_g0 storage2354 vss vss) n12 w=0.5u l=0.13u
MP2360 (one_g0 storage2354 vdd vdd) p12 w=1.5u l=0.13u
MN2361 (qneg2343 one_g0 vss vss) n12 w=0.5u l=0.13u
MP2362 (qneg2343 one_g0 vdd vdd) p12 w=1.5u l=0.13u
MN2363 (storage2354 rst vss vss) n12 w=2u l=0.13u
MN2368 (n2188 clk_low631 storage2367 vss) n12 w=1.2u l=0.13u
MP2369 (n2188 clk_lowb632 storage2367 vdd) p12 w=3.6u l=0.13u
MN2370 (qm2364 clk_high633 storage2367 vss) n12 w=1.2u l=0.13u
MP2371 (qm2364 clk_highb634 storage2367 vdd) p12 w=3.6u l=0.13u
MN2372 (qmb2365 storage2367 vss vss) n12 w=0.5u l=0.13u
MP2373 (qmb2365 storage2367 vdd vdd) p12 w=1.5u l=0.13u
MN2374 (qm2364 qmb2365 vss vss) n12 w=0.5u l=0.13u
MP2375 (qm2364 qmb2365 vdd vdd) p12 w=1.5u l=0.13u
MN2376 (storage2367 rst vss vss) n12 w=2u l=0.13u
MN2378 (qm2364 clk_high633 storage2377 vss) n12 w=1.2u l=0.13u
MP2379 (qm2364 clk_highb634 storage2377 vdd) p12 w=3.6u l=0.13u
MN2380 (one_g1 clk_low631 storage2377 vss) n12 w=1.2u l=0.13u
MP2381 (one_g1 clk_lowb632 storage2377 vdd) p12 w=3.6u l=0.13u
MN2382 (qb2366 storage2377 vss vss) n12 w=0.5u l=0.13u
MP2383 (qb2366 storage2377 vdd vdd) p12 w=1.5u l=0.13u
MN2384 (one_g1 qb2366 vss vss) n12 w=0.5u l=0.13u
MP2385 (one_g1 qb2366 vdd vdd) p12 w=1.5u l=0.13u
MN2386 (storage2377 rst vss vss) n12 w=2u l=0.13u
MN2391 (n2212 clk_low631 storage2390 vss) n12 w=1.2u l=0.13u
MP2392 (n2212 clk_lowb632 storage2390 vdd) p12 w=3.6u l=0.13u
MN2393 (qm2387 clk_high633 storage2390 vss) n12 w=1.2u l=0.13u
MP2394 (qm2387 clk_highb634 storage2390 vdd) p12 w=3.6u l=0.13u
MN2395 (qmb2388 storage2390 vss vss) n12 w=0.5u l=0.13u
MP2396 (qmb2388 storage2390 vdd vdd) p12 w=1.5u l=0.13u
MN2397 (qm2387 qmb2388 vss vss) n12 w=0.5u l=0.13u
MP2398 (qm2387 qmb2388 vdd vdd) p12 w=1.5u l=0.13u
MN2399 (storage2390 rst vss vss) n12 w=2u l=0.13u
MN2401 (qm2387 clk_high633 storage2400 vss) n12 w=1.2u l=0.13u
MP2402 (qm2387 clk_highb634 storage2400 vdd) p12 w=3.6u l=0.13u
MN2403 (one_g2 clk_low631 storage2400 vss) n12 w=1.2u l=0.13u
MP2404 (one_g2 clk_lowb632 storage2400 vdd) p12 w=3.6u l=0.13u
MN2405 (qb2389 storage2400 vss vss) n12 w=0.5u l=0.13u
MP2406 (qb2389 storage2400 vdd vdd) p12 w=1.5u l=0.13u
MN2407 (one_g2 qb2389 vss vss) n12 w=0.5u l=0.13u
MP2408 (one_g2 qb2389 vdd vdd) p12 w=1.5u l=0.13u
MN2409 (storage2400 rst vss vss) n12 w=2u l=0.13u
MN2414 (n2236 clk_low631 storage2413 vss) n12 w=1.2u l=0.13u
MP2415 (n2236 clk_lowb632 storage2413 vdd) p12 w=3.6u l=0.13u
MN2416 (qm2410 clk_high633 storage2413 vss) n12 w=1.2u l=0.13u
MP2417 (qm2410 clk_highb634 storage2413 vdd) p12 w=3.6u l=0.13u
MN2418 (qmb2411 storage2413 vss vss) n12 w=0.5u l=0.13u
MP2419 (qmb2411 storage2413 vdd vdd) p12 w=1.5u l=0.13u
MN2420 (qm2410 qmb2411 vss vss) n12 w=0.5u l=0.13u
MP2421 (qm2410 qmb2411 vdd vdd) p12 w=1.5u l=0.13u
MN2422 (storage2413 rst vss vss) n12 w=2u l=0.13u
MN2424 (qm2410 clk_high633 storage2423 vss) n12 w=1.2u l=0.13u
MP2425 (qm2410 clk_highb634 storage2423 vdd) p12 w=3.6u l=0.13u
MN2426 (one_g3 clk_low631 storage2423 vss) n12 w=1.2u l=0.13u
MP2427 (one_g3 clk_lowb632 storage2423 vdd) p12 w=3.6u l=0.13u
MN2428 (qb2412 storage2423 vss vss) n12 w=0.5u l=0.13u
MP2429 (qb2412 storage2423 vdd vdd) p12 w=1.5u l=0.13u
MN2430 (one_g3 qb2412 vss vss) n12 w=0.5u l=0.13u
MP2431 (one_g3 qb2412 vdd vdd) p12 w=1.5u l=0.13u
MN2432 (storage2423 rst vss vss) n12 w=2u l=0.13u
MN2437 (n2260 clk_low631 storage2436 vss) n12 w=1.2u l=0.13u
MP2438 (n2260 clk_lowb632 storage2436 vdd) p12 w=3.6u l=0.13u
MN2439 (qm2433 clk_high633 storage2436 vss) n12 w=1.2u l=0.13u
MP2440 (qm2433 clk_highb634 storage2436 vdd) p12 w=3.6u l=0.13u
MN2441 (qmb2434 storage2436 vss vss) n12 w=0.5u l=0.13u
MP2442 (qmb2434 storage2436 vdd vdd) p12 w=1.5u l=0.13u
MN2443 (qm2433 qmb2434 vss vss) n12 w=0.5u l=0.13u
MP2444 (qm2433 qmb2434 vdd vdd) p12 w=1.5u l=0.13u
MN2445 (storage2436 rst vss vss) n12 w=2u l=0.13u
MN2447 (qm2433 clk_high633 storage2446 vss) n12 w=1.2u l=0.13u
MP2448 (qm2433 clk_highb634 storage2446 vdd) p12 w=3.6u l=0.13u
MN2449 (one_g4 clk_low631 storage2446 vss) n12 w=1.2u l=0.13u
MP2450 (one_g4 clk_lowb632 storage2446 vdd) p12 w=3.6u l=0.13u
MN2451 (qb2435 storage2446 vss vss) n12 w=0.5u l=0.13u
MP2452 (qb2435 storage2446 vdd vdd) p12 w=1.5u l=0.13u
MN2453 (one_g4 qb2435 vss vss) n12 w=0.5u l=0.13u
MP2454 (one_g4 qb2435 vdd vdd) p12 w=1.5u l=0.13u
MN2455 (storage2446 rst vss vss) n12 w=2u l=0.13u
MN2460 (n2284 clk_low631 storage2459 vss) n12 w=1.2u l=0.13u
MP2461 (n2284 clk_lowb632 storage2459 vdd) p12 w=3.6u l=0.13u
MN2462 (qm2456 clk_high633 storage2459 vss) n12 w=1.2u l=0.13u
MP2463 (qm2456 clk_highb634 storage2459 vdd) p12 w=3.6u l=0.13u
MN2464 (qmb2457 storage2459 vss vss) n12 w=0.5u l=0.13u
MP2465 (qmb2457 storage2459 vdd vdd) p12 w=1.5u l=0.13u
MN2466 (qm2456 qmb2457 vss vss) n12 w=0.5u l=0.13u
MP2467 (qm2456 qmb2457 vdd vdd) p12 w=1.5u l=0.13u
MN2468 (storage2459 rst vss vss) n12 w=2u l=0.13u
MN2470 (qm2456 clk_high633 storage2469 vss) n12 w=1.2u l=0.13u
MP2471 (qm2456 clk_highb634 storage2469 vdd) p12 w=3.6u l=0.13u
MN2472 (one_g5 clk_low631 storage2469 vss) n12 w=1.2u l=0.13u
MP2473 (one_g5 clk_lowb632 storage2469 vdd) p12 w=3.6u l=0.13u
MN2474 (qb2458 storage2469 vss vss) n12 w=0.5u l=0.13u
MP2475 (qb2458 storage2469 vdd vdd) p12 w=1.5u l=0.13u
MN2476 (one_g5 qb2458 vss vss) n12 w=0.5u l=0.13u
MP2477 (one_g5 qb2458 vdd vdd) p12 w=1.5u l=0.13u
MN2478 (storage2469 rst vss vss) n12 w=2u l=0.13u
MN2483 (n2308 clk_low631 storage2482 vss) n12 w=1.2u l=0.13u
MP2484 (n2308 clk_lowb632 storage2482 vdd) p12 w=3.6u l=0.13u
MN2485 (qm2479 clk_high633 storage2482 vss) n12 w=1.2u l=0.13u
MP2486 (qm2479 clk_highb634 storage2482 vdd) p12 w=3.6u l=0.13u
MN2487 (qmb2480 storage2482 vss vss) n12 w=0.5u l=0.13u
MP2488 (qmb2480 storage2482 vdd vdd) p12 w=1.5u l=0.13u
MN2489 (qm2479 qmb2480 vss vss) n12 w=0.5u l=0.13u
MP2490 (qm2479 qmb2480 vdd vdd) p12 w=1.5u l=0.13u
MN2491 (storage2482 rst vss vss) n12 w=2u l=0.13u
MN2493 (qm2479 clk_high633 storage2492 vss) n12 w=1.2u l=0.13u
MP2494 (qm2479 clk_highb634 storage2492 vdd) p12 w=3.6u l=0.13u
MN2495 (one_g6 clk_low631 storage2492 vss) n12 w=1.2u l=0.13u
MP2496 (one_g6 clk_lowb632 storage2492 vdd) p12 w=3.6u l=0.13u
MN2497 (qb2481 storage2492 vss vss) n12 w=0.5u l=0.13u
MP2498 (qb2481 storage2492 vdd vdd) p12 w=1.5u l=0.13u
MN2499 (one_g6 qb2481 vss vss) n12 w=0.5u l=0.13u
MP2500 (one_g6 qb2481 vdd vdd) p12 w=1.5u l=0.13u
MN2501 (storage2492 rst vss vss) n12 w=2u l=0.13u
MN2506 (n2332 clk_low631 storage2505 vss) n12 w=1.2u l=0.13u
MP2507 (n2332 clk_lowb632 storage2505 vdd) p12 w=3.6u l=0.13u
MN2508 (qm2502 clk_high633 storage2505 vss) n12 w=1.2u l=0.13u
MP2509 (qm2502 clk_highb634 storage2505 vdd) p12 w=3.6u l=0.13u
MN2510 (qmb2503 storage2505 vss vss) n12 w=0.5u l=0.13u
MP2511 (qmb2503 storage2505 vdd vdd) p12 w=1.5u l=0.13u
MN2512 (qm2502 qmb2503 vss vss) n12 w=0.5u l=0.13u
MP2513 (qm2502 qmb2503 vdd vdd) p12 w=1.5u l=0.13u
MN2514 (storage2505 rst vss vss) n12 w=2u l=0.13u
MN2516 (qm2502 clk_high633 storage2515 vss) n12 w=1.2u l=0.13u
MP2517 (qm2502 clk_highb634 storage2515 vdd) p12 w=3.6u l=0.13u
MN2518 (one_g7 clk_low631 storage2515 vss) n12 w=1.2u l=0.13u
MP2519 (one_g7 clk_lowb632 storage2515 vdd) p12 w=3.6u l=0.13u
MN2520 (qb2504 storage2515 vss vss) n12 w=0.5u l=0.13u
MP2521 (qb2504 storage2515 vdd vdd) p12 w=1.5u l=0.13u
MN2522 (one_g7 qb2504 vss vss) n12 w=0.5u l=0.13u
MP2523 (one_g7 qb2504 vdd vdd) p12 w=1.5u l=0.13u
MN2524 (storage2515 rst vss vss) n12 w=2u l=0.13u
MN2529 (n2137 clk_low631 storage2528 vss) n12 w=1.2u l=0.13u
MP2530 (n2137 clk_lowb632 storage2528 vdd) p12 w=3.6u l=0.13u
MN2531 (qm2525 clk_high633 storage2528 vss) n12 w=1.2u l=0.13u
MP2532 (qm2525 clk_highb634 storage2528 vdd) p12 w=3.6u l=0.13u
MN2533 (qmb2526 storage2528 vss vss) n12 w=0.5u l=0.13u
MP2534 (qmb2526 storage2528 vdd vdd) p12 w=1.5u l=0.13u
MN2535 (qm2525 qmb2526 vss vss) n12 w=0.5u l=0.13u
MP2536 (qm2525 qmb2526 vdd vdd) p12 w=1.5u l=0.13u
MN2537 (storage2528 rst vss vss) n12 w=2u l=0.13u
MN2539 (qm2525 clk_high633 storage2538 vss) n12 w=1.2u l=0.13u
MP2540 (qm2525 clk_highb634 storage2538 vdd) p12 w=3.6u l=0.13u
MN2541 (one_g8 clk_low631 storage2538 vss) n12 w=1.2u l=0.13u
MP2542 (one_g8 clk_lowb632 storage2538 vdd) p12 w=3.6u l=0.13u
MN2543 (qb2527 storage2538 vss vss) n12 w=0.5u l=0.13u
MP2544 (qb2527 storage2538 vdd vdd) p12 w=1.5u l=0.13u
MN2545 (one_g8 qb2527 vss vss) n12 w=0.5u l=0.13u
MP2546 (one_g8 qb2527 vdd vdd) p12 w=1.5u l=0.13u
MN2547 (storage2538 rst vss vss) n12 w=2u l=0.13u
MN2552 (one_g0 clk_low898 storage2551 vss) n12 w=1.2u l=0.13u
MP2553 (one_g0 clk_lowb899 storage2551 vdd) p12 w=3.6u l=0.13u
MN2554 (qm2548 clk_high900 storage2551 vss) n12 w=1.2u l=0.13u
MP2555 (qm2548 clk_highb901 storage2551 vdd) p12 w=3.6u l=0.13u
MN2556 (qmb2549 storage2551 vss vss) n12 w=0.5u l=0.13u
MP2557 (qmb2549 storage2551 vdd vdd) p12 w=1.5u l=0.13u
MN2558 (qm2548 qmb2549 vss vss) n12 w=0.5u l=0.13u
MP2559 (qm2548 qmb2549 vdd vdd) p12 w=1.5u l=0.13u
MN2560 (storage2551 rst vss vss) n12 w=2u l=0.13u
MN2562 (qm2548 clk_high900 storage2561 vss) n12 w=1.2u l=0.13u
MP2563 (qm2548 clk_highb901 storage2561 vdd) p12 w=3.6u l=0.13u
MN2564 (one_sync1_0 clk_low898 storage2561 vss) n12 w=1.2u l=0.13u
MP2565 (one_sync1_0 clk_lowb899 storage2561 vdd) p12 w=3.6u l=0.13u
MN2566 (qb2550 storage2561 vss vss) n12 w=0.5u l=0.13u
MP2567 (qb2550 storage2561 vdd vdd) p12 w=1.5u l=0.13u
MN2568 (one_sync1_0 qb2550 vss vss) n12 w=0.5u l=0.13u
MP2569 (one_sync1_0 qb2550 vdd vdd) p12 w=1.5u l=0.13u
MN2570 (storage2561 rst vss vss) n12 w=2u l=0.13u
MN2575 (one_sync1_0 clk_low898 storage2574 vss) n12 w=1.2u l=0.13u
MP2576 (one_sync1_0 clk_lowb899 storage2574 vdd) p12 w=3.6u l=0.13u
MN2577 (qm2571 clk_high900 storage2574 vss) n12 w=1.2u l=0.13u
MP2578 (qm2571 clk_highb901 storage2574 vdd) p12 w=3.6u l=0.13u
MN2579 (qmb2572 storage2574 vss vss) n12 w=0.5u l=0.13u
MP2580 (qmb2572 storage2574 vdd vdd) p12 w=1.5u l=0.13u
MN2581 (qm2571 qmb2572 vss vss) n12 w=0.5u l=0.13u
MP2582 (qm2571 qmb2572 vdd vdd) p12 w=1.5u l=0.13u
MN2583 (storage2574 rst vss vss) n12 w=2u l=0.13u
MN2585 (qm2571 clk_high900 storage2584 vss) n12 w=1.2u l=0.13u
MP2586 (qm2571 clk_highb901 storage2584 vdd) p12 w=3.6u l=0.13u
MN2587 (one_sync2_0 clk_low898 storage2584 vss) n12 w=1.2u l=0.13u
MP2588 (one_sync2_0 clk_lowb899 storage2584 vdd) p12 w=3.6u l=0.13u
MN2589 (qb2573 storage2584 vss vss) n12 w=0.5u l=0.13u
MP2590 (qb2573 storage2584 vdd vdd) p12 w=1.5u l=0.13u
MN2591 (one_sync2_0 qb2573 vss vss) n12 w=0.5u l=0.13u
MP2592 (one_sync2_0 qb2573 vdd vdd) p12 w=1.5u l=0.13u
MN2593 (storage2584 rst vss vss) n12 w=2u l=0.13u
MN2598 (one_g1 clk_low898 storage2597 vss) n12 w=1.2u l=0.13u
MP2599 (one_g1 clk_lowb899 storage2597 vdd) p12 w=3.6u l=0.13u
MN2600 (qm2594 clk_high900 storage2597 vss) n12 w=1.2u l=0.13u
MP2601 (qm2594 clk_highb901 storage2597 vdd) p12 w=3.6u l=0.13u
MN2602 (qmb2595 storage2597 vss vss) n12 w=0.5u l=0.13u
MP2603 (qmb2595 storage2597 vdd vdd) p12 w=1.5u l=0.13u
MN2604 (qm2594 qmb2595 vss vss) n12 w=0.5u l=0.13u
MP2605 (qm2594 qmb2595 vdd vdd) p12 w=1.5u l=0.13u
MN2606 (storage2597 rst vss vss) n12 w=2u l=0.13u
MN2608 (qm2594 clk_high900 storage2607 vss) n12 w=1.2u l=0.13u
MP2609 (qm2594 clk_highb901 storage2607 vdd) p12 w=3.6u l=0.13u
MN2610 (one_sync1_1 clk_low898 storage2607 vss) n12 w=1.2u l=0.13u
MP2611 (one_sync1_1 clk_lowb899 storage2607 vdd) p12 w=3.6u l=0.13u
MN2612 (qb2596 storage2607 vss vss) n12 w=0.5u l=0.13u
MP2613 (qb2596 storage2607 vdd vdd) p12 w=1.5u l=0.13u
MN2614 (one_sync1_1 qb2596 vss vss) n12 w=0.5u l=0.13u
MP2615 (one_sync1_1 qb2596 vdd vdd) p12 w=1.5u l=0.13u
MN2616 (storage2607 rst vss vss) n12 w=2u l=0.13u
MN2621 (one_sync1_1 clk_low898 storage2620 vss) n12 w=1.2u l=0.13u
MP2622 (one_sync1_1 clk_lowb899 storage2620 vdd) p12 w=3.6u l=0.13u
MN2623 (qm2617 clk_high900 storage2620 vss) n12 w=1.2u l=0.13u
MP2624 (qm2617 clk_highb901 storage2620 vdd) p12 w=3.6u l=0.13u
MN2625 (qmb2618 storage2620 vss vss) n12 w=0.5u l=0.13u
MP2626 (qmb2618 storage2620 vdd vdd) p12 w=1.5u l=0.13u
MN2627 (qm2617 qmb2618 vss vss) n12 w=0.5u l=0.13u
MP2628 (qm2617 qmb2618 vdd vdd) p12 w=1.5u l=0.13u
MN2629 (storage2620 rst vss vss) n12 w=2u l=0.13u
MN2631 (qm2617 clk_high900 storage2630 vss) n12 w=1.2u l=0.13u
MP2632 (qm2617 clk_highb901 storage2630 vdd) p12 w=3.6u l=0.13u
MN2633 (one_sync2_1 clk_low898 storage2630 vss) n12 w=1.2u l=0.13u
MP2634 (one_sync2_1 clk_lowb899 storage2630 vdd) p12 w=3.6u l=0.13u
MN2635 (qb2619 storage2630 vss vss) n12 w=0.5u l=0.13u
MP2636 (qb2619 storage2630 vdd vdd) p12 w=1.5u l=0.13u
MN2637 (one_sync2_1 qb2619 vss vss) n12 w=0.5u l=0.13u
MP2638 (one_sync2_1 qb2619 vdd vdd) p12 w=1.5u l=0.13u
MN2639 (storage2630 rst vss vss) n12 w=2u l=0.13u
MN2644 (one_g2 clk_low898 storage2643 vss) n12 w=1.2u l=0.13u
MP2645 (one_g2 clk_lowb899 storage2643 vdd) p12 w=3.6u l=0.13u
MN2646 (qm2640 clk_high900 storage2643 vss) n12 w=1.2u l=0.13u
MP2647 (qm2640 clk_highb901 storage2643 vdd) p12 w=3.6u l=0.13u
MN2648 (qmb2641 storage2643 vss vss) n12 w=0.5u l=0.13u
MP2649 (qmb2641 storage2643 vdd vdd) p12 w=1.5u l=0.13u
MN2650 (qm2640 qmb2641 vss vss) n12 w=0.5u l=0.13u
MP2651 (qm2640 qmb2641 vdd vdd) p12 w=1.5u l=0.13u
MN2652 (storage2643 rst vss vss) n12 w=2u l=0.13u
MN2654 (qm2640 clk_high900 storage2653 vss) n12 w=1.2u l=0.13u
MP2655 (qm2640 clk_highb901 storage2653 vdd) p12 w=3.6u l=0.13u
MN2656 (one_sync1_2 clk_low898 storage2653 vss) n12 w=1.2u l=0.13u
MP2657 (one_sync1_2 clk_lowb899 storage2653 vdd) p12 w=3.6u l=0.13u
MN2658 (qb2642 storage2653 vss vss) n12 w=0.5u l=0.13u
MP2659 (qb2642 storage2653 vdd vdd) p12 w=1.5u l=0.13u
MN2660 (one_sync1_2 qb2642 vss vss) n12 w=0.5u l=0.13u
MP2661 (one_sync1_2 qb2642 vdd vdd) p12 w=1.5u l=0.13u
MN2662 (storage2653 rst vss vss) n12 w=2u l=0.13u
MN2667 (one_sync1_2 clk_low898 storage2666 vss) n12 w=1.2u l=0.13u
MP2668 (one_sync1_2 clk_lowb899 storage2666 vdd) p12 w=3.6u l=0.13u
MN2669 (qm2663 clk_high900 storage2666 vss) n12 w=1.2u l=0.13u
MP2670 (qm2663 clk_highb901 storage2666 vdd) p12 w=3.6u l=0.13u
MN2671 (qmb2664 storage2666 vss vss) n12 w=0.5u l=0.13u
MP2672 (qmb2664 storage2666 vdd vdd) p12 w=1.5u l=0.13u
MN2673 (qm2663 qmb2664 vss vss) n12 w=0.5u l=0.13u
MP2674 (qm2663 qmb2664 vdd vdd) p12 w=1.5u l=0.13u
MN2675 (storage2666 rst vss vss) n12 w=2u l=0.13u
MN2677 (qm2663 clk_high900 storage2676 vss) n12 w=1.2u l=0.13u
MP2678 (qm2663 clk_highb901 storage2676 vdd) p12 w=3.6u l=0.13u
MN2679 (one_sync2_2 clk_low898 storage2676 vss) n12 w=1.2u l=0.13u
MP2680 (one_sync2_2 clk_lowb899 storage2676 vdd) p12 w=3.6u l=0.13u
MN2681 (qb2665 storage2676 vss vss) n12 w=0.5u l=0.13u
MP2682 (qb2665 storage2676 vdd vdd) p12 w=1.5u l=0.13u
MN2683 (one_sync2_2 qb2665 vss vss) n12 w=0.5u l=0.13u
MP2684 (one_sync2_2 qb2665 vdd vdd) p12 w=1.5u l=0.13u
MN2685 (storage2676 rst vss vss) n12 w=2u l=0.13u
MN2690 (one_g3 clk_low898 storage2689 vss) n12 w=1.2u l=0.13u
MP2691 (one_g3 clk_lowb899 storage2689 vdd) p12 w=3.6u l=0.13u
MN2692 (qm2686 clk_high900 storage2689 vss) n12 w=1.2u l=0.13u
MP2693 (qm2686 clk_highb901 storage2689 vdd) p12 w=3.6u l=0.13u
MN2694 (qmb2687 storage2689 vss vss) n12 w=0.5u l=0.13u
MP2695 (qmb2687 storage2689 vdd vdd) p12 w=1.5u l=0.13u
MN2696 (qm2686 qmb2687 vss vss) n12 w=0.5u l=0.13u
MP2697 (qm2686 qmb2687 vdd vdd) p12 w=1.5u l=0.13u
MN2698 (storage2689 rst vss vss) n12 w=2u l=0.13u
MN2700 (qm2686 clk_high900 storage2699 vss) n12 w=1.2u l=0.13u
MP2701 (qm2686 clk_highb901 storage2699 vdd) p12 w=3.6u l=0.13u
MN2702 (one_sync1_3 clk_low898 storage2699 vss) n12 w=1.2u l=0.13u
MP2703 (one_sync1_3 clk_lowb899 storage2699 vdd) p12 w=3.6u l=0.13u
MN2704 (qb2688 storage2699 vss vss) n12 w=0.5u l=0.13u
MP2705 (qb2688 storage2699 vdd vdd) p12 w=1.5u l=0.13u
MN2706 (one_sync1_3 qb2688 vss vss) n12 w=0.5u l=0.13u
MP2707 (one_sync1_3 qb2688 vdd vdd) p12 w=1.5u l=0.13u
MN2708 (storage2699 rst vss vss) n12 w=2u l=0.13u
MN2713 (one_sync1_3 clk_low898 storage2712 vss) n12 w=1.2u l=0.13u
MP2714 (one_sync1_3 clk_lowb899 storage2712 vdd) p12 w=3.6u l=0.13u
MN2715 (qm2709 clk_high900 storage2712 vss) n12 w=1.2u l=0.13u
MP2716 (qm2709 clk_highb901 storage2712 vdd) p12 w=3.6u l=0.13u
MN2717 (qmb2710 storage2712 vss vss) n12 w=0.5u l=0.13u
MP2718 (qmb2710 storage2712 vdd vdd) p12 w=1.5u l=0.13u
MN2719 (qm2709 qmb2710 vss vss) n12 w=0.5u l=0.13u
MP2720 (qm2709 qmb2710 vdd vdd) p12 w=1.5u l=0.13u
MN2721 (storage2712 rst vss vss) n12 w=2u l=0.13u
MN2723 (qm2709 clk_high900 storage2722 vss) n12 w=1.2u l=0.13u
MP2724 (qm2709 clk_highb901 storage2722 vdd) p12 w=3.6u l=0.13u
MN2725 (one_sync2_3 clk_low898 storage2722 vss) n12 w=1.2u l=0.13u
MP2726 (one_sync2_3 clk_lowb899 storage2722 vdd) p12 w=3.6u l=0.13u
MN2727 (qb2711 storage2722 vss vss) n12 w=0.5u l=0.13u
MP2728 (qb2711 storage2722 vdd vdd) p12 w=1.5u l=0.13u
MN2729 (one_sync2_3 qb2711 vss vss) n12 w=0.5u l=0.13u
MP2730 (one_sync2_3 qb2711 vdd vdd) p12 w=1.5u l=0.13u
MN2731 (storage2722 rst vss vss) n12 w=2u l=0.13u
MN2736 (one_g4 clk_low898 storage2735 vss) n12 w=1.2u l=0.13u
MP2737 (one_g4 clk_lowb899 storage2735 vdd) p12 w=3.6u l=0.13u
MN2738 (qm2732 clk_high900 storage2735 vss) n12 w=1.2u l=0.13u
MP2739 (qm2732 clk_highb901 storage2735 vdd) p12 w=3.6u l=0.13u
MN2740 (qmb2733 storage2735 vss vss) n12 w=0.5u l=0.13u
MP2741 (qmb2733 storage2735 vdd vdd) p12 w=1.5u l=0.13u
MN2742 (qm2732 qmb2733 vss vss) n12 w=0.5u l=0.13u
MP2743 (qm2732 qmb2733 vdd vdd) p12 w=1.5u l=0.13u
MN2744 (storage2735 rst vss vss) n12 w=2u l=0.13u
MN2746 (qm2732 clk_high900 storage2745 vss) n12 w=1.2u l=0.13u
MP2747 (qm2732 clk_highb901 storage2745 vdd) p12 w=3.6u l=0.13u
MN2748 (one_sync1_4 clk_low898 storage2745 vss) n12 w=1.2u l=0.13u
MP2749 (one_sync1_4 clk_lowb899 storage2745 vdd) p12 w=3.6u l=0.13u
MN2750 (qb2734 storage2745 vss vss) n12 w=0.5u l=0.13u
MP2751 (qb2734 storage2745 vdd vdd) p12 w=1.5u l=0.13u
MN2752 (one_sync1_4 qb2734 vss vss) n12 w=0.5u l=0.13u
MP2753 (one_sync1_4 qb2734 vdd vdd) p12 w=1.5u l=0.13u
MN2754 (storage2745 rst vss vss) n12 w=2u l=0.13u
MN2759 (one_sync1_4 clk_low898 storage2758 vss) n12 w=1.2u l=0.13u
MP2760 (one_sync1_4 clk_lowb899 storage2758 vdd) p12 w=3.6u l=0.13u
MN2761 (qm2755 clk_high900 storage2758 vss) n12 w=1.2u l=0.13u
MP2762 (qm2755 clk_highb901 storage2758 vdd) p12 w=3.6u l=0.13u
MN2763 (qmb2756 storage2758 vss vss) n12 w=0.5u l=0.13u
MP2764 (qmb2756 storage2758 vdd vdd) p12 w=1.5u l=0.13u
MN2765 (qm2755 qmb2756 vss vss) n12 w=0.5u l=0.13u
MP2766 (qm2755 qmb2756 vdd vdd) p12 w=1.5u l=0.13u
MN2767 (storage2758 rst vss vss) n12 w=2u l=0.13u
MN2769 (qm2755 clk_high900 storage2768 vss) n12 w=1.2u l=0.13u
MP2770 (qm2755 clk_highb901 storage2768 vdd) p12 w=3.6u l=0.13u
MN2771 (one_sync2_4 clk_low898 storage2768 vss) n12 w=1.2u l=0.13u
MP2772 (one_sync2_4 clk_lowb899 storage2768 vdd) p12 w=3.6u l=0.13u
MN2773 (qb2757 storage2768 vss vss) n12 w=0.5u l=0.13u
MP2774 (qb2757 storage2768 vdd vdd) p12 w=1.5u l=0.13u
MN2775 (one_sync2_4 qb2757 vss vss) n12 w=0.5u l=0.13u
MP2776 (one_sync2_4 qb2757 vdd vdd) p12 w=1.5u l=0.13u
MN2777 (storage2768 rst vss vss) n12 w=2u l=0.13u
MN2782 (one_g5 clk_low898 storage2781 vss) n12 w=1.2u l=0.13u
MP2783 (one_g5 clk_lowb899 storage2781 vdd) p12 w=3.6u l=0.13u
MN2784 (qm2778 clk_high900 storage2781 vss) n12 w=1.2u l=0.13u
MP2785 (qm2778 clk_highb901 storage2781 vdd) p12 w=3.6u l=0.13u
MN2786 (qmb2779 storage2781 vss vss) n12 w=0.5u l=0.13u
MP2787 (qmb2779 storage2781 vdd vdd) p12 w=1.5u l=0.13u
MN2788 (qm2778 qmb2779 vss vss) n12 w=0.5u l=0.13u
MP2789 (qm2778 qmb2779 vdd vdd) p12 w=1.5u l=0.13u
MN2790 (storage2781 rst vss vss) n12 w=2u l=0.13u
MN2792 (qm2778 clk_high900 storage2791 vss) n12 w=1.2u l=0.13u
MP2793 (qm2778 clk_highb901 storage2791 vdd) p12 w=3.6u l=0.13u
MN2794 (one_sync1_5 clk_low898 storage2791 vss) n12 w=1.2u l=0.13u
MP2795 (one_sync1_5 clk_lowb899 storage2791 vdd) p12 w=3.6u l=0.13u
MN2796 (qb2780 storage2791 vss vss) n12 w=0.5u l=0.13u
MP2797 (qb2780 storage2791 vdd vdd) p12 w=1.5u l=0.13u
MN2798 (one_sync1_5 qb2780 vss vss) n12 w=0.5u l=0.13u
MP2799 (one_sync1_5 qb2780 vdd vdd) p12 w=1.5u l=0.13u
MN2800 (storage2791 rst vss vss) n12 w=2u l=0.13u
MN2805 (one_sync1_5 clk_low898 storage2804 vss) n12 w=1.2u l=0.13u
MP2806 (one_sync1_5 clk_lowb899 storage2804 vdd) p12 w=3.6u l=0.13u
MN2807 (qm2801 clk_high900 storage2804 vss) n12 w=1.2u l=0.13u
MP2808 (qm2801 clk_highb901 storage2804 vdd) p12 w=3.6u l=0.13u
MN2809 (qmb2802 storage2804 vss vss) n12 w=0.5u l=0.13u
MP2810 (qmb2802 storage2804 vdd vdd) p12 w=1.5u l=0.13u
MN2811 (qm2801 qmb2802 vss vss) n12 w=0.5u l=0.13u
MP2812 (qm2801 qmb2802 vdd vdd) p12 w=1.5u l=0.13u
MN2813 (storage2804 rst vss vss) n12 w=2u l=0.13u
MN2815 (qm2801 clk_high900 storage2814 vss) n12 w=1.2u l=0.13u
MP2816 (qm2801 clk_highb901 storage2814 vdd) p12 w=3.6u l=0.13u
MN2817 (one_sync2_5 clk_low898 storage2814 vss) n12 w=1.2u l=0.13u
MP2818 (one_sync2_5 clk_lowb899 storage2814 vdd) p12 w=3.6u l=0.13u
MN2819 (qb2803 storage2814 vss vss) n12 w=0.5u l=0.13u
MP2820 (qb2803 storage2814 vdd vdd) p12 w=1.5u l=0.13u
MN2821 (one_sync2_5 qb2803 vss vss) n12 w=0.5u l=0.13u
MP2822 (one_sync2_5 qb2803 vdd vdd) p12 w=1.5u l=0.13u
MN2823 (storage2814 rst vss vss) n12 w=2u l=0.13u
MN2828 (one_g6 clk_low898 storage2827 vss) n12 w=1.2u l=0.13u
MP2829 (one_g6 clk_lowb899 storage2827 vdd) p12 w=3.6u l=0.13u
MN2830 (qm2824 clk_high900 storage2827 vss) n12 w=1.2u l=0.13u
MP2831 (qm2824 clk_highb901 storage2827 vdd) p12 w=3.6u l=0.13u
MN2832 (qmb2825 storage2827 vss vss) n12 w=0.5u l=0.13u
MP2833 (qmb2825 storage2827 vdd vdd) p12 w=1.5u l=0.13u
MN2834 (qm2824 qmb2825 vss vss) n12 w=0.5u l=0.13u
MP2835 (qm2824 qmb2825 vdd vdd) p12 w=1.5u l=0.13u
MN2836 (storage2827 rst vss vss) n12 w=2u l=0.13u
MN2838 (qm2824 clk_high900 storage2837 vss) n12 w=1.2u l=0.13u
MP2839 (qm2824 clk_highb901 storage2837 vdd) p12 w=3.6u l=0.13u
MN2840 (one_sync1_6 clk_low898 storage2837 vss) n12 w=1.2u l=0.13u
MP2841 (one_sync1_6 clk_lowb899 storage2837 vdd) p12 w=3.6u l=0.13u
MN2842 (qb2826 storage2837 vss vss) n12 w=0.5u l=0.13u
MP2843 (qb2826 storage2837 vdd vdd) p12 w=1.5u l=0.13u
MN2844 (one_sync1_6 qb2826 vss vss) n12 w=0.5u l=0.13u
MP2845 (one_sync1_6 qb2826 vdd vdd) p12 w=1.5u l=0.13u
MN2846 (storage2837 rst vss vss) n12 w=2u l=0.13u
MN2851 (one_sync1_6 clk_low898 storage2850 vss) n12 w=1.2u l=0.13u
MP2852 (one_sync1_6 clk_lowb899 storage2850 vdd) p12 w=3.6u l=0.13u
MN2853 (qm2847 clk_high900 storage2850 vss) n12 w=1.2u l=0.13u
MP2854 (qm2847 clk_highb901 storage2850 vdd) p12 w=3.6u l=0.13u
MN2855 (qmb2848 storage2850 vss vss) n12 w=0.5u l=0.13u
MP2856 (qmb2848 storage2850 vdd vdd) p12 w=1.5u l=0.13u
MN2857 (qm2847 qmb2848 vss vss) n12 w=0.5u l=0.13u
MP2858 (qm2847 qmb2848 vdd vdd) p12 w=1.5u l=0.13u
MN2859 (storage2850 rst vss vss) n12 w=2u l=0.13u
MN2861 (qm2847 clk_high900 storage2860 vss) n12 w=1.2u l=0.13u
MP2862 (qm2847 clk_highb901 storage2860 vdd) p12 w=3.6u l=0.13u
MN2863 (one_sync2_6 clk_low898 storage2860 vss) n12 w=1.2u l=0.13u
MP2864 (one_sync2_6 clk_lowb899 storage2860 vdd) p12 w=3.6u l=0.13u
MN2865 (qb2849 storage2860 vss vss) n12 w=0.5u l=0.13u
MP2866 (qb2849 storage2860 vdd vdd) p12 w=1.5u l=0.13u
MN2867 (one_sync2_6 qb2849 vss vss) n12 w=0.5u l=0.13u
MP2868 (one_sync2_6 qb2849 vdd vdd) p12 w=1.5u l=0.13u
MN2869 (storage2860 rst vss vss) n12 w=2u l=0.13u
MN2874 (one_g7 clk_low898 storage2873 vss) n12 w=1.2u l=0.13u
MP2875 (one_g7 clk_lowb899 storage2873 vdd) p12 w=3.6u l=0.13u
MN2876 (qm2870 clk_high900 storage2873 vss) n12 w=1.2u l=0.13u
MP2877 (qm2870 clk_highb901 storage2873 vdd) p12 w=3.6u l=0.13u
MN2878 (qmb2871 storage2873 vss vss) n12 w=0.5u l=0.13u
MP2879 (qmb2871 storage2873 vdd vdd) p12 w=1.5u l=0.13u
MN2880 (qm2870 qmb2871 vss vss) n12 w=0.5u l=0.13u
MP2881 (qm2870 qmb2871 vdd vdd) p12 w=1.5u l=0.13u
MN2882 (storage2873 rst vss vss) n12 w=2u l=0.13u
MN2884 (qm2870 clk_high900 storage2883 vss) n12 w=1.2u l=0.13u
MP2885 (qm2870 clk_highb901 storage2883 vdd) p12 w=3.6u l=0.13u
MN2886 (one_sync1_7 clk_low898 storage2883 vss) n12 w=1.2u l=0.13u
MP2887 (one_sync1_7 clk_lowb899 storage2883 vdd) p12 w=3.6u l=0.13u
MN2888 (qb2872 storage2883 vss vss) n12 w=0.5u l=0.13u
MP2889 (qb2872 storage2883 vdd vdd) p12 w=1.5u l=0.13u
MN2890 (one_sync1_7 qb2872 vss vss) n12 w=0.5u l=0.13u
MP2891 (one_sync1_7 qb2872 vdd vdd) p12 w=1.5u l=0.13u
MN2892 (storage2883 rst vss vss) n12 w=2u l=0.13u
MN2897 (one_sync1_7 clk_low898 storage2896 vss) n12 w=1.2u l=0.13u
MP2898 (one_sync1_7 clk_lowb899 storage2896 vdd) p12 w=3.6u l=0.13u
MN2899 (qm2893 clk_high900 storage2896 vss) n12 w=1.2u l=0.13u
MP2900 (qm2893 clk_highb901 storage2896 vdd) p12 w=3.6u l=0.13u
MN2901 (qmb2894 storage2896 vss vss) n12 w=0.5u l=0.13u
MP2902 (qmb2894 storage2896 vdd vdd) p12 w=1.5u l=0.13u
MN2903 (qm2893 qmb2894 vss vss) n12 w=0.5u l=0.13u
MP2904 (qm2893 qmb2894 vdd vdd) p12 w=1.5u l=0.13u
MN2905 (storage2896 rst vss vss) n12 w=2u l=0.13u
MN2907 (qm2893 clk_high900 storage2906 vss) n12 w=1.2u l=0.13u
MP2908 (qm2893 clk_highb901 storage2906 vdd) p12 w=3.6u l=0.13u
MN2909 (one_sync2_7 clk_low898 storage2906 vss) n12 w=1.2u l=0.13u
MP2910 (one_sync2_7 clk_lowb899 storage2906 vdd) p12 w=3.6u l=0.13u
MN2911 (qb2895 storage2906 vss vss) n12 w=0.5u l=0.13u
MP2912 (qb2895 storage2906 vdd vdd) p12 w=1.5u l=0.13u
MN2913 (one_sync2_7 qb2895 vss vss) n12 w=0.5u l=0.13u
MP2914 (one_sync2_7 qb2895 vdd vdd) p12 w=1.5u l=0.13u
MN2915 (storage2906 rst vss vss) n12 w=2u l=0.13u
MN2920 (one_g8 clk_low898 storage2919 vss) n12 w=1.2u l=0.13u
MP2921 (one_g8 clk_lowb899 storage2919 vdd) p12 w=3.6u l=0.13u
MN2922 (qm2916 clk_high900 storage2919 vss) n12 w=1.2u l=0.13u
MP2923 (qm2916 clk_highb901 storage2919 vdd) p12 w=3.6u l=0.13u
MN2924 (qmb2917 storage2919 vss vss) n12 w=0.5u l=0.13u
MP2925 (qmb2917 storage2919 vdd vdd) p12 w=1.5u l=0.13u
MN2926 (qm2916 qmb2917 vss vss) n12 w=0.5u l=0.13u
MP2927 (qm2916 qmb2917 vdd vdd) p12 w=1.5u l=0.13u
MN2928 (storage2919 rst vss vss) n12 w=2u l=0.13u
MN2930 (qm2916 clk_high900 storage2929 vss) n12 w=1.2u l=0.13u
MP2931 (qm2916 clk_highb901 storage2929 vdd) p12 w=3.6u l=0.13u
MN2932 (one_sync1_8 clk_low898 storage2929 vss) n12 w=1.2u l=0.13u
MP2933 (one_sync1_8 clk_lowb899 storage2929 vdd) p12 w=3.6u l=0.13u
MN2934 (qb2918 storage2929 vss vss) n12 w=0.5u l=0.13u
MP2935 (qb2918 storage2929 vdd vdd) p12 w=1.5u l=0.13u
MN2936 (one_sync1_8 qb2918 vss vss) n12 w=0.5u l=0.13u
MP2937 (one_sync1_8 qb2918 vdd vdd) p12 w=1.5u l=0.13u
MN2938 (storage2929 rst vss vss) n12 w=2u l=0.13u
MN2943 (one_sync1_8 clk_low898 storage2942 vss) n12 w=1.2u l=0.13u
MP2944 (one_sync1_8 clk_lowb899 storage2942 vdd) p12 w=3.6u l=0.13u
MN2945 (qm2939 clk_high900 storage2942 vss) n12 w=1.2u l=0.13u
MP2946 (qm2939 clk_highb901 storage2942 vdd) p12 w=3.6u l=0.13u
MN2947 (qmb2940 storage2942 vss vss) n12 w=0.5u l=0.13u
MP2948 (qmb2940 storage2942 vdd vdd) p12 w=1.5u l=0.13u
MN2949 (qm2939 qmb2940 vss vss) n12 w=0.5u l=0.13u
MP2950 (qm2939 qmb2940 vdd vdd) p12 w=1.5u l=0.13u
MN2951 (storage2942 rst vss vss) n12 w=2u l=0.13u
MN2953 (qm2939 clk_high900 storage2952 vss) n12 w=1.2u l=0.13u
MP2954 (qm2939 clk_highb901 storage2952 vdd) p12 w=3.6u l=0.13u
MN2955 (one_sync2_8 clk_low898 storage2952 vss) n12 w=1.2u l=0.13u
MP2956 (one_sync2_8 clk_lowb899 storage2952 vdd) p12 w=3.6u l=0.13u
MN2957 (qb2941 storage2952 vss vss) n12 w=0.5u l=0.13u
MP2958 (qb2941 storage2952 vdd vdd) p12 w=1.5u l=0.13u
MN2959 (one_sync2_8 qb2941 vss vss) n12 w=0.5u l=0.13u
MP2960 (one_sync2_8 qb2941 vdd vdd) p12 w=1.5u l=0.13u
MN2961 (storage2952 rst vss vss) n12 w=2u l=0.13u
MN2963 (n2962 n1927 vss vss) n12 w=0.8u l=0.13u
MP2964 (n2962 n1927 vdd vdd) p12 w=2.4u l=0.13u
MN2966 (n2965 n2962 vss vss) n12 w=0.8u l=0.13u
MP2967 (n2965 n2962 vdd vdd) p12 w=2.4u l=0.13u
MN2968 (one_native_b0 n2965 vss vss) n12 w=0.8u l=0.13u
MP2969 (one_native_b0 n2965 vdd vdd) p12 w=2.4u l=0.13u
MN2971 (n2970 n1897 vss vss) n12 w=0.8u l=0.13u
MP2972 (n2970 n1897 vdd vdd) p12 w=2.4u l=0.13u
MN2974 (n2973 n2970 vss vss) n12 w=0.8u l=0.13u
MP2975 (n2973 n2970 vdd vdd) p12 w=2.4u l=0.13u
MN2977 (n2976 n2973 vss vss) n12 w=0.8u l=0.13u
MP2978 (n2976 n2973 vdd vdd) p12 w=2.4u l=0.13u
MN2979 (one_native_b1 n2976 vss vss) n12 w=0.8u l=0.13u
MP2980 (one_native_b1 n2976 vdd vdd) p12 w=2.4u l=0.13u
MN2982 (n2981 n1873 vss vss) n12 w=0.8u l=0.13u
MP2983 (n2981 n1873 vdd vdd) p12 w=2.4u l=0.13u
MN2985 (n2984 n2981 vss vss) n12 w=0.8u l=0.13u
MP2986 (n2984 n2981 vdd vdd) p12 w=2.4u l=0.13u
MN2988 (n2987 n2984 vss vss) n12 w=0.8u l=0.13u
MP2989 (n2987 n2984 vdd vdd) p12 w=2.4u l=0.13u
MN2990 (one_native_b2 n2987 vss vss) n12 w=0.8u l=0.13u
MP2991 (one_native_b2 n2987 vdd vdd) p12 w=2.4u l=0.13u
MN2993 (n2992 n1849 vss vss) n12 w=0.8u l=0.13u
MP2994 (n2992 n1849 vdd vdd) p12 w=2.4u l=0.13u
MN2996 (n2995 n2992 vss vss) n12 w=0.8u l=0.13u
MP2997 (n2995 n2992 vdd vdd) p12 w=2.4u l=0.13u
MN2999 (n2998 n2995 vss vss) n12 w=0.8u l=0.13u
MP3000 (n2998 n2995 vdd vdd) p12 w=2.4u l=0.13u
MN3001 (one_native_b3 n2998 vss vss) n12 w=0.8u l=0.13u
MP3002 (one_native_b3 n2998 vdd vdd) p12 w=2.4u l=0.13u
MN3004 (n3003 n1825 vss vss) n12 w=0.8u l=0.13u
MP3005 (n3003 n1825 vdd vdd) p12 w=2.4u l=0.13u
MN3007 (n3006 n3003 vss vss) n12 w=0.8u l=0.13u
MP3008 (n3006 n3003 vdd vdd) p12 w=2.4u l=0.13u
MN3010 (n3009 n3006 vss vss) n12 w=0.8u l=0.13u
MP3011 (n3009 n3006 vdd vdd) p12 w=2.4u l=0.13u
MN3012 (one_native_b4 n3009 vss vss) n12 w=0.8u l=0.13u
MP3013 (one_native_b4 n3009 vdd vdd) p12 w=2.4u l=0.13u
MN3015 (n3014 n1801 vss vss) n12 w=0.8u l=0.13u
MP3016 (n3014 n1801 vdd vdd) p12 w=2.4u l=0.13u
MN3018 (n3017 n3014 vss vss) n12 w=0.8u l=0.13u
MP3019 (n3017 n3014 vdd vdd) p12 w=2.4u l=0.13u
MN3021 (n3020 n3017 vss vss) n12 w=0.8u l=0.13u
MP3022 (n3020 n3017 vdd vdd) p12 w=2.4u l=0.13u
MN3023 (one_native_b5 n3020 vss vss) n12 w=0.8u l=0.13u
MP3024 (one_native_b5 n3020 vdd vdd) p12 w=2.4u l=0.13u
MN3026 (n3025 n1777 vss vss) n12 w=0.8u l=0.13u
MP3027 (n3025 n1777 vdd vdd) p12 w=2.4u l=0.13u
MN3029 (n3028 n3025 vss vss) n12 w=0.8u l=0.13u
MP3030 (n3028 n3025 vdd vdd) p12 w=2.4u l=0.13u
MN3032 (n3031 n3028 vss vss) n12 w=0.8u l=0.13u
MP3033 (n3031 n3028 vdd vdd) p12 w=2.4u l=0.13u
MN3034 (one_native_b6 n3031 vss vss) n12 w=0.8u l=0.13u
MP3035 (one_native_b6 n3031 vdd vdd) p12 w=2.4u l=0.13u
MN3037 (n3036 n1753 vss vss) n12 w=0.8u l=0.13u
MP3038 (n3036 n1753 vdd vdd) p12 w=2.4u l=0.13u
MN3040 (n3039 n3036 vss vss) n12 w=0.8u l=0.13u
MP3041 (n3039 n3036 vdd vdd) p12 w=2.4u l=0.13u
MN3043 (n3042 n3039 vss vss) n12 w=0.8u l=0.13u
MP3044 (n3042 n3039 vdd vdd) p12 w=2.4u l=0.13u
MN3045 (one_native_b7 n3042 vss vss) n12 w=0.8u l=0.13u
MP3046 (one_native_b7 n3042 vdd vdd) p12 w=2.4u l=0.13u
MN3048 (n3047 one_g8 vss vss) n12 w=0.8u l=0.13u
MP3049 (n3047 one_g8 vdd vdd) p12 w=2.4u l=0.13u
MN3051 (n3050 n3047 vss vss) n12 w=0.8u l=0.13u
MP3052 (n3050 n3047 vdd vdd) p12 w=2.4u l=0.13u
MN3054 (n3053 n3050 vss vss) n12 w=0.8u l=0.13u
MP3055 (n3053 n3050 vdd vdd) p12 w=2.4u l=0.13u
MN3056 (one_native_b8 n3053 vss vss) n12 w=0.8u l=0.13u
MP3057 (one_native_b8 n3053 vdd vdd) p12 w=2.4u l=0.13u
MN3060 (n3058 one_sync2_7 n3059 vss) n12 w=1.6u l=0.13u
MN3061 (n3059 one_sync2_8 vss vss) n12 w=1.6u l=0.13u
MP3062 (n3058 one_sync2_7 vdd vdd) p12 w=2.4u l=0.13u
MP3063 (n3058 one_sync2_8 vdd vdd) p12 w=2.4u l=0.13u
MN3066 (n3064 n3058 n3065 vss) n12 w=1.6u l=0.13u
MN3067 (n3065 one_sync2_7 vss vss) n12 w=1.6u l=0.13u
MP3068 (n3064 n3058 vdd vdd) p12 w=2.4u l=0.13u
MP3069 (n3064 one_sync2_7 vdd vdd) p12 w=2.4u l=0.13u
MN3072 (n3070 n3058 n3071 vss) n12 w=1.6u l=0.13u
MN3073 (n3071 one_sync2_8 vss vss) n12 w=1.6u l=0.13u
MP3074 (n3070 n3058 vdd vdd) p12 w=2.4u l=0.13u
MP3075 (n3070 one_sync2_8 vdd vdd) p12 w=2.4u l=0.13u
MN3078 (n3076 n3064 n3077 vss) n12 w=1.6u l=0.13u
MN3079 (n3077 n3070 vss vss) n12 w=1.6u l=0.13u
MP3080 (n3076 n3064 vdd vdd) p12 w=2.4u l=0.13u
MP3081 (n3076 n3070 vdd vdd) p12 w=2.4u l=0.13u
MN3084 (n3082 n3076 n3083 vss) n12 w=1.6u l=0.13u
MN3085 (n3083 one_sync2_6 vss vss) n12 w=1.6u l=0.13u
MP3086 (n3082 n3076 vdd vdd) p12 w=2.4u l=0.13u
MP3087 (n3082 one_sync2_6 vdd vdd) p12 w=2.4u l=0.13u
MN3090 (n3088 n3076 n3089 vss) n12 w=1.6u l=0.13u
MN3091 (n3089 n3082 vss vss) n12 w=1.6u l=0.13u
MP3092 (n3088 n3076 vdd vdd) p12 w=2.4u l=0.13u
MP3093 (n3088 n3082 vdd vdd) p12 w=2.4u l=0.13u
MN3096 (n3094 n3082 n3095 vss) n12 w=1.6u l=0.13u
MN3097 (n3095 one_sync2_6 vss vss) n12 w=1.6u l=0.13u
MP3098 (n3094 n3082 vdd vdd) p12 w=2.4u l=0.13u
MP3099 (n3094 one_sync2_6 vdd vdd) p12 w=2.4u l=0.13u
MN3102 (n3100 n3088 n3101 vss) n12 w=1.6u l=0.13u
MN3103 (n3101 n3094 vss vss) n12 w=1.6u l=0.13u
MP3104 (n3100 n3088 vdd vdd) p12 w=2.4u l=0.13u
MP3105 (n3100 n3094 vdd vdd) p12 w=2.4u l=0.13u
MN3108 (n3106 n3100 n3107 vss) n12 w=1.6u l=0.13u
MN3109 (n3107 one_sync2_5 vss vss) n12 w=1.6u l=0.13u
MP3110 (n3106 n3100 vdd vdd) p12 w=2.4u l=0.13u
MP3111 (n3106 one_sync2_5 vdd vdd) p12 w=2.4u l=0.13u
MN3114 (n3112 n3100 n3113 vss) n12 w=1.6u l=0.13u
MN3115 (n3113 n3106 vss vss) n12 w=1.6u l=0.13u
MP3116 (n3112 n3100 vdd vdd) p12 w=2.4u l=0.13u
MP3117 (n3112 n3106 vdd vdd) p12 w=2.4u l=0.13u
MN3120 (n3118 n3106 n3119 vss) n12 w=1.6u l=0.13u
MN3121 (n3119 one_sync2_5 vss vss) n12 w=1.6u l=0.13u
MP3122 (n3118 n3106 vdd vdd) p12 w=2.4u l=0.13u
MP3123 (n3118 one_sync2_5 vdd vdd) p12 w=2.4u l=0.13u
MN3126 (n3124 n3112 n3125 vss) n12 w=1.6u l=0.13u
MN3127 (n3125 n3118 vss vss) n12 w=1.6u l=0.13u
MP3128 (n3124 n3112 vdd vdd) p12 w=2.4u l=0.13u
MP3129 (n3124 n3118 vdd vdd) p12 w=2.4u l=0.13u
MN3132 (n3130 n3124 n3131 vss) n12 w=1.6u l=0.13u
MN3133 (n3131 one_sync2_4 vss vss) n12 w=1.6u l=0.13u
MP3134 (n3130 n3124 vdd vdd) p12 w=2.4u l=0.13u
MP3135 (n3130 one_sync2_4 vdd vdd) p12 w=2.4u l=0.13u
MN3138 (n3136 n3124 n3137 vss) n12 w=1.6u l=0.13u
MN3139 (n3137 n3130 vss vss) n12 w=1.6u l=0.13u
MP3140 (n3136 n3124 vdd vdd) p12 w=2.4u l=0.13u
MP3141 (n3136 n3130 vdd vdd) p12 w=2.4u l=0.13u
MN3144 (n3142 n3130 n3143 vss) n12 w=1.6u l=0.13u
MN3145 (n3143 one_sync2_4 vss vss) n12 w=1.6u l=0.13u
MP3146 (n3142 n3130 vdd vdd) p12 w=2.4u l=0.13u
MP3147 (n3142 one_sync2_4 vdd vdd) p12 w=2.4u l=0.13u
MN3150 (n3148 n3136 n3149 vss) n12 w=1.6u l=0.13u
MN3151 (n3149 n3142 vss vss) n12 w=1.6u l=0.13u
MP3152 (n3148 n3136 vdd vdd) p12 w=2.4u l=0.13u
MP3153 (n3148 n3142 vdd vdd) p12 w=2.4u l=0.13u
MN3156 (n3154 n3148 n3155 vss) n12 w=1.6u l=0.13u
MN3157 (n3155 one_sync2_3 vss vss) n12 w=1.6u l=0.13u
MP3158 (n3154 n3148 vdd vdd) p12 w=2.4u l=0.13u
MP3159 (n3154 one_sync2_3 vdd vdd) p12 w=2.4u l=0.13u
MN3162 (n3160 n3148 n3161 vss) n12 w=1.6u l=0.13u
MN3163 (n3161 n3154 vss vss) n12 w=1.6u l=0.13u
MP3164 (n3160 n3148 vdd vdd) p12 w=2.4u l=0.13u
MP3165 (n3160 n3154 vdd vdd) p12 w=2.4u l=0.13u
MN3168 (n3166 n3154 n3167 vss) n12 w=1.6u l=0.13u
MN3169 (n3167 one_sync2_3 vss vss) n12 w=1.6u l=0.13u
MP3170 (n3166 n3154 vdd vdd) p12 w=2.4u l=0.13u
MP3171 (n3166 one_sync2_3 vdd vdd) p12 w=2.4u l=0.13u
MN3174 (n3172 n3160 n3173 vss) n12 w=1.6u l=0.13u
MN3175 (n3173 n3166 vss vss) n12 w=1.6u l=0.13u
MP3176 (n3172 n3160 vdd vdd) p12 w=2.4u l=0.13u
MP3177 (n3172 n3166 vdd vdd) p12 w=2.4u l=0.13u
MN3180 (n3178 n3172 n3179 vss) n12 w=1.6u l=0.13u
MN3181 (n3179 one_sync2_2 vss vss) n12 w=1.6u l=0.13u
MP3182 (n3178 n3172 vdd vdd) p12 w=2.4u l=0.13u
MP3183 (n3178 one_sync2_2 vdd vdd) p12 w=2.4u l=0.13u
MN3186 (n3184 n3172 n3185 vss) n12 w=1.6u l=0.13u
MN3187 (n3185 n3178 vss vss) n12 w=1.6u l=0.13u
MP3188 (n3184 n3172 vdd vdd) p12 w=2.4u l=0.13u
MP3189 (n3184 n3178 vdd vdd) p12 w=2.4u l=0.13u
MN3192 (n3190 n3178 n3191 vss) n12 w=1.6u l=0.13u
MN3193 (n3191 one_sync2_2 vss vss) n12 w=1.6u l=0.13u
MP3194 (n3190 n3178 vdd vdd) p12 w=2.4u l=0.13u
MP3195 (n3190 one_sync2_2 vdd vdd) p12 w=2.4u l=0.13u
MN3198 (n3196 n3184 n3197 vss) n12 w=1.6u l=0.13u
MN3199 (n3197 n3190 vss vss) n12 w=1.6u l=0.13u
MP3200 (n3196 n3184 vdd vdd) p12 w=2.4u l=0.13u
MP3201 (n3196 n3190 vdd vdd) p12 w=2.4u l=0.13u
MN3204 (n3202 n3196 n3203 vss) n12 w=1.6u l=0.13u
MN3205 (n3203 one_sync2_1 vss vss) n12 w=1.6u l=0.13u
MP3206 (n3202 n3196 vdd vdd) p12 w=2.4u l=0.13u
MP3207 (n3202 one_sync2_1 vdd vdd) p12 w=2.4u l=0.13u
MN3210 (n3208 n3196 n3209 vss) n12 w=1.6u l=0.13u
MN3211 (n3209 n3202 vss vss) n12 w=1.6u l=0.13u
MP3212 (n3208 n3196 vdd vdd) p12 w=2.4u l=0.13u
MP3213 (n3208 n3202 vdd vdd) p12 w=2.4u l=0.13u
MN3216 (n3214 n3202 n3215 vss) n12 w=1.6u l=0.13u
MN3217 (n3215 one_sync2_1 vss vss) n12 w=1.6u l=0.13u
MP3218 (n3214 n3202 vdd vdd) p12 w=2.4u l=0.13u
MP3219 (n3214 one_sync2_1 vdd vdd) p12 w=2.4u l=0.13u
MN3222 (n3220 n3208 n3221 vss) n12 w=1.6u l=0.13u
MN3223 (n3221 n3214 vss vss) n12 w=1.6u l=0.13u
MP3224 (n3220 n3208 vdd vdd) p12 w=2.4u l=0.13u
MP3225 (n3220 n3214 vdd vdd) p12 w=2.4u l=0.13u
MN3228 (n3226 n3220 n3227 vss) n12 w=1.6u l=0.13u
MN3229 (n3227 one_sync2_0 vss vss) n12 w=1.6u l=0.13u
MP3230 (n3226 n3220 vdd vdd) p12 w=2.4u l=0.13u
MP3231 (n3226 one_sync2_0 vdd vdd) p12 w=2.4u l=0.13u
MN3234 (n3232 n3220 n3233 vss) n12 w=1.6u l=0.13u
MN3235 (n3233 n3226 vss vss) n12 w=1.6u l=0.13u
MP3236 (n3232 n3220 vdd vdd) p12 w=2.4u l=0.13u
MP3237 (n3232 n3226 vdd vdd) p12 w=2.4u l=0.13u
MN3240 (n3238 n3226 n3239 vss) n12 w=1.6u l=0.13u
MN3241 (n3239 one_sync2_0 vss vss) n12 w=1.6u l=0.13u
MP3242 (n3238 n3226 vdd vdd) p12 w=2.4u l=0.13u
MP3243 (n3238 one_sync2_0 vdd vdd) p12 w=2.4u l=0.13u
MN3246 (n3244 n3232 n3245 vss) n12 w=1.6u l=0.13u
MN3247 (n3245 n3238 vss vss) n12 w=1.6u l=0.13u
MP3248 (n3244 n3232 vdd vdd) p12 w=2.4u l=0.13u
MP3249 (n3244 n3238 vdd vdd) p12 w=2.4u l=0.13u
MN3251 (n3250 n3244 vss vss) n12 w=0.8u l=0.13u
MP3252 (n3250 n3244 vdd vdd) p12 w=2.4u l=0.13u
MN3254 (n3253 n3250 vss vss) n12 w=0.8u l=0.13u
MP3255 (n3253 n3250 vdd vdd) p12 w=2.4u l=0.13u
MN3257 (n3256 n3253 vss vss) n12 w=0.8u l=0.13u
MP3258 (n3256 n3253 vdd vdd) p12 w=2.4u l=0.13u
MN3259 (one_sync_b0 n3256 vss vss) n12 w=0.8u l=0.13u
MP3260 (one_sync_b0 n3256 vdd vdd) p12 w=2.4u l=0.13u
MN3262 (n3261 n3220 vss vss) n12 w=0.8u l=0.13u
MP3263 (n3261 n3220 vdd vdd) p12 w=2.4u l=0.13u
MN3265 (n3264 n3261 vss vss) n12 w=0.8u l=0.13u
MP3266 (n3264 n3261 vdd vdd) p12 w=2.4u l=0.13u
MN3268 (n3267 n3264 vss vss) n12 w=0.8u l=0.13u
MP3269 (n3267 n3264 vdd vdd) p12 w=2.4u l=0.13u
MN3270 (one_sync_b1 n3267 vss vss) n12 w=0.8u l=0.13u
MP3271 (one_sync_b1 n3267 vdd vdd) p12 w=2.4u l=0.13u
MN3273 (n3272 n3196 vss vss) n12 w=0.8u l=0.13u
MP3274 (n3272 n3196 vdd vdd) p12 w=2.4u l=0.13u
MN3276 (n3275 n3272 vss vss) n12 w=0.8u l=0.13u
MP3277 (n3275 n3272 vdd vdd) p12 w=2.4u l=0.13u
MN3279 (n3278 n3275 vss vss) n12 w=0.8u l=0.13u
MP3280 (n3278 n3275 vdd vdd) p12 w=2.4u l=0.13u
MN3281 (one_sync_b2 n3278 vss vss) n12 w=0.8u l=0.13u
MP3282 (one_sync_b2 n3278 vdd vdd) p12 w=2.4u l=0.13u
MN3284 (n3283 n3172 vss vss) n12 w=0.8u l=0.13u
MP3285 (n3283 n3172 vdd vdd) p12 w=2.4u l=0.13u
MN3287 (n3286 n3283 vss vss) n12 w=0.8u l=0.13u
MP3288 (n3286 n3283 vdd vdd) p12 w=2.4u l=0.13u
MN3290 (n3289 n3286 vss vss) n12 w=0.8u l=0.13u
MP3291 (n3289 n3286 vdd vdd) p12 w=2.4u l=0.13u
MN3292 (one_sync_b3 n3289 vss vss) n12 w=0.8u l=0.13u
MP3293 (one_sync_b3 n3289 vdd vdd) p12 w=2.4u l=0.13u
MN3295 (n3294 n3148 vss vss) n12 w=0.8u l=0.13u
MP3296 (n3294 n3148 vdd vdd) p12 w=2.4u l=0.13u
MN3298 (n3297 n3294 vss vss) n12 w=0.8u l=0.13u
MP3299 (n3297 n3294 vdd vdd) p12 w=2.4u l=0.13u
MN3301 (n3300 n3297 vss vss) n12 w=0.8u l=0.13u
MP3302 (n3300 n3297 vdd vdd) p12 w=2.4u l=0.13u
MN3303 (one_sync_b4 n3300 vss vss) n12 w=0.8u l=0.13u
MP3304 (one_sync_b4 n3300 vdd vdd) p12 w=2.4u l=0.13u
MN3306 (n3305 n3124 vss vss) n12 w=0.8u l=0.13u
MP3307 (n3305 n3124 vdd vdd) p12 w=2.4u l=0.13u
MN3309 (n3308 n3305 vss vss) n12 w=0.8u l=0.13u
MP3310 (n3308 n3305 vdd vdd) p12 w=2.4u l=0.13u
MN3312 (n3311 n3308 vss vss) n12 w=0.8u l=0.13u
MP3313 (n3311 n3308 vdd vdd) p12 w=2.4u l=0.13u
MN3314 (one_sync_b5 n3311 vss vss) n12 w=0.8u l=0.13u
MP3315 (one_sync_b5 n3311 vdd vdd) p12 w=2.4u l=0.13u
MN3317 (n3316 n3100 vss vss) n12 w=0.8u l=0.13u
MP3318 (n3316 n3100 vdd vdd) p12 w=2.4u l=0.13u
MN3320 (n3319 n3316 vss vss) n12 w=0.8u l=0.13u
MP3321 (n3319 n3316 vdd vdd) p12 w=2.4u l=0.13u
MN3323 (n3322 n3319 vss vss) n12 w=0.8u l=0.13u
MP3324 (n3322 n3319 vdd vdd) p12 w=2.4u l=0.13u
MN3325 (one_sync_b6 n3322 vss vss) n12 w=0.8u l=0.13u
MP3326 (one_sync_b6 n3322 vdd vdd) p12 w=2.4u l=0.13u
MN3328 (n3327 n3076 vss vss) n12 w=0.8u l=0.13u
MP3329 (n3327 n3076 vdd vdd) p12 w=2.4u l=0.13u
MN3331 (n3330 n3327 vss vss) n12 w=0.8u l=0.13u
MP3332 (n3330 n3327 vdd vdd) p12 w=2.4u l=0.13u
MN3334 (n3333 n3330 vss vss) n12 w=0.8u l=0.13u
MP3335 (n3333 n3330 vdd vdd) p12 w=2.4u l=0.13u
MN3336 (one_sync_b7 n3333 vss vss) n12 w=0.8u l=0.13u
MP3337 (one_sync_b7 n3333 vdd vdd) p12 w=2.4u l=0.13u
MN3339 (n3338 one_sync2_8 vss vss) n12 w=0.8u l=0.13u
MP3340 (n3338 one_sync2_8 vdd vdd) p12 w=2.4u l=0.13u
MN3342 (n3341 n3338 vss vss) n12 w=0.8u l=0.13u
MP3343 (n3341 n3338 vdd vdd) p12 w=2.4u l=0.13u
MN3345 (n3344 n3341 vss vss) n12 w=0.8u l=0.13u
MP3346 (n3344 n3341 vdd vdd) p12 w=2.4u l=0.13u
MN3347 (one_sync_b8 n3344 vss vss) n12 w=0.8u l=0.13u
MP3348 (one_sync_b8 n3344 vdd vdd) p12 w=2.4u l=0.13u
ends counter9_gray_cdc_mos
