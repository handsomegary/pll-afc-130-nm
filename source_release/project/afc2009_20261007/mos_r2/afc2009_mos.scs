// GENERATED transistor-only static-CMOS AFC: Jeong2009-inspired first-edge phase bracket.
// R2 OFFLINE PREPARED:9bitnativeGray/CDC/snapshots,lag224/globalepochage248.
// RetainsR1 non-overlap interlocked clock controls and frozen-DRAIN counters.
// NOT the selectedphysicalimplementation; electricallyunverified.
// All state physical TG DFFs, all compare/control staticMOS gates, no VA.
// REF100MHz, FB=VCO/32, positive frequency/code polarity; vdd=1.2V.
// VDD/VSS body rails; n12/p12 ordinary tt models required in top-level.
// Phase selector reset-release16physicalINV guard is not timing-signoff.
simulator lang=spectre
subckt afc2009_mos (vdd vss ref fb rst start s0 s1 s2 s3 s4 done fail hold fine_enable pfd_reset active)
MN3 (n1 fail vss vss) n12 w=0.8u l=0.13u
MN4 (n1 fine_enable vss vss) n12 w=0.8u l=0.13u
MP5 (n1 fail n2 vdd) p12 w=4.8u l=0.13u
MP6 (n2 fine_enable vdd vdd) p12 w=4.8u l=0.13u
MN8 (n7 n1 vss vss) n12 w=0.8u l=0.13u
MP9 (n7 n1 vdd vdd) p12 w=2.4u l=0.13u
MN11 (n10 n7 vss vss) n12 w=0.8u l=0.13u
MP12 (n10 n7 vdd vdd) p12 w=2.4u l=0.13u
MN15 (n13 n10 n14 vss) n12 w=1.6u l=0.13u
MN16 (n14 ref vss vss) n12 w=1.6u l=0.13u
MP17 (n13 n10 vdd vdd) p12 w=2.4u l=0.13u
MP18 (n13 ref vdd vdd) p12 w=2.4u l=0.13u
MN20 (n19 n13 vss vss) n12 w=0.8u l=0.13u
MP21 (n19 n13 vdd vdd) p12 w=2.4u l=0.13u
MN23 (n22 n19 vss vss) n12 w=0.8u l=0.13u
MP24 (n22 n19 vdd vdd) p12 w=2.4u l=0.13u
MN26 (n25 n22 vss vss) n12 w=0.8u l=0.13u
MP27 (n25 n22 vdd vdd) p12 w=2.4u l=0.13u
MN29 (n28 n25 vss vss) n12 w=0.8u l=0.13u
MP30 (n28 n25 vdd vdd) p12 w=2.4u l=0.13u
MN31 (control_clock n28 vss vss) n12 w=0.8u l=0.13u
MP32 (control_clock n28 vdd vdd) p12 w=2.4u l=0.13u
MN34 (n33 started vss vss) n12 w=0.8u l=0.13u
MP35 (n33 started vdd vdd) p12 w=2.4u l=0.13u
MN37 (n36 done vss vss) n12 w=0.8u l=0.13u
MP38 (n36 done vdd vdd) p12 w=2.4u l=0.13u
MN40 (n39 fail vss vss) n12 w=0.8u l=0.13u
MP41 (n39 fail vdd vdd) p12 w=2.4u l=0.13u
MN44 (n42 n33 n43 vss) n12 w=1.6u l=0.13u
MN45 (n43 start vss vss) n12 w=1.6u l=0.13u
MP46 (n42 n33 vdd vdd) p12 w=2.4u l=0.13u
MP47 (n42 start vdd vdd) p12 w=2.4u l=0.13u
MN49 (n48 n42 vss vss) n12 w=0.8u l=0.13u
MP50 (n48 n42 vdd vdd) p12 w=2.4u l=0.13u
MN53 (n51 n36 n52 vss) n12 w=1.6u l=0.13u
MN54 (n52 n39 vss vss) n12 w=1.6u l=0.13u
MP55 (n51 n36 vdd vdd) p12 w=2.4u l=0.13u
MP56 (n51 n39 vdd vdd) p12 w=2.4u l=0.13u
MN58 (n57 n51 vss vss) n12 w=0.8u l=0.13u
MP59 (n57 n51 vdd vdd) p12 w=2.4u l=0.13u
MN62 (n60 n48 n61 vss) n12 w=1.6u l=0.13u
MN63 (n61 n57 vss vss) n12 w=1.6u l=0.13u
MP64 (n60 n48 vdd vdd) p12 w=2.4u l=0.13u
MP65 (n60 n57 vdd vdd) p12 w=2.4u l=0.13u
MN67 (n66 n60 vss vss) n12 w=0.8u l=0.13u
MP68 (n66 n60 vdd vdd) p12 w=2.4u l=0.13u
MN70 (n69 n66 vss vss) n12 w=0.8u l=0.13u
MP71 (n69 n66 vdd vdd) p12 w=2.4u l=0.13u
MN74 (n72 n69 n73 vss) n12 w=1.6u l=0.13u
MN75 (n73 started vss vss) n12 w=1.6u l=0.13u
MP76 (n72 n69 vdd vdd) p12 w=2.4u l=0.13u
MP77 (n72 started vdd vdd) p12 w=2.4u l=0.13u
MN80 (n78 n69 n79 vss) n12 w=1.6u l=0.13u
MN81 (n79 n72 vss vss) n12 w=1.6u l=0.13u
MP82 (n78 n69 vdd vdd) p12 w=2.4u l=0.13u
MP83 (n78 n72 vdd vdd) p12 w=2.4u l=0.13u
MN85 (delay84 n19 vss vss) n12 w=0.8u l=0.13u
MP86 (delay84 n19 vdd vdd) p12 w=2.4u l=0.13u
MN88 (delay87 delay84 vss vss) n12 w=0.8u l=0.13u
MP89 (delay87 delay84 vdd vdd) p12 w=2.4u l=0.13u
MN91 (delay90 delay87 vss vss) n12 w=0.8u l=0.13u
MP92 (delay90 delay87 vdd vdd) p12 w=2.4u l=0.13u
MN94 (delay93 delay90 vss vss) n12 w=0.8u l=0.13u
MP95 (delay93 delay90 vdd vdd) p12 w=2.4u l=0.13u
MN97 (delay96 delay93 vss vss) n12 w=0.8u l=0.13u
MP98 (delay96 delay93 vdd vdd) p12 w=2.4u l=0.13u
MN100 (delay99 delay96 vss vss) n12 w=0.8u l=0.13u
MP101 (delay99 delay96 vdd vdd) p12 w=2.4u l=0.13u
MN103 (n102 delay99 vss vss) n12 w=0.8u l=0.13u
MP104 (n102 delay99 vdd vdd) p12 w=2.4u l=0.13u
MN106 (n105 rst vss vss) n12 w=0.8u l=0.13u
MP107 (n105 rst vdd vdd) p12 w=2.4u l=0.13u
MN116 (n112 n22 n113 vss) n12 w=3.2u l=0.13u
MP117 (n112 n22 vdd vdd) p12 w=2.4u l=0.13u
MN118 (n113 n102 n114 vss) n12 w=3.2u l=0.13u
MP119 (n112 n102 vdd vdd) p12 w=2.4u l=0.13u
MN120 (n114 clk_highb111 n115 vss) n12 w=3.2u l=0.13u
MP121 (n112 clk_highb111 vdd vdd) p12 w=2.4u l=0.13u
MN122 (n115 n105 vss vss) n12 w=3.2u l=0.13u
MP123 (n112 n105 vdd vdd) p12 w=2.4u l=0.13u
MN128 (n124 n19 n125 vss) n12 w=3.2u l=0.13u
MP129 (n124 n19 vdd vdd) p12 w=2.4u l=0.13u
MN130 (n125 delay99 n126 vss) n12 w=3.2u l=0.13u
MP131 (n124 delay99 vdd vdd) p12 w=2.4u l=0.13u
MN132 (n126 clk_lowb109 n127 vss) n12 w=3.2u l=0.13u
MP133 (n124 clk_lowb109 vdd vdd) p12 w=2.4u l=0.13u
MN134 (n127 n105 vss vss) n12 w=3.2u l=0.13u
MP135 (n124 n105 vdd vdd) p12 w=2.4u l=0.13u
MN136 (clk_low108 n112 vss vss) n12 w=8u l=0.13u
MP137 (clk_low108 n112 vdd vdd) p12 w=24u l=0.13u
MN138 (clk_lowb109 clk_low108 vss vss) n12 w=8u l=0.13u
MP139 (clk_lowb109 clk_low108 vdd vdd) p12 w=24u l=0.13u
MN140 (clk_high110 n124 vss vss) n12 w=8u l=0.13u
MP141 (clk_high110 n124 vdd vdd) p12 w=24u l=0.13u
MN142 (clk_highb111 clk_high110 vss vss) n12 w=8u l=0.13u
MP143 (clk_highb111 clk_high110 vdd vdd) p12 w=24u l=0.13u
MN148 (n78 clk_low108 storage147 vss) n12 w=1.2u l=0.13u
MP149 (n78 clk_lowb109 storage147 vdd) p12 w=3.6u l=0.13u
MN150 (qm144 clk_high110 storage147 vss) n12 w=1.2u l=0.13u
MP151 (qm144 clk_highb111 storage147 vdd) p12 w=3.6u l=0.13u
MN152 (qmb145 storage147 vss vss) n12 w=0.5u l=0.13u
MP153 (qmb145 storage147 vdd vdd) p12 w=1.5u l=0.13u
MN154 (qm144 qmb145 vss vss) n12 w=0.5u l=0.13u
MP155 (qm144 qmb145 vdd vdd) p12 w=1.5u l=0.13u
MN156 (storage147 rst vss vss) n12 w=2u l=0.13u
MN158 (qm144 clk_high110 storage157 vss) n12 w=1.2u l=0.13u
MP159 (qm144 clk_highb111 storage157 vdd) p12 w=3.6u l=0.13u
MN160 (started clk_low108 storage157 vss) n12 w=1.2u l=0.13u
MP161 (started clk_lowb109 storage157 vdd) p12 w=3.6u l=0.13u
MN162 (qb146 storage157 vss vss) n12 w=0.5u l=0.13u
MP163 (qb146 storage157 vdd vdd) p12 w=1.5u l=0.13u
MN164 (started qb146 vss vss) n12 w=0.5u l=0.13u
MP165 (started qb146 vdd vdd) p12 w=1.5u l=0.13u
MN166 (storage157 rst vss vss) n12 w=2u l=0.13u
MN169 (n167 arm vss vss) n12 w=0.8u l=0.13u
MN170 (n167 settle vss vss) n12 w=0.8u l=0.13u
MP171 (n167 arm n168 vdd) p12 w=4.8u l=0.13u
MP172 (n168 settle vdd vdd) p12 w=4.8u l=0.13u
MN174 (n173 n167 vss vss) n12 w=0.8u l=0.13u
MP175 (n173 n167 vdd vdd) p12 w=2.4u l=0.13u
MN178 (n176 drain vss vss) n12 w=0.8u l=0.13u
MN179 (n176 measure vss vss) n12 w=0.8u l=0.13u
MP180 (n176 drain n177 vdd) p12 w=4.8u l=0.13u
MP181 (n177 measure vdd vdd) p12 w=4.8u l=0.13u
MN183 (n182 n176 vss vss) n12 w=0.8u l=0.13u
MP184 (n182 n176 vdd vdd) p12 w=2.4u l=0.13u
MN187 (n185 n173 vss vss) n12 w=0.8u l=0.13u
MN188 (n185 n182 vss vss) n12 w=0.8u l=0.13u
MP189 (n185 n173 n186 vdd) p12 w=4.8u l=0.13u
MP190 (n186 n182 vdd vdd) p12 w=4.8u l=0.13u
MN192 (n191 n185 vss vss) n12 w=0.8u l=0.13u
MP193 (n191 n185 vdd vdd) p12 w=2.4u l=0.13u
MN196 (n194 done vss vss) n12 w=0.8u l=0.13u
MN197 (n194 fail vss vss) n12 w=0.8u l=0.13u
MP198 (n194 done n195 vdd) p12 w=4.8u l=0.13u
MP199 (n195 fail vdd vdd) p12 w=4.8u l=0.13u
MN201 (n200 n194 vss vss) n12 w=0.8u l=0.13u
MP202 (n200 n194 vdd vdd) p12 w=2.4u l=0.13u
MN204 (n203 n200 vss vss) n12 w=0.8u l=0.13u
MP205 (n203 n200 vdd vdd) p12 w=2.4u l=0.13u
MN208 (n206 n203 n207 vss) n12 w=1.6u l=0.13u
MN209 (n207 started vss vss) n12 w=1.6u l=0.13u
MP210 (n206 n203 vdd vdd) p12 w=2.4u l=0.13u
MP211 (n206 started vdd vdd) p12 w=2.4u l=0.13u
MN213 (n212 n206 vss vss) n12 w=0.8u l=0.13u
MP214 (n212 n206 vdd vdd) p12 w=2.4u l=0.13u
MN216 (n215 n212 vss vss) n12 w=0.8u l=0.13u
MP217 (n215 n212 vdd vdd) p12 w=2.4u l=0.13u
MN219 (n218 n215 vss vss) n12 w=0.8u l=0.13u
MP220 (n218 n215 vdd vdd) p12 w=2.4u l=0.13u
MN222 (n221 n218 vss vss) n12 w=0.8u l=0.13u
MP223 (n221 n218 vdd vdd) p12 w=2.4u l=0.13u
MN224 (active n221 vss vss) n12 w=0.8u l=0.13u
MP225 (active n221 vdd vdd) p12 w=2.4u l=0.13u
MN227 (delay226 fb vss vss) n12 w=0.8u l=0.13u
MP228 (delay226 fb vdd vdd) p12 w=2.4u l=0.13u
MN230 (delay229 delay226 vss vss) n12 w=0.8u l=0.13u
MP231 (delay229 delay226 vdd vdd) p12 w=2.4u l=0.13u
MN233 (delay232 delay229 vss vss) n12 w=0.8u l=0.13u
MP234 (delay232 delay229 vdd vdd) p12 w=2.4u l=0.13u
MN236 (delay235 delay232 vss vss) n12 w=0.8u l=0.13u
MP237 (delay235 delay232 vdd vdd) p12 w=2.4u l=0.13u
MN239 (delay238 delay235 vss vss) n12 w=0.8u l=0.13u
MP240 (delay238 delay235 vdd vdd) p12 w=2.4u l=0.13u
MN242 (delay241 delay238 vss vss) n12 w=0.8u l=0.13u
MP243 (delay241 delay238 vdd vdd) p12 w=2.4u l=0.13u
MN245 (n244 fb vss vss) n12 w=0.8u l=0.13u
MP246 (n244 fb vdd vdd) p12 w=2.4u l=0.13u
MN248 (n247 delay241 vss vss) n12 w=0.8u l=0.13u
MP249 (n247 delay241 vdd vdd) p12 w=2.4u l=0.13u
MN258 (n254 n244 n255 vss) n12 w=3.2u l=0.13u
MP259 (n254 n244 vdd vdd) p12 w=2.4u l=0.13u
MN260 (n255 n247 n256 vss) n12 w=3.2u l=0.13u
MP261 (n254 n247 vdd vdd) p12 w=2.4u l=0.13u
MN262 (n256 clk_highb253 n257 vss) n12 w=3.2u l=0.13u
MP263 (n254 clk_highb253 vdd vdd) p12 w=2.4u l=0.13u
MN264 (n257 n105 vss vss) n12 w=3.2u l=0.13u
MP265 (n254 n105 vdd vdd) p12 w=2.4u l=0.13u
MN270 (n266 fb n267 vss) n12 w=3.2u l=0.13u
MP271 (n266 fb vdd vdd) p12 w=2.4u l=0.13u
MN272 (n267 delay241 n268 vss) n12 w=3.2u l=0.13u
MP273 (n266 delay241 vdd vdd) p12 w=2.4u l=0.13u
MN274 (n268 clk_lowb251 n269 vss) n12 w=3.2u l=0.13u
MP275 (n266 clk_lowb251 vdd vdd) p12 w=2.4u l=0.13u
MN276 (n269 n105 vss vss) n12 w=3.2u l=0.13u
MP277 (n266 n105 vdd vdd) p12 w=2.4u l=0.13u
MN278 (clk_low250 n254 vss vss) n12 w=8u l=0.13u
MP279 (clk_low250 n254 vdd vdd) p12 w=24u l=0.13u
MN280 (clk_lowb251 clk_low250 vss vss) n12 w=8u l=0.13u
MP281 (clk_lowb251 clk_low250 vdd vdd) p12 w=24u l=0.13u
MN282 (clk_high252 n266 vss vss) n12 w=8u l=0.13u
MP283 (clk_high252 n266 vdd vdd) p12 w=24u l=0.13u
MN284 (clk_highb253 clk_high252 vss vss) n12 w=8u l=0.13u
MP285 (clk_highb253 clk_high252 vdd vdd) p12 w=24u l=0.13u
MN287 (count_run clk_low250 storage286 vss) n12 w=1.2u l=0.13u
MP288 (count_run clk_lowb251 storage286 vdd) p12 w=3.6u l=0.13u
MN289 (fb_clock_enable clk_high252 storage286 vss) n12 w=1.2u l=0.13u
MP290 (fb_clock_enable clk_highb253 storage286 vdd) p12 w=3.6u l=0.13u
MN291 (fb_clock_enableb storage286 vss vss) n12 w=0.5u l=0.13u
MP292 (fb_clock_enableb storage286 vdd vdd) p12 w=1.5u l=0.13u
MN293 (fb_clock_enable fb_clock_enableb vss vss) n12 w=0.5u l=0.13u
MP294 (fb_clock_enable fb_clock_enableb vdd vdd) p12 w=1.5u l=0.13u
MN295 (storage286 rst vss vss) n12 w=2u l=0.13u
MN298 (n296 fb n297 vss) n12 w=1.6u l=0.13u
MN299 (n297 fb_clock_enable vss vss) n12 w=1.6u l=0.13u
MP300 (n296 fb vdd vdd) p12 w=2.4u l=0.13u
MP301 (n296 fb_clock_enable vdd vdd) p12 w=2.4u l=0.13u
MN303 (n302 n296 vss vss) n12 w=0.8u l=0.13u
MP304 (n302 n296 vdd vdd) p12 w=2.4u l=0.13u
MN306 (n305 n302 vss vss) n12 w=0.8u l=0.13u
MP307 (n305 n302 vdd vdd) p12 w=2.4u l=0.13u
MN309 (n308 n305 vss vss) n12 w=0.8u l=0.13u
MP310 (n308 n305 vdd vdd) p12 w=2.4u l=0.13u
MN312 (n311 n308 vss vss) n12 w=0.8u l=0.13u
MP313 (n311 n308 vdd vdd) p12 w=2.4u l=0.13u
MN314 (counter_fb_clock n311 vss vss) n12 w=0.8u l=0.13u
MP315 (counter_fb_clock n311 vdd vdd) p12 w=2.4u l=0.13u
MN317 (delay316 n302 vss vss) n12 w=0.8u l=0.13u
MP318 (delay316 n302 vdd vdd) p12 w=2.4u l=0.13u
MN320 (delay319 delay316 vss vss) n12 w=0.8u l=0.13u
MP321 (delay319 delay316 vdd vdd) p12 w=2.4u l=0.13u
MN323 (delay322 delay319 vss vss) n12 w=0.8u l=0.13u
MP324 (delay322 delay319 vdd vdd) p12 w=2.4u l=0.13u
MN326 (delay325 delay322 vss vss) n12 w=0.8u l=0.13u
MP327 (delay325 delay322 vdd vdd) p12 w=2.4u l=0.13u
MN329 (delay328 delay325 vss vss) n12 w=0.8u l=0.13u
MP330 (delay328 delay325 vdd vdd) p12 w=2.4u l=0.13u
MN332 (delay331 delay328 vss vss) n12 w=0.8u l=0.13u
MP333 (delay331 delay328 vdd vdd) p12 w=2.4u l=0.13u
MN335 (n334 delay331 vss vss) n12 w=0.8u l=0.13u
MP336 (n334 delay331 vdd vdd) p12 w=2.4u l=0.13u
MN338 (n337 count_rst vss vss) n12 w=0.8u l=0.13u
MP339 (n337 count_rst vdd vdd) p12 w=2.4u l=0.13u
MN348 (n344 n305 n345 vss) n12 w=3.2u l=0.13u
MP349 (n344 n305 vdd vdd) p12 w=2.4u l=0.13u
MN350 (n345 n334 n346 vss) n12 w=3.2u l=0.13u
MP351 (n344 n334 vdd vdd) p12 w=2.4u l=0.13u
MN352 (n346 clk_highb343 n347 vss) n12 w=3.2u l=0.13u
MP353 (n344 clk_highb343 vdd vdd) p12 w=2.4u l=0.13u
MN354 (n347 n337 vss vss) n12 w=3.2u l=0.13u
MP355 (n344 n337 vdd vdd) p12 w=2.4u l=0.13u
MN360 (n356 n302 n357 vss) n12 w=3.2u l=0.13u
MP361 (n356 n302 vdd vdd) p12 w=2.4u l=0.13u
MN362 (n357 delay331 n358 vss) n12 w=3.2u l=0.13u
MP363 (n356 delay331 vdd vdd) p12 w=2.4u l=0.13u
MN364 (n358 clk_lowb341 n359 vss) n12 w=3.2u l=0.13u
MP365 (n356 clk_lowb341 vdd vdd) p12 w=2.4u l=0.13u
MN366 (n359 n337 vss vss) n12 w=3.2u l=0.13u
MP367 (n356 n337 vdd vdd) p12 w=2.4u l=0.13u
MN368 (clk_low340 n344 vss vss) n12 w=8u l=0.13u
MP369 (clk_low340 n344 vdd vdd) p12 w=24u l=0.13u
MN370 (clk_lowb341 clk_low340 vss vss) n12 w=8u l=0.13u
MP371 (clk_lowb341 clk_low340 vdd vdd) p12 w=24u l=0.13u
MN372 (clk_high342 n356 vss vss) n12 w=8u l=0.13u
MP373 (clk_high342 n356 vdd vdd) p12 w=24u l=0.13u
MN374 (clk_highb343 clk_high342 vss vss) n12 w=8u l=0.13u
MP375 (clk_highb343 clk_high342 vdd vdd) p12 w=24u l=0.13u
MN380 (vdd clk_low340 storage379 vss) n12 w=1.2u l=0.13u
MP381 (vdd clk_lowb341 storage379 vdd) p12 w=3.6u l=0.13u
MN382 (qm376 clk_high342 storage379 vss) n12 w=1.2u l=0.13u
MP383 (qm376 clk_highb343 storage379 vdd) p12 w=3.6u l=0.13u
MN384 (qmb377 storage379 vss vss) n12 w=0.5u l=0.13u
MP385 (qmb377 storage379 vdd vdd) p12 w=1.5u l=0.13u
MN386 (qm376 qmb377 vss vss) n12 w=0.5u l=0.13u
MP387 (qm376 qmb377 vdd vdd) p12 w=1.5u l=0.13u
MN388 (storage379 count_rst vss vss) n12 w=2u l=0.13u
MN390 (qm376 clk_high342 storage389 vss) n12 w=1.2u l=0.13u
MP391 (qm376 clk_highb343 storage389 vdd) p12 w=3.6u l=0.13u
MN392 (seen clk_low340 storage389 vss) n12 w=1.2u l=0.13u
MP393 (seen clk_lowb341 storage389 vdd) p12 w=3.6u l=0.13u
MN394 (qb378 storage389 vss vss) n12 w=0.5u l=0.13u
MP395 (qb378 storage389 vdd vdd) p12 w=1.5u l=0.13u
MN396 (seen qb378 vss vss) n12 w=0.5u l=0.13u
MP397 (seen qb378 vdd vdd) p12 w=1.5u l=0.13u
MN398 (storage389 count_rst vss vss) n12 w=2u l=0.13u
MN400 (n399 seen vss vss) n12 w=0.8u l=0.13u
MP401 (n399 seen vdd vdd) p12 w=2.4u l=0.13u
MN404 (n402 n399 n403 vss) n12 w=1.6u l=0.13u
MN405 (n403 ref vss vss) n12 w=1.6u l=0.13u
MP406 (n402 n399 vdd vdd) p12 w=2.4u l=0.13u
MP407 (n402 ref vdd vdd) p12 w=2.4u l=0.13u
MN409 (n408 n399 vss vss) n12 w=0.8u l=0.13u
MP410 (n408 n399 vdd vdd) p12 w=2.4u l=0.13u
MN413 (n411 n408 n412 vss) n12 w=1.6u l=0.13u
MN414 (n412 phase vss vss) n12 w=1.6u l=0.13u
MP415 (n411 n408 vdd vdd) p12 w=2.4u l=0.13u
MP416 (n411 phase vdd vdd) p12 w=2.4u l=0.13u
MN419 (n417 n402 n418 vss) n12 w=1.6u l=0.13u
MN420 (n418 n411 vss vss) n12 w=1.6u l=0.13u
MP421 (n417 n402 vdd vdd) p12 w=2.4u l=0.13u
MP422 (n417 n411 vdd vdd) p12 w=2.4u l=0.13u
MN427 (n417 clk_low340 storage426 vss) n12 w=1.2u l=0.13u
MP428 (n417 clk_lowb341 storage426 vdd) p12 w=3.6u l=0.13u
MN429 (qm423 clk_high342 storage426 vss) n12 w=1.2u l=0.13u
MP430 (qm423 clk_highb343 storage426 vdd) p12 w=3.6u l=0.13u
MN431 (qmb424 storage426 vss vss) n12 w=0.5u l=0.13u
MP432 (qmb424 storage426 vdd vdd) p12 w=1.5u l=0.13u
MN433 (qm423 qmb424 vss vss) n12 w=0.5u l=0.13u
MP434 (qm423 qmb424 vdd vdd) p12 w=1.5u l=0.13u
MN435 (storage426 count_rst vss vss) n12 w=2u l=0.13u
MN437 (qm423 clk_high342 storage436 vss) n12 w=1.2u l=0.13u
MP438 (qm423 clk_highb343 storage436 vdd) p12 w=3.6u l=0.13u
MN439 (phase clk_low340 storage436 vss) n12 w=1.2u l=0.13u
MP440 (phase clk_lowb341 storage436 vdd) p12 w=3.6u l=0.13u
MN441 (qb425 storage436 vss vss) n12 w=0.5u l=0.13u
MP442 (qb425 storage436 vdd vdd) p12 w=1.5u l=0.13u
MN443 (phase qb425 vss vss) n12 w=0.5u l=0.13u
MP444 (phase qb425 vdd vdd) p12 w=1.5u l=0.13u
MN445 (storage436 count_rst vss vss) n12 w=2u l=0.13u
MN447 (delay446 seen vss vss) n12 w=0.8u l=0.13u
MP448 (delay446 seen vdd vdd) p12 w=2.4u l=0.13u
MN450 (delay449 delay446 vss vss) n12 w=0.8u l=0.13u
MP451 (delay449 delay446 vdd vdd) p12 w=2.4u l=0.13u
MN453 (delay452 delay449 vss vss) n12 w=0.8u l=0.13u
MP454 (delay452 delay449 vdd vdd) p12 w=2.4u l=0.13u
MN456 (delay455 delay452 vss vss) n12 w=0.8u l=0.13u
MP457 (delay455 delay452 vdd vdd) p12 w=2.4u l=0.13u
MN459 (delay458 delay455 vss vss) n12 w=0.8u l=0.13u
MP460 (delay458 delay455 vdd vdd) p12 w=2.4u l=0.13u
MN462 (delay461 delay458 vss vss) n12 w=0.8u l=0.13u
MP463 (delay461 delay458 vdd vdd) p12 w=2.4u l=0.13u
MN465 (delay464 delay461 vss vss) n12 w=0.8u l=0.13u
MP466 (delay464 delay461 vdd vdd) p12 w=2.4u l=0.13u
MN468 (delay467 delay464 vss vss) n12 w=0.8u l=0.13u
MP469 (delay467 delay464 vdd vdd) p12 w=2.4u l=0.13u
MN471 (delay470 delay467 vss vss) n12 w=0.8u l=0.13u
MP472 (delay470 delay467 vdd vdd) p12 w=2.4u l=0.13u
MN474 (delay473 delay470 vss vss) n12 w=0.8u l=0.13u
MP475 (delay473 delay470 vdd vdd) p12 w=2.4u l=0.13u
MN477 (delay476 delay473 vss vss) n12 w=0.8u l=0.13u
MP478 (delay476 delay473 vdd vdd) p12 w=2.4u l=0.13u
MN480 (delay479 delay476 vss vss) n12 w=0.8u l=0.13u
MP481 (delay479 delay476 vdd vdd) p12 w=2.4u l=0.13u
MN483 (delay482 delay479 vss vss) n12 w=0.8u l=0.13u
MP484 (delay482 delay479 vdd vdd) p12 w=2.4u l=0.13u
MN486 (delay485 delay482 vss vss) n12 w=0.8u l=0.13u
MP487 (delay485 delay482 vdd vdd) p12 w=2.4u l=0.13u
MN489 (delay488 delay485 vss vss) n12 w=0.8u l=0.13u
MP490 (delay488 delay485 vdd vdd) p12 w=2.4u l=0.13u
MN492 (delay491 delay488 vss vss) n12 w=0.8u l=0.13u
MP493 (delay491 delay488 vdd vdd) p12 w=2.4u l=0.13u
MN495 (n494 delay491 vss vss) n12 w=0.8u l=0.13u
MP496 (n494 delay491 vdd vdd) p12 w=2.4u l=0.13u
MN499 (n497 count_rst vss vss) n12 w=0.8u l=0.13u
MN500 (n497 n494 vss vss) n12 w=0.8u l=0.13u
MP501 (n497 count_rst n498 vdd) p12 w=4.8u l=0.13u
MP502 (n498 n494 vdd vdd) p12 w=4.8u l=0.13u
MN504 (n503 n497 vss vss) n12 w=0.8u l=0.13u
MP505 (n503 n497 vdd vdd) p12 w=2.4u l=0.13u
MN507 (n506 n503 vss vss) n12 w=0.8u l=0.13u
MP508 (n506 n503 vdd vdd) p12 w=2.4u l=0.13u
MN510 (n509 n506 vss vss) n12 w=0.8u l=0.13u
MP511 (n509 n506 vdd vdd) p12 w=2.4u l=0.13u
MN513 (n512 n509 vss vss) n12 w=0.8u l=0.13u
MP514 (n512 n509 vdd vdd) p12 w=2.4u l=0.13u
MN515 (reference_count_rst n512 vss vss) n12 w=0.8u l=0.13u
MP516 (reference_count_rst n512 vdd vdd) p12 w=2.4u l=0.13u
MN518 (n517 ref vss vss) n12 w=0.8u l=0.13u
MP519 (n517 ref vdd vdd) p12 w=2.4u l=0.13u
MN522 (n520 phase n521 vss) n12 w=1.6u l=0.13u
MN523 (n521 ref vss vss) n12 w=1.6u l=0.13u
MP524 (n520 phase vdd vdd) p12 w=2.4u l=0.13u
MP525 (n520 ref vdd vdd) p12 w=2.4u l=0.13u
MN527 (n526 phase vss vss) n12 w=0.8u l=0.13u
MP528 (n526 phase vdd vdd) p12 w=2.4u l=0.13u
MN531 (n529 n517 n530 vss) n12 w=1.6u l=0.13u
MN532 (n530 n526 vss vss) n12 w=1.6u l=0.13u
MP533 (n529 n517 vdd vdd) p12 w=2.4u l=0.13u
MP534 (n529 n526 vdd vdd) p12 w=2.4u l=0.13u
MN537 (n535 n520 n536 vss) n12 w=1.6u l=0.13u
MN538 (n536 n529 vss vss) n12 w=1.6u l=0.13u
MP539 (n535 n520 vdd vdd) p12 w=2.4u l=0.13u
MP540 (n535 n529 vdd vdd) p12 w=2.4u l=0.13u
MN543 (n541 n517 n542 vss) n12 w=1.6u l=0.13u
MN544 (n542 phase vss vss) n12 w=1.6u l=0.13u
MP545 (n541 n517 vdd vdd) p12 w=2.4u l=0.13u
MP546 (n541 phase vdd vdd) p12 w=2.4u l=0.13u
MN549 (n547 n526 n548 vss) n12 w=1.6u l=0.13u
MN550 (n548 ref vss vss) n12 w=1.6u l=0.13u
MP551 (n547 n526 vdd vdd) p12 w=2.4u l=0.13u
MP552 (n547 ref vdd vdd) p12 w=2.4u l=0.13u
MN555 (n553 n541 n554 vss) n12 w=1.6u l=0.13u
MN556 (n554 n547 vss vss) n12 w=1.6u l=0.13u
MP557 (n553 n541 vdd vdd) p12 w=2.4u l=0.13u
MP558 (n553 n547 vdd vdd) p12 w=2.4u l=0.13u
MN560 (n559 n535 vss vss) n12 w=0.8u l=0.13u
MP561 (n559 n535 vdd vdd) p12 w=2.4u l=0.13u
MN563 (n562 n559 vss vss) n12 w=0.8u l=0.13u
MP564 (n562 n559 vdd vdd) p12 w=2.4u l=0.13u
MN566 (n565 n562 vss vss) n12 w=0.8u l=0.13u
MP567 (n565 n562 vdd vdd) p12 w=2.4u l=0.13u
MN568 (lead_clock n565 vss vss) n12 w=0.8u l=0.13u
MP569 (lead_clock n565 vdd vdd) p12 w=2.4u l=0.13u
MN571 (n570 n553 vss vss) n12 w=0.8u l=0.13u
MP572 (n570 n553 vdd vdd) p12 w=2.4u l=0.13u
MN574 (n573 n570 vss vss) n12 w=0.8u l=0.13u
MP575 (n573 n570 vdd vdd) p12 w=2.4u l=0.13u
MN577 (n576 n573 vss vss) n12 w=0.8u l=0.13u
MP578 (n576 n573 vdd vdd) p12 w=2.4u l=0.13u
MN579 (lag_clock n576 vss vss) n12 w=0.8u l=0.13u
MP580 (lag_clock n576 vdd vdd) p12 w=2.4u l=0.13u
MN583 (n581 count_run n582 vss) n12 w=1.6u l=0.13u
MN584 (n582 n535 vss vss) n12 w=1.6u l=0.13u
MP585 (n581 count_run vdd vdd) p12 w=2.4u l=0.13u
MP586 (n581 n535 vdd vdd) p12 w=2.4u l=0.13u
MN588 (n587 n581 vss vss) n12 w=0.8u l=0.13u
MP589 (n587 n581 vdd vdd) p12 w=2.4u l=0.13u
MN592 (n590 count_run n591 vss) n12 w=1.6u l=0.13u
MN593 (n591 n553 vss vss) n12 w=1.6u l=0.13u
MP594 (n590 count_run vdd vdd) p12 w=2.4u l=0.13u
MP595 (n590 n553 vdd vdd) p12 w=2.4u l=0.13u
MN597 (n596 n590 vss vss) n12 w=0.8u l=0.13u
MP598 (n596 n590 vdd vdd) p12 w=2.4u l=0.13u
MN601 (n599 lead_g7 n600 vss) n12 w=1.6u l=0.13u
MN602 (n600 lead_g8 vss vss) n12 w=1.6u l=0.13u
MP603 (n599 lead_g7 vdd vdd) p12 w=2.4u l=0.13u
MP604 (n599 lead_g8 vdd vdd) p12 w=2.4u l=0.13u
MN607 (n605 lead_g7 n606 vss) n12 w=1.6u l=0.13u
MN608 (n606 n599 vss vss) n12 w=1.6u l=0.13u
MP609 (n605 lead_g7 vdd vdd) p12 w=2.4u l=0.13u
MP610 (n605 n599 vdd vdd) p12 w=2.4u l=0.13u
MN613 (n611 lead_g8 n612 vss) n12 w=1.6u l=0.13u
MN614 (n612 n599 vss vss) n12 w=1.6u l=0.13u
MP615 (n611 lead_g8 vdd vdd) p12 w=2.4u l=0.13u
MP616 (n611 n599 vdd vdd) p12 w=2.4u l=0.13u
MN619 (n617 n605 n618 vss) n12 w=1.6u l=0.13u
MN620 (n618 n611 vss vss) n12 w=1.6u l=0.13u
MP621 (n617 n605 vdd vdd) p12 w=2.4u l=0.13u
MP622 (n617 n611 vdd vdd) p12 w=2.4u l=0.13u
MN625 (n623 lead_g6 n624 vss) n12 w=1.6u l=0.13u
MN626 (n624 n617 vss vss) n12 w=1.6u l=0.13u
MP627 (n623 lead_g6 vdd vdd) p12 w=2.4u l=0.13u
MP628 (n623 n617 vdd vdd) p12 w=2.4u l=0.13u
MN631 (n629 lead_g6 n630 vss) n12 w=1.6u l=0.13u
MN632 (n630 n623 vss vss) n12 w=1.6u l=0.13u
MP633 (n629 lead_g6 vdd vdd) p12 w=2.4u l=0.13u
MP634 (n629 n623 vdd vdd) p12 w=2.4u l=0.13u
MN637 (n635 n617 n636 vss) n12 w=1.6u l=0.13u
MN638 (n636 n623 vss vss) n12 w=1.6u l=0.13u
MP639 (n635 n617 vdd vdd) p12 w=2.4u l=0.13u
MP640 (n635 n623 vdd vdd) p12 w=2.4u l=0.13u
MN643 (n641 n629 n642 vss) n12 w=1.6u l=0.13u
MN644 (n642 n635 vss vss) n12 w=1.6u l=0.13u
MP645 (n641 n629 vdd vdd) p12 w=2.4u l=0.13u
MP646 (n641 n635 vdd vdd) p12 w=2.4u l=0.13u
MN649 (n647 lead_g5 n648 vss) n12 w=1.6u l=0.13u
MN650 (n648 n641 vss vss) n12 w=1.6u l=0.13u
MP651 (n647 lead_g5 vdd vdd) p12 w=2.4u l=0.13u
MP652 (n647 n641 vdd vdd) p12 w=2.4u l=0.13u
MN655 (n653 lead_g5 n654 vss) n12 w=1.6u l=0.13u
MN656 (n654 n647 vss vss) n12 w=1.6u l=0.13u
MP657 (n653 lead_g5 vdd vdd) p12 w=2.4u l=0.13u
MP658 (n653 n647 vdd vdd) p12 w=2.4u l=0.13u
MN661 (n659 n641 n660 vss) n12 w=1.6u l=0.13u
MN662 (n660 n647 vss vss) n12 w=1.6u l=0.13u
MP663 (n659 n641 vdd vdd) p12 w=2.4u l=0.13u
MP664 (n659 n647 vdd vdd) p12 w=2.4u l=0.13u
MN667 (n665 n653 n666 vss) n12 w=1.6u l=0.13u
MN668 (n666 n659 vss vss) n12 w=1.6u l=0.13u
MP669 (n665 n653 vdd vdd) p12 w=2.4u l=0.13u
MP670 (n665 n659 vdd vdd) p12 w=2.4u l=0.13u
MN673 (n671 lead_g4 n672 vss) n12 w=1.6u l=0.13u
MN674 (n672 n665 vss vss) n12 w=1.6u l=0.13u
MP675 (n671 lead_g4 vdd vdd) p12 w=2.4u l=0.13u
MP676 (n671 n665 vdd vdd) p12 w=2.4u l=0.13u
MN679 (n677 lead_g4 n678 vss) n12 w=1.6u l=0.13u
MN680 (n678 n671 vss vss) n12 w=1.6u l=0.13u
MP681 (n677 lead_g4 vdd vdd) p12 w=2.4u l=0.13u
MP682 (n677 n671 vdd vdd) p12 w=2.4u l=0.13u
MN685 (n683 n665 n684 vss) n12 w=1.6u l=0.13u
MN686 (n684 n671 vss vss) n12 w=1.6u l=0.13u
MP687 (n683 n665 vdd vdd) p12 w=2.4u l=0.13u
MP688 (n683 n671 vdd vdd) p12 w=2.4u l=0.13u
MN691 (n689 n677 n690 vss) n12 w=1.6u l=0.13u
MN692 (n690 n683 vss vss) n12 w=1.6u l=0.13u
MP693 (n689 n677 vdd vdd) p12 w=2.4u l=0.13u
MP694 (n689 n683 vdd vdd) p12 w=2.4u l=0.13u
MN697 (n695 lead_g3 n696 vss) n12 w=1.6u l=0.13u
MN698 (n696 n689 vss vss) n12 w=1.6u l=0.13u
MP699 (n695 lead_g3 vdd vdd) p12 w=2.4u l=0.13u
MP700 (n695 n689 vdd vdd) p12 w=2.4u l=0.13u
MN703 (n701 lead_g3 n702 vss) n12 w=1.6u l=0.13u
MN704 (n702 n695 vss vss) n12 w=1.6u l=0.13u
MP705 (n701 lead_g3 vdd vdd) p12 w=2.4u l=0.13u
MP706 (n701 n695 vdd vdd) p12 w=2.4u l=0.13u
MN709 (n707 n689 n708 vss) n12 w=1.6u l=0.13u
MN710 (n708 n695 vss vss) n12 w=1.6u l=0.13u
MP711 (n707 n689 vdd vdd) p12 w=2.4u l=0.13u
MP712 (n707 n695 vdd vdd) p12 w=2.4u l=0.13u
MN715 (n713 n701 n714 vss) n12 w=1.6u l=0.13u
MN716 (n714 n707 vss vss) n12 w=1.6u l=0.13u
MP717 (n713 n701 vdd vdd) p12 w=2.4u l=0.13u
MP718 (n713 n707 vdd vdd) p12 w=2.4u l=0.13u
MN721 (n719 lead_g2 n720 vss) n12 w=1.6u l=0.13u
MN722 (n720 n713 vss vss) n12 w=1.6u l=0.13u
MP723 (n719 lead_g2 vdd vdd) p12 w=2.4u l=0.13u
MP724 (n719 n713 vdd vdd) p12 w=2.4u l=0.13u
MN727 (n725 lead_g2 n726 vss) n12 w=1.6u l=0.13u
MN728 (n726 n719 vss vss) n12 w=1.6u l=0.13u
MP729 (n725 lead_g2 vdd vdd) p12 w=2.4u l=0.13u
MP730 (n725 n719 vdd vdd) p12 w=2.4u l=0.13u
MN733 (n731 n713 n732 vss) n12 w=1.6u l=0.13u
MN734 (n732 n719 vss vss) n12 w=1.6u l=0.13u
MP735 (n731 n713 vdd vdd) p12 w=2.4u l=0.13u
MP736 (n731 n719 vdd vdd) p12 w=2.4u l=0.13u
MN739 (n737 n725 n738 vss) n12 w=1.6u l=0.13u
MN740 (n738 n731 vss vss) n12 w=1.6u l=0.13u
MP741 (n737 n725 vdd vdd) p12 w=2.4u l=0.13u
MP742 (n737 n731 vdd vdd) p12 w=2.4u l=0.13u
MN745 (n743 lead_g1 n744 vss) n12 w=1.6u l=0.13u
MN746 (n744 n737 vss vss) n12 w=1.6u l=0.13u
MP747 (n743 lead_g1 vdd vdd) p12 w=2.4u l=0.13u
MP748 (n743 n737 vdd vdd) p12 w=2.4u l=0.13u
MN751 (n749 lead_g1 n750 vss) n12 w=1.6u l=0.13u
MN752 (n750 n743 vss vss) n12 w=1.6u l=0.13u
MP753 (n749 lead_g1 vdd vdd) p12 w=2.4u l=0.13u
MP754 (n749 n743 vdd vdd) p12 w=2.4u l=0.13u
MN757 (n755 n737 n756 vss) n12 w=1.6u l=0.13u
MN758 (n756 n743 vss vss) n12 w=1.6u l=0.13u
MP759 (n755 n737 vdd vdd) p12 w=2.4u l=0.13u
MP760 (n755 n743 vdd vdd) p12 w=2.4u l=0.13u
MN763 (n761 n749 n762 vss) n12 w=1.6u l=0.13u
MN764 (n762 n755 vss vss) n12 w=1.6u l=0.13u
MP765 (n761 n749 vdd vdd) p12 w=2.4u l=0.13u
MP766 (n761 n755 vdd vdd) p12 w=2.4u l=0.13u
MN769 (n767 lead_g0 n768 vss) n12 w=1.6u l=0.13u
MN770 (n768 n761 vss vss) n12 w=1.6u l=0.13u
MP771 (n767 lead_g0 vdd vdd) p12 w=2.4u l=0.13u
MP772 (n767 n761 vdd vdd) p12 w=2.4u l=0.13u
MN775 (n773 lead_g0 n774 vss) n12 w=1.6u l=0.13u
MN776 (n774 n767 vss vss) n12 w=1.6u l=0.13u
MP777 (n773 lead_g0 vdd vdd) p12 w=2.4u l=0.13u
MP778 (n773 n767 vdd vdd) p12 w=2.4u l=0.13u
MN781 (n779 n761 n780 vss) n12 w=1.6u l=0.13u
MN782 (n780 n767 vss vss) n12 w=1.6u l=0.13u
MP783 (n779 n761 vdd vdd) p12 w=2.4u l=0.13u
MP784 (n779 n767 vdd vdd) p12 w=2.4u l=0.13u
MN787 (n785 n773 n786 vss) n12 w=1.6u l=0.13u
MN788 (n786 n779 vss vss) n12 w=1.6u l=0.13u
MP789 (n785 n773 vdd vdd) p12 w=2.4u l=0.13u
MP790 (n785 n779 vdd vdd) p12 w=2.4u l=0.13u
MN792 (n791 n785 vss vss) n12 w=0.8u l=0.13u
MP793 (n791 n785 vdd vdd) p12 w=2.4u l=0.13u
MN796 (n794 n761 n795 vss) n12 w=1.6u l=0.13u
MN797 (n795 n785 vss vss) n12 w=1.6u l=0.13u
MP798 (n794 n761 vdd vdd) p12 w=2.4u l=0.13u
MP799 (n794 n785 vdd vdd) p12 w=2.4u l=0.13u
MN802 (n800 n761 n801 vss) n12 w=1.6u l=0.13u
MN803 (n801 n794 vss vss) n12 w=1.6u l=0.13u
MP804 (n800 n761 vdd vdd) p12 w=2.4u l=0.13u
MP805 (n800 n794 vdd vdd) p12 w=2.4u l=0.13u
MN808 (n806 n785 n807 vss) n12 w=1.6u l=0.13u
MN809 (n807 n794 vss vss) n12 w=1.6u l=0.13u
MP810 (n806 n785 vdd vdd) p12 w=2.4u l=0.13u
MP811 (n806 n794 vdd vdd) p12 w=2.4u l=0.13u
MN814 (n812 n800 n813 vss) n12 w=1.6u l=0.13u
MN815 (n813 n806 vss vss) n12 w=1.6u l=0.13u
MP816 (n812 n800 vdd vdd) p12 w=2.4u l=0.13u
MP817 (n812 n806 vdd vdd) p12 w=2.4u l=0.13u
MN819 (n818 n794 vss vss) n12 w=0.8u l=0.13u
MP820 (n818 n794 vdd vdd) p12 w=2.4u l=0.13u
MN823 (n821 n737 n822 vss) n12 w=1.6u l=0.13u
MN824 (n822 n818 vss vss) n12 w=1.6u l=0.13u
MP825 (n821 n737 vdd vdd) p12 w=2.4u l=0.13u
MP826 (n821 n818 vdd vdd) p12 w=2.4u l=0.13u
MN829 (n827 n737 n828 vss) n12 w=1.6u l=0.13u
MN830 (n828 n821 vss vss) n12 w=1.6u l=0.13u
MP831 (n827 n737 vdd vdd) p12 w=2.4u l=0.13u
MP832 (n827 n821 vdd vdd) p12 w=2.4u l=0.13u
MN835 (n833 n818 n834 vss) n12 w=1.6u l=0.13u
MN836 (n834 n821 vss vss) n12 w=1.6u l=0.13u
MP837 (n833 n818 vdd vdd) p12 w=2.4u l=0.13u
MP838 (n833 n821 vdd vdd) p12 w=2.4u l=0.13u
MN841 (n839 n827 n840 vss) n12 w=1.6u l=0.13u
MN842 (n840 n833 vss vss) n12 w=1.6u l=0.13u
MP843 (n839 n827 vdd vdd) p12 w=2.4u l=0.13u
MP844 (n839 n833 vdd vdd) p12 w=2.4u l=0.13u
MN846 (n845 n821 vss vss) n12 w=0.8u l=0.13u
MP847 (n845 n821 vdd vdd) p12 w=2.4u l=0.13u
MN850 (n848 n713 n849 vss) n12 w=1.6u l=0.13u
MN851 (n849 n845 vss vss) n12 w=1.6u l=0.13u
MP852 (n848 n713 vdd vdd) p12 w=2.4u l=0.13u
MP853 (n848 n845 vdd vdd) p12 w=2.4u l=0.13u
MN856 (n854 n713 n855 vss) n12 w=1.6u l=0.13u
MN857 (n855 n848 vss vss) n12 w=1.6u l=0.13u
MP858 (n854 n713 vdd vdd) p12 w=2.4u l=0.13u
MP859 (n854 n848 vdd vdd) p12 w=2.4u l=0.13u
MN862 (n860 n845 n861 vss) n12 w=1.6u l=0.13u
MN863 (n861 n848 vss vss) n12 w=1.6u l=0.13u
MP864 (n860 n845 vdd vdd) p12 w=2.4u l=0.13u
MP865 (n860 n848 vdd vdd) p12 w=2.4u l=0.13u
MN868 (n866 n854 n867 vss) n12 w=1.6u l=0.13u
MN869 (n867 n860 vss vss) n12 w=1.6u l=0.13u
MP870 (n866 n854 vdd vdd) p12 w=2.4u l=0.13u
MP871 (n866 n860 vdd vdd) p12 w=2.4u l=0.13u
MN873 (n872 n848 vss vss) n12 w=0.8u l=0.13u
MP874 (n872 n848 vdd vdd) p12 w=2.4u l=0.13u
MN877 (n875 n689 n876 vss) n12 w=1.6u l=0.13u
MN878 (n876 n872 vss vss) n12 w=1.6u l=0.13u
MP879 (n875 n689 vdd vdd) p12 w=2.4u l=0.13u
MP880 (n875 n872 vdd vdd) p12 w=2.4u l=0.13u
MN883 (n881 n689 n882 vss) n12 w=1.6u l=0.13u
MN884 (n882 n875 vss vss) n12 w=1.6u l=0.13u
MP885 (n881 n689 vdd vdd) p12 w=2.4u l=0.13u
MP886 (n881 n875 vdd vdd) p12 w=2.4u l=0.13u
MN889 (n887 n872 n888 vss) n12 w=1.6u l=0.13u
MN890 (n888 n875 vss vss) n12 w=1.6u l=0.13u
MP891 (n887 n872 vdd vdd) p12 w=2.4u l=0.13u
MP892 (n887 n875 vdd vdd) p12 w=2.4u l=0.13u
MN895 (n893 n881 n894 vss) n12 w=1.6u l=0.13u
MN896 (n894 n887 vss vss) n12 w=1.6u l=0.13u
MP897 (n893 n881 vdd vdd) p12 w=2.4u l=0.13u
MP898 (n893 n887 vdd vdd) p12 w=2.4u l=0.13u
MN900 (n899 n875 vss vss) n12 w=0.8u l=0.13u
MP901 (n899 n875 vdd vdd) p12 w=2.4u l=0.13u
MN904 (n902 n665 n903 vss) n12 w=1.6u l=0.13u
MN905 (n903 n899 vss vss) n12 w=1.6u l=0.13u
MP906 (n902 n665 vdd vdd) p12 w=2.4u l=0.13u
MP907 (n902 n899 vdd vdd) p12 w=2.4u l=0.13u
MN910 (n908 n665 n909 vss) n12 w=1.6u l=0.13u
MN911 (n909 n902 vss vss) n12 w=1.6u l=0.13u
MP912 (n908 n665 vdd vdd) p12 w=2.4u l=0.13u
MP913 (n908 n902 vdd vdd) p12 w=2.4u l=0.13u
MN916 (n914 n899 n915 vss) n12 w=1.6u l=0.13u
MN917 (n915 n902 vss vss) n12 w=1.6u l=0.13u
MP918 (n914 n899 vdd vdd) p12 w=2.4u l=0.13u
MP919 (n914 n902 vdd vdd) p12 w=2.4u l=0.13u
MN922 (n920 n908 n921 vss) n12 w=1.6u l=0.13u
MN923 (n921 n914 vss vss) n12 w=1.6u l=0.13u
MP924 (n920 n908 vdd vdd) p12 w=2.4u l=0.13u
MP925 (n920 n914 vdd vdd) p12 w=2.4u l=0.13u
MN927 (n926 n902 vss vss) n12 w=0.8u l=0.13u
MP928 (n926 n902 vdd vdd) p12 w=2.4u l=0.13u
MN931 (n929 n641 n930 vss) n12 w=1.6u l=0.13u
MN932 (n930 n926 vss vss) n12 w=1.6u l=0.13u
MP933 (n929 n641 vdd vdd) p12 w=2.4u l=0.13u
MP934 (n929 n926 vdd vdd) p12 w=2.4u l=0.13u
MN937 (n935 n641 n936 vss) n12 w=1.6u l=0.13u
MN938 (n936 n929 vss vss) n12 w=1.6u l=0.13u
MP939 (n935 n641 vdd vdd) p12 w=2.4u l=0.13u
MP940 (n935 n929 vdd vdd) p12 w=2.4u l=0.13u
MN943 (n941 n926 n942 vss) n12 w=1.6u l=0.13u
MN944 (n942 n929 vss vss) n12 w=1.6u l=0.13u
MP945 (n941 n926 vdd vdd) p12 w=2.4u l=0.13u
MP946 (n941 n929 vdd vdd) p12 w=2.4u l=0.13u
MN949 (n947 n935 n948 vss) n12 w=1.6u l=0.13u
MN950 (n948 n941 vss vss) n12 w=1.6u l=0.13u
MP951 (n947 n935 vdd vdd) p12 w=2.4u l=0.13u
MP952 (n947 n941 vdd vdd) p12 w=2.4u l=0.13u
MN954 (n953 n929 vss vss) n12 w=0.8u l=0.13u
MP955 (n953 n929 vdd vdd) p12 w=2.4u l=0.13u
MN958 (n956 n617 n957 vss) n12 w=1.6u l=0.13u
MN959 (n957 n953 vss vss) n12 w=1.6u l=0.13u
MP960 (n956 n617 vdd vdd) p12 w=2.4u l=0.13u
MP961 (n956 n953 vdd vdd) p12 w=2.4u l=0.13u
MN964 (n962 n617 n963 vss) n12 w=1.6u l=0.13u
MN965 (n963 n956 vss vss) n12 w=1.6u l=0.13u
MP966 (n962 n617 vdd vdd) p12 w=2.4u l=0.13u
MP967 (n962 n956 vdd vdd) p12 w=2.4u l=0.13u
MN970 (n968 n953 n969 vss) n12 w=1.6u l=0.13u
MN971 (n969 n956 vss vss) n12 w=1.6u l=0.13u
MP972 (n968 n953 vdd vdd) p12 w=2.4u l=0.13u
MP973 (n968 n956 vdd vdd) p12 w=2.4u l=0.13u
MN976 (n974 n962 n975 vss) n12 w=1.6u l=0.13u
MN977 (n975 n968 vss vss) n12 w=1.6u l=0.13u
MP978 (n974 n962 vdd vdd) p12 w=2.4u l=0.13u
MP979 (n974 n968 vdd vdd) p12 w=2.4u l=0.13u
MN981 (n980 n956 vss vss) n12 w=0.8u l=0.13u
MP982 (n980 n956 vdd vdd) p12 w=2.4u l=0.13u
MN985 (n983 lead_g8 n984 vss) n12 w=1.6u l=0.13u
MN986 (n984 n980 vss vss) n12 w=1.6u l=0.13u
MP987 (n983 lead_g8 vdd vdd) p12 w=2.4u l=0.13u
MP988 (n983 n980 vdd vdd) p12 w=2.4u l=0.13u
MN991 (n989 lead_g8 n990 vss) n12 w=1.6u l=0.13u
MN992 (n990 n983 vss vss) n12 w=1.6u l=0.13u
MP993 (n989 lead_g8 vdd vdd) p12 w=2.4u l=0.13u
MP994 (n989 n983 vdd vdd) p12 w=2.4u l=0.13u
MN997 (n995 n980 n996 vss) n12 w=1.6u l=0.13u
MN998 (n996 n983 vss vss) n12 w=1.6u l=0.13u
MP999 (n995 n980 vdd vdd) p12 w=2.4u l=0.13u
MP1000 (n995 n983 vdd vdd) p12 w=2.4u l=0.13u
MN1003 (n1001 n989 n1002 vss) n12 w=1.6u l=0.13u
MN1004 (n1002 n995 vss vss) n12 w=1.6u l=0.13u
MP1005 (n1001 n989 vdd vdd) p12 w=2.4u l=0.13u
MP1006 (n1001 n995 vdd vdd) p12 w=2.4u l=0.13u
MN1008 (n1007 n983 vss vss) n12 w=0.8u l=0.13u
MP1009 (n1007 n983 vdd vdd) p12 w=2.4u l=0.13u
MN1012 (n1010 n791 n1011 vss) n12 w=1.6u l=0.13u
MN1013 (n1011 n812 vss vss) n12 w=1.6u l=0.13u
MP1014 (n1010 n791 vdd vdd) p12 w=2.4u l=0.13u
MP1015 (n1010 n812 vdd vdd) p12 w=2.4u l=0.13u
MN1018 (n1016 n1010 n1017 vss) n12 w=1.6u l=0.13u
MN1019 (n1017 n791 vss vss) n12 w=1.6u l=0.13u
MP1020 (n1016 n1010 vdd vdd) p12 w=2.4u l=0.13u
MP1021 (n1016 n791 vdd vdd) p12 w=2.4u l=0.13u
MN1024 (n1022 n1010 n1023 vss) n12 w=1.6u l=0.13u
MN1025 (n1023 n812 vss vss) n12 w=1.6u l=0.13u
MP1026 (n1022 n1010 vdd vdd) p12 w=2.4u l=0.13u
MP1027 (n1022 n812 vdd vdd) p12 w=2.4u l=0.13u
MN1030 (n1028 n1016 n1029 vss) n12 w=1.6u l=0.13u
MN1031 (n1029 n1022 vss vss) n12 w=1.6u l=0.13u
MP1032 (n1028 n1016 vdd vdd) p12 w=2.4u l=0.13u
MP1033 (n1028 n1022 vdd vdd) p12 w=2.4u l=0.13u
MN1036 (n1034 n812 n1035 vss) n12 w=1.6u l=0.13u
MN1037 (n1035 n839 vss vss) n12 w=1.6u l=0.13u
MP1038 (n1034 n812 vdd vdd) p12 w=2.4u l=0.13u
MP1039 (n1034 n839 vdd vdd) p12 w=2.4u l=0.13u
MN1042 (n1040 n1034 n1041 vss) n12 w=1.6u l=0.13u
MN1043 (n1041 n812 vss vss) n12 w=1.6u l=0.13u
MP1044 (n1040 n1034 vdd vdd) p12 w=2.4u l=0.13u
MP1045 (n1040 n812 vdd vdd) p12 w=2.4u l=0.13u
MN1048 (n1046 n1034 n1047 vss) n12 w=1.6u l=0.13u
MN1049 (n1047 n839 vss vss) n12 w=1.6u l=0.13u
MP1050 (n1046 n1034 vdd vdd) p12 w=2.4u l=0.13u
MP1051 (n1046 n839 vdd vdd) p12 w=2.4u l=0.13u
MN1054 (n1052 n1040 n1053 vss) n12 w=1.6u l=0.13u
MN1055 (n1053 n1046 vss vss) n12 w=1.6u l=0.13u
MP1056 (n1052 n1040 vdd vdd) p12 w=2.4u l=0.13u
MP1057 (n1052 n1046 vdd vdd) p12 w=2.4u l=0.13u
MN1060 (n1058 n839 n1059 vss) n12 w=1.6u l=0.13u
MN1061 (n1059 n866 vss vss) n12 w=1.6u l=0.13u
MP1062 (n1058 n839 vdd vdd) p12 w=2.4u l=0.13u
MP1063 (n1058 n866 vdd vdd) p12 w=2.4u l=0.13u
MN1066 (n1064 n1058 n1065 vss) n12 w=1.6u l=0.13u
MN1067 (n1065 n839 vss vss) n12 w=1.6u l=0.13u
MP1068 (n1064 n1058 vdd vdd) p12 w=2.4u l=0.13u
MP1069 (n1064 n839 vdd vdd) p12 w=2.4u l=0.13u
MN1072 (n1070 n1058 n1071 vss) n12 w=1.6u l=0.13u
MN1073 (n1071 n866 vss vss) n12 w=1.6u l=0.13u
MP1074 (n1070 n1058 vdd vdd) p12 w=2.4u l=0.13u
MP1075 (n1070 n866 vdd vdd) p12 w=2.4u l=0.13u
MN1078 (n1076 n1064 n1077 vss) n12 w=1.6u l=0.13u
MN1079 (n1077 n1070 vss vss) n12 w=1.6u l=0.13u
MP1080 (n1076 n1064 vdd vdd) p12 w=2.4u l=0.13u
MP1081 (n1076 n1070 vdd vdd) p12 w=2.4u l=0.13u
MN1084 (n1082 n866 n1083 vss) n12 w=1.6u l=0.13u
MN1085 (n1083 n893 vss vss) n12 w=1.6u l=0.13u
MP1086 (n1082 n866 vdd vdd) p12 w=2.4u l=0.13u
MP1087 (n1082 n893 vdd vdd) p12 w=2.4u l=0.13u
MN1090 (n1088 n1082 n1089 vss) n12 w=1.6u l=0.13u
MN1091 (n1089 n866 vss vss) n12 w=1.6u l=0.13u
MP1092 (n1088 n1082 vdd vdd) p12 w=2.4u l=0.13u
MP1093 (n1088 n866 vdd vdd) p12 w=2.4u l=0.13u
MN1096 (n1094 n1082 n1095 vss) n12 w=1.6u l=0.13u
MN1097 (n1095 n893 vss vss) n12 w=1.6u l=0.13u
MP1098 (n1094 n1082 vdd vdd) p12 w=2.4u l=0.13u
MP1099 (n1094 n893 vdd vdd) p12 w=2.4u l=0.13u
MN1102 (n1100 n1088 n1101 vss) n12 w=1.6u l=0.13u
MN1103 (n1101 n1094 vss vss) n12 w=1.6u l=0.13u
MP1104 (n1100 n1088 vdd vdd) p12 w=2.4u l=0.13u
MP1105 (n1100 n1094 vdd vdd) p12 w=2.4u l=0.13u
MN1108 (n1106 n893 n1107 vss) n12 w=1.6u l=0.13u
MN1109 (n1107 n920 vss vss) n12 w=1.6u l=0.13u
MP1110 (n1106 n893 vdd vdd) p12 w=2.4u l=0.13u
MP1111 (n1106 n920 vdd vdd) p12 w=2.4u l=0.13u
MN1114 (n1112 n1106 n1113 vss) n12 w=1.6u l=0.13u
MN1115 (n1113 n893 vss vss) n12 w=1.6u l=0.13u
MP1116 (n1112 n1106 vdd vdd) p12 w=2.4u l=0.13u
MP1117 (n1112 n893 vdd vdd) p12 w=2.4u l=0.13u
MN1120 (n1118 n1106 n1119 vss) n12 w=1.6u l=0.13u
MN1121 (n1119 n920 vss vss) n12 w=1.6u l=0.13u
MP1122 (n1118 n1106 vdd vdd) p12 w=2.4u l=0.13u
MP1123 (n1118 n920 vdd vdd) p12 w=2.4u l=0.13u
MN1126 (n1124 n1112 n1125 vss) n12 w=1.6u l=0.13u
MN1127 (n1125 n1118 vss vss) n12 w=1.6u l=0.13u
MP1128 (n1124 n1112 vdd vdd) p12 w=2.4u l=0.13u
MP1129 (n1124 n1118 vdd vdd) p12 w=2.4u l=0.13u
MN1132 (n1130 n920 n1131 vss) n12 w=1.6u l=0.13u
MN1133 (n1131 n947 vss vss) n12 w=1.6u l=0.13u
MP1134 (n1130 n920 vdd vdd) p12 w=2.4u l=0.13u
MP1135 (n1130 n947 vdd vdd) p12 w=2.4u l=0.13u
MN1138 (n1136 n1130 n1137 vss) n12 w=1.6u l=0.13u
MN1139 (n1137 n920 vss vss) n12 w=1.6u l=0.13u
MP1140 (n1136 n1130 vdd vdd) p12 w=2.4u l=0.13u
MP1141 (n1136 n920 vdd vdd) p12 w=2.4u l=0.13u
MN1144 (n1142 n1130 n1143 vss) n12 w=1.6u l=0.13u
MN1145 (n1143 n947 vss vss) n12 w=1.6u l=0.13u
MP1146 (n1142 n1130 vdd vdd) p12 w=2.4u l=0.13u
MP1147 (n1142 n947 vdd vdd) p12 w=2.4u l=0.13u
MN1150 (n1148 n1136 n1149 vss) n12 w=1.6u l=0.13u
MN1151 (n1149 n1142 vss vss) n12 w=1.6u l=0.13u
MP1152 (n1148 n1136 vdd vdd) p12 w=2.4u l=0.13u
MP1153 (n1148 n1142 vdd vdd) p12 w=2.4u l=0.13u
MN1156 (n1154 n947 n1155 vss) n12 w=1.6u l=0.13u
MN1157 (n1155 n974 vss vss) n12 w=1.6u l=0.13u
MP1158 (n1154 n947 vdd vdd) p12 w=2.4u l=0.13u
MP1159 (n1154 n974 vdd vdd) p12 w=2.4u l=0.13u
MN1162 (n1160 n1154 n1161 vss) n12 w=1.6u l=0.13u
MN1163 (n1161 n947 vss vss) n12 w=1.6u l=0.13u
MP1164 (n1160 n1154 vdd vdd) p12 w=2.4u l=0.13u
MP1165 (n1160 n947 vdd vdd) p12 w=2.4u l=0.13u
MN1168 (n1166 n1154 n1167 vss) n12 w=1.6u l=0.13u
MN1169 (n1167 n974 vss vss) n12 w=1.6u l=0.13u
MP1170 (n1166 n1154 vdd vdd) p12 w=2.4u l=0.13u
MP1171 (n1166 n974 vdd vdd) p12 w=2.4u l=0.13u
MN1174 (n1172 n1160 n1173 vss) n12 w=1.6u l=0.13u
MN1175 (n1173 n1166 vss vss) n12 w=1.6u l=0.13u
MP1176 (n1172 n1160 vdd vdd) p12 w=2.4u l=0.13u
MP1177 (n1172 n1166 vdd vdd) p12 w=2.4u l=0.13u
MN1180 (n1178 n1001 n1179 vss) n12 w=1.6u l=0.13u
MN1181 (n1179 n974 vss vss) n12 w=1.6u l=0.13u
MP1182 (n1178 n1001 vdd vdd) p12 w=2.4u l=0.13u
MP1183 (n1178 n974 vdd vdd) p12 w=2.4u l=0.13u
MN1186 (n1184 n1001 n1185 vss) n12 w=1.6u l=0.13u
MN1187 (n1185 n1178 vss vss) n12 w=1.6u l=0.13u
MP1188 (n1184 n1001 vdd vdd) p12 w=2.4u l=0.13u
MP1189 (n1184 n1178 vdd vdd) p12 w=2.4u l=0.13u
MN1192 (n1190 n1178 n1191 vss) n12 w=1.6u l=0.13u
MN1193 (n1191 n974 vss vss) n12 w=1.6u l=0.13u
MP1194 (n1190 n1178 vdd vdd) p12 w=2.4u l=0.13u
MP1195 (n1190 n974 vdd vdd) p12 w=2.4u l=0.13u
MN1198 (n1196 n1184 n1197 vss) n12 w=1.6u l=0.13u
MN1199 (n1197 n1190 vss vss) n12 w=1.6u l=0.13u
MP1200 (n1196 n1184 vdd vdd) p12 w=2.4u l=0.13u
MP1201 (n1196 n1190 vdd vdd) p12 w=2.4u l=0.13u
MN1203 (delay1202 n587 vss vss) n12 w=0.8u l=0.13u
MP1204 (delay1202 n587 vdd vdd) p12 w=2.4u l=0.13u
MN1206 (delay1205 delay1202 vss vss) n12 w=0.8u l=0.13u
MP1207 (delay1205 delay1202 vdd vdd) p12 w=2.4u l=0.13u
MN1209 (delay1208 delay1205 vss vss) n12 w=0.8u l=0.13u
MP1210 (delay1208 delay1205 vdd vdd) p12 w=2.4u l=0.13u
MN1212 (delay1211 delay1208 vss vss) n12 w=0.8u l=0.13u
MP1213 (delay1211 delay1208 vdd vdd) p12 w=2.4u l=0.13u
MN1215 (delay1214 delay1211 vss vss) n12 w=0.8u l=0.13u
MP1216 (delay1214 delay1211 vdd vdd) p12 w=2.4u l=0.13u
MN1218 (delay1217 delay1214 vss vss) n12 w=0.8u l=0.13u
MP1219 (delay1217 delay1214 vdd vdd) p12 w=2.4u l=0.13u
MN1221 (n1220 n587 vss vss) n12 w=0.8u l=0.13u
MP1222 (n1220 n587 vdd vdd) p12 w=2.4u l=0.13u
MN1224 (n1223 delay1217 vss vss) n12 w=0.8u l=0.13u
MP1225 (n1223 delay1217 vdd vdd) p12 w=2.4u l=0.13u
MN1227 (n1226 reference_count_rst vss vss) n12 w=0.8u l=0.13u
MP1228 (n1226 reference_count_rst vdd vdd) p12 w=2.4u l=0.13u
MN1237 (n1233 n1220 n1234 vss) n12 w=3.2u l=0.13u
MP1238 (n1233 n1220 vdd vdd) p12 w=2.4u l=0.13u
MN1239 (n1234 n1223 n1235 vss) n12 w=3.2u l=0.13u
MP1240 (n1233 n1223 vdd vdd) p12 w=2.4u l=0.13u
MN1241 (n1235 clk_highb1232 n1236 vss) n12 w=3.2u l=0.13u
MP1242 (n1233 clk_highb1232 vdd vdd) p12 w=2.4u l=0.13u
MN1243 (n1236 n1226 vss vss) n12 w=3.2u l=0.13u
MP1244 (n1233 n1226 vdd vdd) p12 w=2.4u l=0.13u
MN1249 (n1245 n587 n1246 vss) n12 w=3.2u l=0.13u
MP1250 (n1245 n587 vdd vdd) p12 w=2.4u l=0.13u
MN1251 (n1246 delay1217 n1247 vss) n12 w=3.2u l=0.13u
MP1252 (n1245 delay1217 vdd vdd) p12 w=2.4u l=0.13u
MN1253 (n1247 clk_lowb1230 n1248 vss) n12 w=3.2u l=0.13u
MP1254 (n1245 clk_lowb1230 vdd vdd) p12 w=2.4u l=0.13u
MN1255 (n1248 n1226 vss vss) n12 w=3.2u l=0.13u
MP1256 (n1245 n1226 vdd vdd) p12 w=2.4u l=0.13u
MN1257 (clk_low1229 n1233 vss vss) n12 w=8u l=0.13u
MP1258 (clk_low1229 n1233 vdd vdd) p12 w=24u l=0.13u
MN1259 (clk_lowb1230 clk_low1229 vss vss) n12 w=8u l=0.13u
MP1260 (clk_lowb1230 clk_low1229 vdd vdd) p12 w=24u l=0.13u
MN1261 (clk_high1231 n1245 vss vss) n12 w=8u l=0.13u
MP1262 (clk_high1231 n1245 vdd vdd) p12 w=24u l=0.13u
MN1263 (clk_highb1232 clk_high1231 vss vss) n12 w=8u l=0.13u
MP1264 (clk_highb1232 clk_high1231 vdd vdd) p12 w=24u l=0.13u
MN1268 (n1267 n1028 vss vss) n12 w=0.8u l=0.13u
MP1269 (n1267 n1028 vdd vdd) p12 w=2.4u l=0.13u
MN1272 (n1267 clk_low1229 storage1271 vss) n12 w=1.2u l=0.13u
MP1273 (n1267 clk_lowb1230 storage1271 vdd) p12 w=3.6u l=0.13u
MN1274 (qm1265 clk_high1231 storage1271 vss) n12 w=1.2u l=0.13u
MP1275 (qm1265 clk_highb1232 storage1271 vdd) p12 w=3.6u l=0.13u
MN1276 (qmb1266 storage1271 vss vss) n12 w=0.5u l=0.13u
MP1277 (qmb1266 storage1271 vdd vdd) p12 w=1.5u l=0.13u
MN1278 (qm1265 qmb1266 vss vss) n12 w=0.5u l=0.13u
MP1279 (qm1265 qmb1266 vdd vdd) p12 w=1.5u l=0.13u
MN1280 (storage1271 reference_count_rst vss vss) n12 w=2u l=0.13u
MN1282 (qm1265 clk_high1231 storage1281 vss) n12 w=1.2u l=0.13u
MP1283 (qm1265 clk_highb1232 storage1281 vdd) p12 w=3.6u l=0.13u
MN1284 (qneg1270 clk_low1229 storage1281 vss) n12 w=1.2u l=0.13u
MP1285 (qneg1270 clk_lowb1230 storage1281 vdd) p12 w=3.6u l=0.13u
MN1286 (lead_g0 storage1281 vss vss) n12 w=0.5u l=0.13u
MP1287 (lead_g0 storage1281 vdd vdd) p12 w=1.5u l=0.13u
MN1288 (qneg1270 lead_g0 vss vss) n12 w=0.5u l=0.13u
MP1289 (qneg1270 lead_g0 vdd vdd) p12 w=1.5u l=0.13u
MN1290 (storage1281 reference_count_rst vss vss) n12 w=2u l=0.13u
MN1295 (n1052 clk_low1229 storage1294 vss) n12 w=1.2u l=0.13u
MP1296 (n1052 clk_lowb1230 storage1294 vdd) p12 w=3.6u l=0.13u
MN1297 (qm1291 clk_high1231 storage1294 vss) n12 w=1.2u l=0.13u
MP1298 (qm1291 clk_highb1232 storage1294 vdd) p12 w=3.6u l=0.13u
MN1299 (qmb1292 storage1294 vss vss) n12 w=0.5u l=0.13u
MP1300 (qmb1292 storage1294 vdd vdd) p12 w=1.5u l=0.13u
MN1301 (qm1291 qmb1292 vss vss) n12 w=0.5u l=0.13u
MP1302 (qm1291 qmb1292 vdd vdd) p12 w=1.5u l=0.13u
MN1303 (storage1294 reference_count_rst vss vss) n12 w=2u l=0.13u
MN1305 (qm1291 clk_high1231 storage1304 vss) n12 w=1.2u l=0.13u
MP1306 (qm1291 clk_highb1232 storage1304 vdd) p12 w=3.6u l=0.13u
MN1307 (lead_g1 clk_low1229 storage1304 vss) n12 w=1.2u l=0.13u
MP1308 (lead_g1 clk_lowb1230 storage1304 vdd) p12 w=3.6u l=0.13u
MN1309 (qb1293 storage1304 vss vss) n12 w=0.5u l=0.13u
MP1310 (qb1293 storage1304 vdd vdd) p12 w=1.5u l=0.13u
MN1311 (lead_g1 qb1293 vss vss) n12 w=0.5u l=0.13u
MP1312 (lead_g1 qb1293 vdd vdd) p12 w=1.5u l=0.13u
MN1313 (storage1304 reference_count_rst vss vss) n12 w=2u l=0.13u
MN1318 (n1076 clk_low1229 storage1317 vss) n12 w=1.2u l=0.13u
MP1319 (n1076 clk_lowb1230 storage1317 vdd) p12 w=3.6u l=0.13u
MN1320 (qm1314 clk_high1231 storage1317 vss) n12 w=1.2u l=0.13u
MP1321 (qm1314 clk_highb1232 storage1317 vdd) p12 w=3.6u l=0.13u
MN1322 (qmb1315 storage1317 vss vss) n12 w=0.5u l=0.13u
MP1323 (qmb1315 storage1317 vdd vdd) p12 w=1.5u l=0.13u
MN1324 (qm1314 qmb1315 vss vss) n12 w=0.5u l=0.13u
MP1325 (qm1314 qmb1315 vdd vdd) p12 w=1.5u l=0.13u
MN1326 (storage1317 reference_count_rst vss vss) n12 w=2u l=0.13u
MN1328 (qm1314 clk_high1231 storage1327 vss) n12 w=1.2u l=0.13u
MP1329 (qm1314 clk_highb1232 storage1327 vdd) p12 w=3.6u l=0.13u
MN1330 (lead_g2 clk_low1229 storage1327 vss) n12 w=1.2u l=0.13u
MP1331 (lead_g2 clk_lowb1230 storage1327 vdd) p12 w=3.6u l=0.13u
MN1332 (qb1316 storage1327 vss vss) n12 w=0.5u l=0.13u
MP1333 (qb1316 storage1327 vdd vdd) p12 w=1.5u l=0.13u
MN1334 (lead_g2 qb1316 vss vss) n12 w=0.5u l=0.13u
MP1335 (lead_g2 qb1316 vdd vdd) p12 w=1.5u l=0.13u
MN1336 (storage1327 reference_count_rst vss vss) n12 w=2u l=0.13u
MN1341 (n1100 clk_low1229 storage1340 vss) n12 w=1.2u l=0.13u
MP1342 (n1100 clk_lowb1230 storage1340 vdd) p12 w=3.6u l=0.13u
MN1343 (qm1337 clk_high1231 storage1340 vss) n12 w=1.2u l=0.13u
MP1344 (qm1337 clk_highb1232 storage1340 vdd) p12 w=3.6u l=0.13u
MN1345 (qmb1338 storage1340 vss vss) n12 w=0.5u l=0.13u
MP1346 (qmb1338 storage1340 vdd vdd) p12 w=1.5u l=0.13u
MN1347 (qm1337 qmb1338 vss vss) n12 w=0.5u l=0.13u
MP1348 (qm1337 qmb1338 vdd vdd) p12 w=1.5u l=0.13u
MN1349 (storage1340 reference_count_rst vss vss) n12 w=2u l=0.13u
MN1351 (qm1337 clk_high1231 storage1350 vss) n12 w=1.2u l=0.13u
MP1352 (qm1337 clk_highb1232 storage1350 vdd) p12 w=3.6u l=0.13u
MN1353 (lead_g3 clk_low1229 storage1350 vss) n12 w=1.2u l=0.13u
MP1354 (lead_g3 clk_lowb1230 storage1350 vdd) p12 w=3.6u l=0.13u
MN1355 (qb1339 storage1350 vss vss) n12 w=0.5u l=0.13u
MP1356 (qb1339 storage1350 vdd vdd) p12 w=1.5u l=0.13u
MN1357 (lead_g3 qb1339 vss vss) n12 w=0.5u l=0.13u
MP1358 (lead_g3 qb1339 vdd vdd) p12 w=1.5u l=0.13u
MN1359 (storage1350 reference_count_rst vss vss) n12 w=2u l=0.13u
MN1364 (n1124 clk_low1229 storage1363 vss) n12 w=1.2u l=0.13u
MP1365 (n1124 clk_lowb1230 storage1363 vdd) p12 w=3.6u l=0.13u
MN1366 (qm1360 clk_high1231 storage1363 vss) n12 w=1.2u l=0.13u
MP1367 (qm1360 clk_highb1232 storage1363 vdd) p12 w=3.6u l=0.13u
MN1368 (qmb1361 storage1363 vss vss) n12 w=0.5u l=0.13u
MP1369 (qmb1361 storage1363 vdd vdd) p12 w=1.5u l=0.13u
MN1370 (qm1360 qmb1361 vss vss) n12 w=0.5u l=0.13u
MP1371 (qm1360 qmb1361 vdd vdd) p12 w=1.5u l=0.13u
MN1372 (storage1363 reference_count_rst vss vss) n12 w=2u l=0.13u
MN1374 (qm1360 clk_high1231 storage1373 vss) n12 w=1.2u l=0.13u
MP1375 (qm1360 clk_highb1232 storage1373 vdd) p12 w=3.6u l=0.13u
MN1376 (lead_g4 clk_low1229 storage1373 vss) n12 w=1.2u l=0.13u
MP1377 (lead_g4 clk_lowb1230 storage1373 vdd) p12 w=3.6u l=0.13u
MN1378 (qb1362 storage1373 vss vss) n12 w=0.5u l=0.13u
MP1379 (qb1362 storage1373 vdd vdd) p12 w=1.5u l=0.13u
MN1380 (lead_g4 qb1362 vss vss) n12 w=0.5u l=0.13u
MP1381 (lead_g4 qb1362 vdd vdd) p12 w=1.5u l=0.13u
MN1382 (storage1373 reference_count_rst vss vss) n12 w=2u l=0.13u
MN1387 (n1148 clk_low1229 storage1386 vss) n12 w=1.2u l=0.13u
MP1388 (n1148 clk_lowb1230 storage1386 vdd) p12 w=3.6u l=0.13u
MN1389 (qm1383 clk_high1231 storage1386 vss) n12 w=1.2u l=0.13u
MP1390 (qm1383 clk_highb1232 storage1386 vdd) p12 w=3.6u l=0.13u
MN1391 (qmb1384 storage1386 vss vss) n12 w=0.5u l=0.13u
MP1392 (qmb1384 storage1386 vdd vdd) p12 w=1.5u l=0.13u
MN1393 (qm1383 qmb1384 vss vss) n12 w=0.5u l=0.13u
MP1394 (qm1383 qmb1384 vdd vdd) p12 w=1.5u l=0.13u
MN1395 (storage1386 reference_count_rst vss vss) n12 w=2u l=0.13u
MN1397 (qm1383 clk_high1231 storage1396 vss) n12 w=1.2u l=0.13u
MP1398 (qm1383 clk_highb1232 storage1396 vdd) p12 w=3.6u l=0.13u
MN1399 (lead_g5 clk_low1229 storage1396 vss) n12 w=1.2u l=0.13u
MP1400 (lead_g5 clk_lowb1230 storage1396 vdd) p12 w=3.6u l=0.13u
MN1401 (qb1385 storage1396 vss vss) n12 w=0.5u l=0.13u
MP1402 (qb1385 storage1396 vdd vdd) p12 w=1.5u l=0.13u
MN1403 (lead_g5 qb1385 vss vss) n12 w=0.5u l=0.13u
MP1404 (lead_g5 qb1385 vdd vdd) p12 w=1.5u l=0.13u
MN1405 (storage1396 reference_count_rst vss vss) n12 w=2u l=0.13u
MN1410 (n1172 clk_low1229 storage1409 vss) n12 w=1.2u l=0.13u
MP1411 (n1172 clk_lowb1230 storage1409 vdd) p12 w=3.6u l=0.13u
MN1412 (qm1406 clk_high1231 storage1409 vss) n12 w=1.2u l=0.13u
MP1413 (qm1406 clk_highb1232 storage1409 vdd) p12 w=3.6u l=0.13u
MN1414 (qmb1407 storage1409 vss vss) n12 w=0.5u l=0.13u
MP1415 (qmb1407 storage1409 vdd vdd) p12 w=1.5u l=0.13u
MN1416 (qm1406 qmb1407 vss vss) n12 w=0.5u l=0.13u
MP1417 (qm1406 qmb1407 vdd vdd) p12 w=1.5u l=0.13u
MN1418 (storage1409 reference_count_rst vss vss) n12 w=2u l=0.13u
MN1420 (qm1406 clk_high1231 storage1419 vss) n12 w=1.2u l=0.13u
MP1421 (qm1406 clk_highb1232 storage1419 vdd) p12 w=3.6u l=0.13u
MN1422 (lead_g6 clk_low1229 storage1419 vss) n12 w=1.2u l=0.13u
MP1423 (lead_g6 clk_lowb1230 storage1419 vdd) p12 w=3.6u l=0.13u
MN1424 (qb1408 storage1419 vss vss) n12 w=0.5u l=0.13u
MP1425 (qb1408 storage1419 vdd vdd) p12 w=1.5u l=0.13u
MN1426 (lead_g6 qb1408 vss vss) n12 w=0.5u l=0.13u
MP1427 (lead_g6 qb1408 vdd vdd) p12 w=1.5u l=0.13u
MN1428 (storage1419 reference_count_rst vss vss) n12 w=2u l=0.13u
MN1433 (n1196 clk_low1229 storage1432 vss) n12 w=1.2u l=0.13u
MP1434 (n1196 clk_lowb1230 storage1432 vdd) p12 w=3.6u l=0.13u
MN1435 (qm1429 clk_high1231 storage1432 vss) n12 w=1.2u l=0.13u
MP1436 (qm1429 clk_highb1232 storage1432 vdd) p12 w=3.6u l=0.13u
MN1437 (qmb1430 storage1432 vss vss) n12 w=0.5u l=0.13u
MP1438 (qmb1430 storage1432 vdd vdd) p12 w=1.5u l=0.13u
MN1439 (qm1429 qmb1430 vss vss) n12 w=0.5u l=0.13u
MP1440 (qm1429 qmb1430 vdd vdd) p12 w=1.5u l=0.13u
MN1441 (storage1432 reference_count_rst vss vss) n12 w=2u l=0.13u
MN1443 (qm1429 clk_high1231 storage1442 vss) n12 w=1.2u l=0.13u
MP1444 (qm1429 clk_highb1232 storage1442 vdd) p12 w=3.6u l=0.13u
MN1445 (lead_g7 clk_low1229 storage1442 vss) n12 w=1.2u l=0.13u
MP1446 (lead_g7 clk_lowb1230 storage1442 vdd) p12 w=3.6u l=0.13u
MN1447 (qb1431 storage1442 vss vss) n12 w=0.5u l=0.13u
MP1448 (qb1431 storage1442 vdd vdd) p12 w=1.5u l=0.13u
MN1449 (lead_g7 qb1431 vss vss) n12 w=0.5u l=0.13u
MP1450 (lead_g7 qb1431 vdd vdd) p12 w=1.5u l=0.13u
MN1451 (storage1442 reference_count_rst vss vss) n12 w=2u l=0.13u
MN1456 (n1001 clk_low1229 storage1455 vss) n12 w=1.2u l=0.13u
MP1457 (n1001 clk_lowb1230 storage1455 vdd) p12 w=3.6u l=0.13u
MN1458 (qm1452 clk_high1231 storage1455 vss) n12 w=1.2u l=0.13u
MP1459 (qm1452 clk_highb1232 storage1455 vdd) p12 w=3.6u l=0.13u
MN1460 (qmb1453 storage1455 vss vss) n12 w=0.5u l=0.13u
MP1461 (qmb1453 storage1455 vdd vdd) p12 w=1.5u l=0.13u
MN1462 (qm1452 qmb1453 vss vss) n12 w=0.5u l=0.13u
MP1463 (qm1452 qmb1453 vdd vdd) p12 w=1.5u l=0.13u
MN1464 (storage1455 reference_count_rst vss vss) n12 w=2u l=0.13u
MN1466 (qm1452 clk_high1231 storage1465 vss) n12 w=1.2u l=0.13u
MP1467 (qm1452 clk_highb1232 storage1465 vdd) p12 w=3.6u l=0.13u
MN1468 (lead_g8 clk_low1229 storage1465 vss) n12 w=1.2u l=0.13u
MP1469 (lead_g8 clk_lowb1230 storage1465 vdd) p12 w=3.6u l=0.13u
MN1470 (qb1454 storage1465 vss vss) n12 w=0.5u l=0.13u
MP1471 (qb1454 storage1465 vdd vdd) p12 w=1.5u l=0.13u
MN1472 (lead_g8 qb1454 vss vss) n12 w=0.5u l=0.13u
MP1473 (lead_g8 qb1454 vdd vdd) p12 w=1.5u l=0.13u
MN1474 (storage1465 reference_count_rst vss vss) n12 w=2u l=0.13u
MN1477 (n1475 lag_g7 n1476 vss) n12 w=1.6u l=0.13u
MN1478 (n1476 lag_g8 vss vss) n12 w=1.6u l=0.13u
MP1479 (n1475 lag_g7 vdd vdd) p12 w=2.4u l=0.13u
MP1480 (n1475 lag_g8 vdd vdd) p12 w=2.4u l=0.13u
MN1483 (n1481 lag_g7 n1482 vss) n12 w=1.6u l=0.13u
MN1484 (n1482 n1475 vss vss) n12 w=1.6u l=0.13u
MP1485 (n1481 lag_g7 vdd vdd) p12 w=2.4u l=0.13u
MP1486 (n1481 n1475 vdd vdd) p12 w=2.4u l=0.13u
MN1489 (n1487 lag_g8 n1488 vss) n12 w=1.6u l=0.13u
MN1490 (n1488 n1475 vss vss) n12 w=1.6u l=0.13u
MP1491 (n1487 lag_g8 vdd vdd) p12 w=2.4u l=0.13u
MP1492 (n1487 n1475 vdd vdd) p12 w=2.4u l=0.13u
MN1495 (n1493 n1481 n1494 vss) n12 w=1.6u l=0.13u
MN1496 (n1494 n1487 vss vss) n12 w=1.6u l=0.13u
MP1497 (n1493 n1481 vdd vdd) p12 w=2.4u l=0.13u
MP1498 (n1493 n1487 vdd vdd) p12 w=2.4u l=0.13u
MN1501 (n1499 lag_g6 n1500 vss) n12 w=1.6u l=0.13u
MN1502 (n1500 n1493 vss vss) n12 w=1.6u l=0.13u
MP1503 (n1499 lag_g6 vdd vdd) p12 w=2.4u l=0.13u
MP1504 (n1499 n1493 vdd vdd) p12 w=2.4u l=0.13u
MN1507 (n1505 lag_g6 n1506 vss) n12 w=1.6u l=0.13u
MN1508 (n1506 n1499 vss vss) n12 w=1.6u l=0.13u
MP1509 (n1505 lag_g6 vdd vdd) p12 w=2.4u l=0.13u
MP1510 (n1505 n1499 vdd vdd) p12 w=2.4u l=0.13u
MN1513 (n1511 n1493 n1512 vss) n12 w=1.6u l=0.13u
MN1514 (n1512 n1499 vss vss) n12 w=1.6u l=0.13u
MP1515 (n1511 n1493 vdd vdd) p12 w=2.4u l=0.13u
MP1516 (n1511 n1499 vdd vdd) p12 w=2.4u l=0.13u
MN1519 (n1517 n1505 n1518 vss) n12 w=1.6u l=0.13u
MN1520 (n1518 n1511 vss vss) n12 w=1.6u l=0.13u
MP1521 (n1517 n1505 vdd vdd) p12 w=2.4u l=0.13u
MP1522 (n1517 n1511 vdd vdd) p12 w=2.4u l=0.13u
MN1525 (n1523 lag_g5 n1524 vss) n12 w=1.6u l=0.13u
MN1526 (n1524 n1517 vss vss) n12 w=1.6u l=0.13u
MP1527 (n1523 lag_g5 vdd vdd) p12 w=2.4u l=0.13u
MP1528 (n1523 n1517 vdd vdd) p12 w=2.4u l=0.13u
MN1531 (n1529 lag_g5 n1530 vss) n12 w=1.6u l=0.13u
MN1532 (n1530 n1523 vss vss) n12 w=1.6u l=0.13u
MP1533 (n1529 lag_g5 vdd vdd) p12 w=2.4u l=0.13u
MP1534 (n1529 n1523 vdd vdd) p12 w=2.4u l=0.13u
MN1537 (n1535 n1517 n1536 vss) n12 w=1.6u l=0.13u
MN1538 (n1536 n1523 vss vss) n12 w=1.6u l=0.13u
MP1539 (n1535 n1517 vdd vdd) p12 w=2.4u l=0.13u
MP1540 (n1535 n1523 vdd vdd) p12 w=2.4u l=0.13u
MN1543 (n1541 n1529 n1542 vss) n12 w=1.6u l=0.13u
MN1544 (n1542 n1535 vss vss) n12 w=1.6u l=0.13u
MP1545 (n1541 n1529 vdd vdd) p12 w=2.4u l=0.13u
MP1546 (n1541 n1535 vdd vdd) p12 w=2.4u l=0.13u
MN1549 (n1547 lag_g4 n1548 vss) n12 w=1.6u l=0.13u
MN1550 (n1548 n1541 vss vss) n12 w=1.6u l=0.13u
MP1551 (n1547 lag_g4 vdd vdd) p12 w=2.4u l=0.13u
MP1552 (n1547 n1541 vdd vdd) p12 w=2.4u l=0.13u
MN1555 (n1553 lag_g4 n1554 vss) n12 w=1.6u l=0.13u
MN1556 (n1554 n1547 vss vss) n12 w=1.6u l=0.13u
MP1557 (n1553 lag_g4 vdd vdd) p12 w=2.4u l=0.13u
MP1558 (n1553 n1547 vdd vdd) p12 w=2.4u l=0.13u
MN1561 (n1559 n1541 n1560 vss) n12 w=1.6u l=0.13u
MN1562 (n1560 n1547 vss vss) n12 w=1.6u l=0.13u
MP1563 (n1559 n1541 vdd vdd) p12 w=2.4u l=0.13u
MP1564 (n1559 n1547 vdd vdd) p12 w=2.4u l=0.13u
MN1567 (n1565 n1553 n1566 vss) n12 w=1.6u l=0.13u
MN1568 (n1566 n1559 vss vss) n12 w=1.6u l=0.13u
MP1569 (n1565 n1553 vdd vdd) p12 w=2.4u l=0.13u
MP1570 (n1565 n1559 vdd vdd) p12 w=2.4u l=0.13u
MN1573 (n1571 lag_g3 n1572 vss) n12 w=1.6u l=0.13u
MN1574 (n1572 n1565 vss vss) n12 w=1.6u l=0.13u
MP1575 (n1571 lag_g3 vdd vdd) p12 w=2.4u l=0.13u
MP1576 (n1571 n1565 vdd vdd) p12 w=2.4u l=0.13u
MN1579 (n1577 lag_g3 n1578 vss) n12 w=1.6u l=0.13u
MN1580 (n1578 n1571 vss vss) n12 w=1.6u l=0.13u
MP1581 (n1577 lag_g3 vdd vdd) p12 w=2.4u l=0.13u
MP1582 (n1577 n1571 vdd vdd) p12 w=2.4u l=0.13u
MN1585 (n1583 n1565 n1584 vss) n12 w=1.6u l=0.13u
MN1586 (n1584 n1571 vss vss) n12 w=1.6u l=0.13u
MP1587 (n1583 n1565 vdd vdd) p12 w=2.4u l=0.13u
MP1588 (n1583 n1571 vdd vdd) p12 w=2.4u l=0.13u
MN1591 (n1589 n1577 n1590 vss) n12 w=1.6u l=0.13u
MN1592 (n1590 n1583 vss vss) n12 w=1.6u l=0.13u
MP1593 (n1589 n1577 vdd vdd) p12 w=2.4u l=0.13u
MP1594 (n1589 n1583 vdd vdd) p12 w=2.4u l=0.13u
MN1597 (n1595 lag_g2 n1596 vss) n12 w=1.6u l=0.13u
MN1598 (n1596 n1589 vss vss) n12 w=1.6u l=0.13u
MP1599 (n1595 lag_g2 vdd vdd) p12 w=2.4u l=0.13u
MP1600 (n1595 n1589 vdd vdd) p12 w=2.4u l=0.13u
MN1603 (n1601 lag_g2 n1602 vss) n12 w=1.6u l=0.13u
MN1604 (n1602 n1595 vss vss) n12 w=1.6u l=0.13u
MP1605 (n1601 lag_g2 vdd vdd) p12 w=2.4u l=0.13u
MP1606 (n1601 n1595 vdd vdd) p12 w=2.4u l=0.13u
MN1609 (n1607 n1589 n1608 vss) n12 w=1.6u l=0.13u
MN1610 (n1608 n1595 vss vss) n12 w=1.6u l=0.13u
MP1611 (n1607 n1589 vdd vdd) p12 w=2.4u l=0.13u
MP1612 (n1607 n1595 vdd vdd) p12 w=2.4u l=0.13u
MN1615 (n1613 n1601 n1614 vss) n12 w=1.6u l=0.13u
MN1616 (n1614 n1607 vss vss) n12 w=1.6u l=0.13u
MP1617 (n1613 n1601 vdd vdd) p12 w=2.4u l=0.13u
MP1618 (n1613 n1607 vdd vdd) p12 w=2.4u l=0.13u
MN1621 (n1619 lag_g1 n1620 vss) n12 w=1.6u l=0.13u
MN1622 (n1620 n1613 vss vss) n12 w=1.6u l=0.13u
MP1623 (n1619 lag_g1 vdd vdd) p12 w=2.4u l=0.13u
MP1624 (n1619 n1613 vdd vdd) p12 w=2.4u l=0.13u
MN1627 (n1625 lag_g1 n1626 vss) n12 w=1.6u l=0.13u
MN1628 (n1626 n1619 vss vss) n12 w=1.6u l=0.13u
MP1629 (n1625 lag_g1 vdd vdd) p12 w=2.4u l=0.13u
MP1630 (n1625 n1619 vdd vdd) p12 w=2.4u l=0.13u
MN1633 (n1631 n1613 n1632 vss) n12 w=1.6u l=0.13u
MN1634 (n1632 n1619 vss vss) n12 w=1.6u l=0.13u
MP1635 (n1631 n1613 vdd vdd) p12 w=2.4u l=0.13u
MP1636 (n1631 n1619 vdd vdd) p12 w=2.4u l=0.13u
MN1639 (n1637 n1625 n1638 vss) n12 w=1.6u l=0.13u
MN1640 (n1638 n1631 vss vss) n12 w=1.6u l=0.13u
MP1641 (n1637 n1625 vdd vdd) p12 w=2.4u l=0.13u
MP1642 (n1637 n1631 vdd vdd) p12 w=2.4u l=0.13u
MN1645 (n1643 lag_g0 n1644 vss) n12 w=1.6u l=0.13u
MN1646 (n1644 n1637 vss vss) n12 w=1.6u l=0.13u
MP1647 (n1643 lag_g0 vdd vdd) p12 w=2.4u l=0.13u
MP1648 (n1643 n1637 vdd vdd) p12 w=2.4u l=0.13u
MN1651 (n1649 lag_g0 n1650 vss) n12 w=1.6u l=0.13u
MN1652 (n1650 n1643 vss vss) n12 w=1.6u l=0.13u
MP1653 (n1649 lag_g0 vdd vdd) p12 w=2.4u l=0.13u
MP1654 (n1649 n1643 vdd vdd) p12 w=2.4u l=0.13u
MN1657 (n1655 n1637 n1656 vss) n12 w=1.6u l=0.13u
MN1658 (n1656 n1643 vss vss) n12 w=1.6u l=0.13u
MP1659 (n1655 n1637 vdd vdd) p12 w=2.4u l=0.13u
MP1660 (n1655 n1643 vdd vdd) p12 w=2.4u l=0.13u
MN1663 (n1661 n1649 n1662 vss) n12 w=1.6u l=0.13u
MN1664 (n1662 n1655 vss vss) n12 w=1.6u l=0.13u
MP1665 (n1661 n1649 vdd vdd) p12 w=2.4u l=0.13u
MP1666 (n1661 n1655 vdd vdd) p12 w=2.4u l=0.13u
MN1668 (n1667 n1661 vss vss) n12 w=0.8u l=0.13u
MP1669 (n1667 n1661 vdd vdd) p12 w=2.4u l=0.13u
MN1672 (n1670 n1637 n1671 vss) n12 w=1.6u l=0.13u
MN1673 (n1671 n1661 vss vss) n12 w=1.6u l=0.13u
MP1674 (n1670 n1637 vdd vdd) p12 w=2.4u l=0.13u
MP1675 (n1670 n1661 vdd vdd) p12 w=2.4u l=0.13u
MN1678 (n1676 n1637 n1677 vss) n12 w=1.6u l=0.13u
MN1679 (n1677 n1670 vss vss) n12 w=1.6u l=0.13u
MP1680 (n1676 n1637 vdd vdd) p12 w=2.4u l=0.13u
MP1681 (n1676 n1670 vdd vdd) p12 w=2.4u l=0.13u
MN1684 (n1682 n1661 n1683 vss) n12 w=1.6u l=0.13u
MN1685 (n1683 n1670 vss vss) n12 w=1.6u l=0.13u
MP1686 (n1682 n1661 vdd vdd) p12 w=2.4u l=0.13u
MP1687 (n1682 n1670 vdd vdd) p12 w=2.4u l=0.13u
MN1690 (n1688 n1676 n1689 vss) n12 w=1.6u l=0.13u
MN1691 (n1689 n1682 vss vss) n12 w=1.6u l=0.13u
MP1692 (n1688 n1676 vdd vdd) p12 w=2.4u l=0.13u
MP1693 (n1688 n1682 vdd vdd) p12 w=2.4u l=0.13u
MN1695 (n1694 n1670 vss vss) n12 w=0.8u l=0.13u
MP1696 (n1694 n1670 vdd vdd) p12 w=2.4u l=0.13u
MN1699 (n1697 n1613 n1698 vss) n12 w=1.6u l=0.13u
MN1700 (n1698 n1694 vss vss) n12 w=1.6u l=0.13u
MP1701 (n1697 n1613 vdd vdd) p12 w=2.4u l=0.13u
MP1702 (n1697 n1694 vdd vdd) p12 w=2.4u l=0.13u
MN1705 (n1703 n1613 n1704 vss) n12 w=1.6u l=0.13u
MN1706 (n1704 n1697 vss vss) n12 w=1.6u l=0.13u
MP1707 (n1703 n1613 vdd vdd) p12 w=2.4u l=0.13u
MP1708 (n1703 n1697 vdd vdd) p12 w=2.4u l=0.13u
MN1711 (n1709 n1694 n1710 vss) n12 w=1.6u l=0.13u
MN1712 (n1710 n1697 vss vss) n12 w=1.6u l=0.13u
MP1713 (n1709 n1694 vdd vdd) p12 w=2.4u l=0.13u
MP1714 (n1709 n1697 vdd vdd) p12 w=2.4u l=0.13u
MN1717 (n1715 n1703 n1716 vss) n12 w=1.6u l=0.13u
MN1718 (n1716 n1709 vss vss) n12 w=1.6u l=0.13u
MP1719 (n1715 n1703 vdd vdd) p12 w=2.4u l=0.13u
MP1720 (n1715 n1709 vdd vdd) p12 w=2.4u l=0.13u
MN1722 (n1721 n1697 vss vss) n12 w=0.8u l=0.13u
MP1723 (n1721 n1697 vdd vdd) p12 w=2.4u l=0.13u
MN1726 (n1724 n1589 n1725 vss) n12 w=1.6u l=0.13u
MN1727 (n1725 n1721 vss vss) n12 w=1.6u l=0.13u
MP1728 (n1724 n1589 vdd vdd) p12 w=2.4u l=0.13u
MP1729 (n1724 n1721 vdd vdd) p12 w=2.4u l=0.13u
MN1732 (n1730 n1589 n1731 vss) n12 w=1.6u l=0.13u
MN1733 (n1731 n1724 vss vss) n12 w=1.6u l=0.13u
MP1734 (n1730 n1589 vdd vdd) p12 w=2.4u l=0.13u
MP1735 (n1730 n1724 vdd vdd) p12 w=2.4u l=0.13u
MN1738 (n1736 n1721 n1737 vss) n12 w=1.6u l=0.13u
MN1739 (n1737 n1724 vss vss) n12 w=1.6u l=0.13u
MP1740 (n1736 n1721 vdd vdd) p12 w=2.4u l=0.13u
MP1741 (n1736 n1724 vdd vdd) p12 w=2.4u l=0.13u
MN1744 (n1742 n1730 n1743 vss) n12 w=1.6u l=0.13u
MN1745 (n1743 n1736 vss vss) n12 w=1.6u l=0.13u
MP1746 (n1742 n1730 vdd vdd) p12 w=2.4u l=0.13u
MP1747 (n1742 n1736 vdd vdd) p12 w=2.4u l=0.13u
MN1749 (n1748 n1724 vss vss) n12 w=0.8u l=0.13u
MP1750 (n1748 n1724 vdd vdd) p12 w=2.4u l=0.13u
MN1753 (n1751 n1565 n1752 vss) n12 w=1.6u l=0.13u
MN1754 (n1752 n1748 vss vss) n12 w=1.6u l=0.13u
MP1755 (n1751 n1565 vdd vdd) p12 w=2.4u l=0.13u
MP1756 (n1751 n1748 vdd vdd) p12 w=2.4u l=0.13u
MN1759 (n1757 n1565 n1758 vss) n12 w=1.6u l=0.13u
MN1760 (n1758 n1751 vss vss) n12 w=1.6u l=0.13u
MP1761 (n1757 n1565 vdd vdd) p12 w=2.4u l=0.13u
MP1762 (n1757 n1751 vdd vdd) p12 w=2.4u l=0.13u
MN1765 (n1763 n1748 n1764 vss) n12 w=1.6u l=0.13u
MN1766 (n1764 n1751 vss vss) n12 w=1.6u l=0.13u
MP1767 (n1763 n1748 vdd vdd) p12 w=2.4u l=0.13u
MP1768 (n1763 n1751 vdd vdd) p12 w=2.4u l=0.13u
MN1771 (n1769 n1757 n1770 vss) n12 w=1.6u l=0.13u
MN1772 (n1770 n1763 vss vss) n12 w=1.6u l=0.13u
MP1773 (n1769 n1757 vdd vdd) p12 w=2.4u l=0.13u
MP1774 (n1769 n1763 vdd vdd) p12 w=2.4u l=0.13u
MN1776 (n1775 n1751 vss vss) n12 w=0.8u l=0.13u
MP1777 (n1775 n1751 vdd vdd) p12 w=2.4u l=0.13u
MN1780 (n1778 n1541 n1779 vss) n12 w=1.6u l=0.13u
MN1781 (n1779 n1775 vss vss) n12 w=1.6u l=0.13u
MP1782 (n1778 n1541 vdd vdd) p12 w=2.4u l=0.13u
MP1783 (n1778 n1775 vdd vdd) p12 w=2.4u l=0.13u
MN1786 (n1784 n1541 n1785 vss) n12 w=1.6u l=0.13u
MN1787 (n1785 n1778 vss vss) n12 w=1.6u l=0.13u
MP1788 (n1784 n1541 vdd vdd) p12 w=2.4u l=0.13u
MP1789 (n1784 n1778 vdd vdd) p12 w=2.4u l=0.13u
MN1792 (n1790 n1775 n1791 vss) n12 w=1.6u l=0.13u
MN1793 (n1791 n1778 vss vss) n12 w=1.6u l=0.13u
MP1794 (n1790 n1775 vdd vdd) p12 w=2.4u l=0.13u
MP1795 (n1790 n1778 vdd vdd) p12 w=2.4u l=0.13u
MN1798 (n1796 n1784 n1797 vss) n12 w=1.6u l=0.13u
MN1799 (n1797 n1790 vss vss) n12 w=1.6u l=0.13u
MP1800 (n1796 n1784 vdd vdd) p12 w=2.4u l=0.13u
MP1801 (n1796 n1790 vdd vdd) p12 w=2.4u l=0.13u
MN1803 (n1802 n1778 vss vss) n12 w=0.8u l=0.13u
MP1804 (n1802 n1778 vdd vdd) p12 w=2.4u l=0.13u
MN1807 (n1805 n1517 n1806 vss) n12 w=1.6u l=0.13u
MN1808 (n1806 n1802 vss vss) n12 w=1.6u l=0.13u
MP1809 (n1805 n1517 vdd vdd) p12 w=2.4u l=0.13u
MP1810 (n1805 n1802 vdd vdd) p12 w=2.4u l=0.13u
MN1813 (n1811 n1517 n1812 vss) n12 w=1.6u l=0.13u
MN1814 (n1812 n1805 vss vss) n12 w=1.6u l=0.13u
MP1815 (n1811 n1517 vdd vdd) p12 w=2.4u l=0.13u
MP1816 (n1811 n1805 vdd vdd) p12 w=2.4u l=0.13u
MN1819 (n1817 n1802 n1818 vss) n12 w=1.6u l=0.13u
MN1820 (n1818 n1805 vss vss) n12 w=1.6u l=0.13u
MP1821 (n1817 n1802 vdd vdd) p12 w=2.4u l=0.13u
MP1822 (n1817 n1805 vdd vdd) p12 w=2.4u l=0.13u
MN1825 (n1823 n1811 n1824 vss) n12 w=1.6u l=0.13u
MN1826 (n1824 n1817 vss vss) n12 w=1.6u l=0.13u
MP1827 (n1823 n1811 vdd vdd) p12 w=2.4u l=0.13u
MP1828 (n1823 n1817 vdd vdd) p12 w=2.4u l=0.13u
MN1830 (n1829 n1805 vss vss) n12 w=0.8u l=0.13u
MP1831 (n1829 n1805 vdd vdd) p12 w=2.4u l=0.13u
MN1834 (n1832 n1493 n1833 vss) n12 w=1.6u l=0.13u
MN1835 (n1833 n1829 vss vss) n12 w=1.6u l=0.13u
MP1836 (n1832 n1493 vdd vdd) p12 w=2.4u l=0.13u
MP1837 (n1832 n1829 vdd vdd) p12 w=2.4u l=0.13u
MN1840 (n1838 n1493 n1839 vss) n12 w=1.6u l=0.13u
MN1841 (n1839 n1832 vss vss) n12 w=1.6u l=0.13u
MP1842 (n1838 n1493 vdd vdd) p12 w=2.4u l=0.13u
MP1843 (n1838 n1832 vdd vdd) p12 w=2.4u l=0.13u
MN1846 (n1844 n1829 n1845 vss) n12 w=1.6u l=0.13u
MN1847 (n1845 n1832 vss vss) n12 w=1.6u l=0.13u
MP1848 (n1844 n1829 vdd vdd) p12 w=2.4u l=0.13u
MP1849 (n1844 n1832 vdd vdd) p12 w=2.4u l=0.13u
MN1852 (n1850 n1838 n1851 vss) n12 w=1.6u l=0.13u
MN1853 (n1851 n1844 vss vss) n12 w=1.6u l=0.13u
MP1854 (n1850 n1838 vdd vdd) p12 w=2.4u l=0.13u
MP1855 (n1850 n1844 vdd vdd) p12 w=2.4u l=0.13u
MN1857 (n1856 n1832 vss vss) n12 w=0.8u l=0.13u
MP1858 (n1856 n1832 vdd vdd) p12 w=2.4u l=0.13u
MN1861 (n1859 lag_g8 n1860 vss) n12 w=1.6u l=0.13u
MN1862 (n1860 n1856 vss vss) n12 w=1.6u l=0.13u
MP1863 (n1859 lag_g8 vdd vdd) p12 w=2.4u l=0.13u
MP1864 (n1859 n1856 vdd vdd) p12 w=2.4u l=0.13u
MN1867 (n1865 lag_g8 n1866 vss) n12 w=1.6u l=0.13u
MN1868 (n1866 n1859 vss vss) n12 w=1.6u l=0.13u
MP1869 (n1865 lag_g8 vdd vdd) p12 w=2.4u l=0.13u
MP1870 (n1865 n1859 vdd vdd) p12 w=2.4u l=0.13u
MN1873 (n1871 n1856 n1872 vss) n12 w=1.6u l=0.13u
MN1874 (n1872 n1859 vss vss) n12 w=1.6u l=0.13u
MP1875 (n1871 n1856 vdd vdd) p12 w=2.4u l=0.13u
MP1876 (n1871 n1859 vdd vdd) p12 w=2.4u l=0.13u
MN1879 (n1877 n1865 n1878 vss) n12 w=1.6u l=0.13u
MN1880 (n1878 n1871 vss vss) n12 w=1.6u l=0.13u
MP1881 (n1877 n1865 vdd vdd) p12 w=2.4u l=0.13u
MP1882 (n1877 n1871 vdd vdd) p12 w=2.4u l=0.13u
MN1884 (n1883 n1859 vss vss) n12 w=0.8u l=0.13u
MP1885 (n1883 n1859 vdd vdd) p12 w=2.4u l=0.13u
MN1888 (n1886 n1667 n1887 vss) n12 w=1.6u l=0.13u
MN1889 (n1887 n1688 vss vss) n12 w=1.6u l=0.13u
MP1890 (n1886 n1667 vdd vdd) p12 w=2.4u l=0.13u
MP1891 (n1886 n1688 vdd vdd) p12 w=2.4u l=0.13u
MN1894 (n1892 n1667 n1893 vss) n12 w=1.6u l=0.13u
MN1895 (n1893 n1886 vss vss) n12 w=1.6u l=0.13u
MP1896 (n1892 n1667 vdd vdd) p12 w=2.4u l=0.13u
MP1897 (n1892 n1886 vdd vdd) p12 w=2.4u l=0.13u
MN1900 (n1898 n1688 n1899 vss) n12 w=1.6u l=0.13u
MN1901 (n1899 n1886 vss vss) n12 w=1.6u l=0.13u
MP1902 (n1898 n1688 vdd vdd) p12 w=2.4u l=0.13u
MP1903 (n1898 n1886 vdd vdd) p12 w=2.4u l=0.13u
MN1906 (n1904 n1892 n1905 vss) n12 w=1.6u l=0.13u
MN1907 (n1905 n1898 vss vss) n12 w=1.6u l=0.13u
MP1908 (n1904 n1892 vdd vdd) p12 w=2.4u l=0.13u
MP1909 (n1904 n1898 vdd vdd) p12 w=2.4u l=0.13u
MN1912 (n1910 n1688 n1911 vss) n12 w=1.6u l=0.13u
MN1913 (n1911 n1715 vss vss) n12 w=1.6u l=0.13u
MP1914 (n1910 n1688 vdd vdd) p12 w=2.4u l=0.13u
MP1915 (n1910 n1715 vdd vdd) p12 w=2.4u l=0.13u
MN1918 (n1916 n1688 n1917 vss) n12 w=1.6u l=0.13u
MN1919 (n1917 n1910 vss vss) n12 w=1.6u l=0.13u
MP1920 (n1916 n1688 vdd vdd) p12 w=2.4u l=0.13u
MP1921 (n1916 n1910 vdd vdd) p12 w=2.4u l=0.13u
MN1924 (n1922 n1715 n1923 vss) n12 w=1.6u l=0.13u
MN1925 (n1923 n1910 vss vss) n12 w=1.6u l=0.13u
MP1926 (n1922 n1715 vdd vdd) p12 w=2.4u l=0.13u
MP1927 (n1922 n1910 vdd vdd) p12 w=2.4u l=0.13u
MN1930 (n1928 n1916 n1929 vss) n12 w=1.6u l=0.13u
MN1931 (n1929 n1922 vss vss) n12 w=1.6u l=0.13u
MP1932 (n1928 n1916 vdd vdd) p12 w=2.4u l=0.13u
MP1933 (n1928 n1922 vdd vdd) p12 w=2.4u l=0.13u
MN1936 (n1934 n1715 n1935 vss) n12 w=1.6u l=0.13u
MN1937 (n1935 n1742 vss vss) n12 w=1.6u l=0.13u
MP1938 (n1934 n1715 vdd vdd) p12 w=2.4u l=0.13u
MP1939 (n1934 n1742 vdd vdd) p12 w=2.4u l=0.13u
MN1942 (n1940 n1715 n1941 vss) n12 w=1.6u l=0.13u
MN1943 (n1941 n1934 vss vss) n12 w=1.6u l=0.13u
MP1944 (n1940 n1715 vdd vdd) p12 w=2.4u l=0.13u
MP1945 (n1940 n1934 vdd vdd) p12 w=2.4u l=0.13u
MN1948 (n1946 n1742 n1947 vss) n12 w=1.6u l=0.13u
MN1949 (n1947 n1934 vss vss) n12 w=1.6u l=0.13u
MP1950 (n1946 n1742 vdd vdd) p12 w=2.4u l=0.13u
MP1951 (n1946 n1934 vdd vdd) p12 w=2.4u l=0.13u
MN1954 (n1952 n1940 n1953 vss) n12 w=1.6u l=0.13u
MN1955 (n1953 n1946 vss vss) n12 w=1.6u l=0.13u
MP1956 (n1952 n1940 vdd vdd) p12 w=2.4u l=0.13u
MP1957 (n1952 n1946 vdd vdd) p12 w=2.4u l=0.13u
MN1960 (n1958 n1742 n1959 vss) n12 w=1.6u l=0.13u
MN1961 (n1959 n1769 vss vss) n12 w=1.6u l=0.13u
MP1962 (n1958 n1742 vdd vdd) p12 w=2.4u l=0.13u
MP1963 (n1958 n1769 vdd vdd) p12 w=2.4u l=0.13u
MN1966 (n1964 n1742 n1965 vss) n12 w=1.6u l=0.13u
MN1967 (n1965 n1958 vss vss) n12 w=1.6u l=0.13u
MP1968 (n1964 n1742 vdd vdd) p12 w=2.4u l=0.13u
MP1969 (n1964 n1958 vdd vdd) p12 w=2.4u l=0.13u
MN1972 (n1970 n1769 n1971 vss) n12 w=1.6u l=0.13u
MN1973 (n1971 n1958 vss vss) n12 w=1.6u l=0.13u
MP1974 (n1970 n1769 vdd vdd) p12 w=2.4u l=0.13u
MP1975 (n1970 n1958 vdd vdd) p12 w=2.4u l=0.13u
MN1978 (n1976 n1964 n1977 vss) n12 w=1.6u l=0.13u
MN1979 (n1977 n1970 vss vss) n12 w=1.6u l=0.13u
MP1980 (n1976 n1964 vdd vdd) p12 w=2.4u l=0.13u
MP1981 (n1976 n1970 vdd vdd) p12 w=2.4u l=0.13u
MN1984 (n1982 n1769 n1983 vss) n12 w=1.6u l=0.13u
MN1985 (n1983 n1796 vss vss) n12 w=1.6u l=0.13u
MP1986 (n1982 n1769 vdd vdd) p12 w=2.4u l=0.13u
MP1987 (n1982 n1796 vdd vdd) p12 w=2.4u l=0.13u
MN1990 (n1988 n1769 n1989 vss) n12 w=1.6u l=0.13u
MN1991 (n1989 n1982 vss vss) n12 w=1.6u l=0.13u
MP1992 (n1988 n1769 vdd vdd) p12 w=2.4u l=0.13u
MP1993 (n1988 n1982 vdd vdd) p12 w=2.4u l=0.13u
MN1996 (n1994 n1796 n1995 vss) n12 w=1.6u l=0.13u
MN1997 (n1995 n1982 vss vss) n12 w=1.6u l=0.13u
MP1998 (n1994 n1796 vdd vdd) p12 w=2.4u l=0.13u
MP1999 (n1994 n1982 vdd vdd) p12 w=2.4u l=0.13u
MN2002 (n2000 n1988 n2001 vss) n12 w=1.6u l=0.13u
MN2003 (n2001 n1994 vss vss) n12 w=1.6u l=0.13u
MP2004 (n2000 n1988 vdd vdd) p12 w=2.4u l=0.13u
MP2005 (n2000 n1994 vdd vdd) p12 w=2.4u l=0.13u
MN2008 (n2006 n1796 n2007 vss) n12 w=1.6u l=0.13u
MN2009 (n2007 n1823 vss vss) n12 w=1.6u l=0.13u
MP2010 (n2006 n1796 vdd vdd) p12 w=2.4u l=0.13u
MP2011 (n2006 n1823 vdd vdd) p12 w=2.4u l=0.13u
MN2014 (n2012 n1796 n2013 vss) n12 w=1.6u l=0.13u
MN2015 (n2013 n2006 vss vss) n12 w=1.6u l=0.13u
MP2016 (n2012 n1796 vdd vdd) p12 w=2.4u l=0.13u
MP2017 (n2012 n2006 vdd vdd) p12 w=2.4u l=0.13u
MN2020 (n2018 n1823 n2019 vss) n12 w=1.6u l=0.13u
MN2021 (n2019 n2006 vss vss) n12 w=1.6u l=0.13u
MP2022 (n2018 n1823 vdd vdd) p12 w=2.4u l=0.13u
MP2023 (n2018 n2006 vdd vdd) p12 w=2.4u l=0.13u
MN2026 (n2024 n2012 n2025 vss) n12 w=1.6u l=0.13u
MN2027 (n2025 n2018 vss vss) n12 w=1.6u l=0.13u
MP2028 (n2024 n2012 vdd vdd) p12 w=2.4u l=0.13u
MP2029 (n2024 n2018 vdd vdd) p12 w=2.4u l=0.13u
MN2032 (n2030 n1823 n2031 vss) n12 w=1.6u l=0.13u
MN2033 (n2031 n1850 vss vss) n12 w=1.6u l=0.13u
MP2034 (n2030 n1823 vdd vdd) p12 w=2.4u l=0.13u
MP2035 (n2030 n1850 vdd vdd) p12 w=2.4u l=0.13u
MN2038 (n2036 n1823 n2037 vss) n12 w=1.6u l=0.13u
MN2039 (n2037 n2030 vss vss) n12 w=1.6u l=0.13u
MP2040 (n2036 n1823 vdd vdd) p12 w=2.4u l=0.13u
MP2041 (n2036 n2030 vdd vdd) p12 w=2.4u l=0.13u
MN2044 (n2042 n1850 n2043 vss) n12 w=1.6u l=0.13u
MN2045 (n2043 n2030 vss vss) n12 w=1.6u l=0.13u
MP2046 (n2042 n1850 vdd vdd) p12 w=2.4u l=0.13u
MP2047 (n2042 n2030 vdd vdd) p12 w=2.4u l=0.13u
MN2050 (n2048 n2036 n2049 vss) n12 w=1.6u l=0.13u
MN2051 (n2049 n2042 vss vss) n12 w=1.6u l=0.13u
MP2052 (n2048 n2036 vdd vdd) p12 w=2.4u l=0.13u
MP2053 (n2048 n2042 vdd vdd) p12 w=2.4u l=0.13u
MN2056 (n2054 n1850 n2055 vss) n12 w=1.6u l=0.13u
MN2057 (n2055 n1877 vss vss) n12 w=1.6u l=0.13u
MP2058 (n2054 n1850 vdd vdd) p12 w=2.4u l=0.13u
MP2059 (n2054 n1877 vdd vdd) p12 w=2.4u l=0.13u
MN2062 (n2060 n1850 n2061 vss) n12 w=1.6u l=0.13u
MN2063 (n2061 n2054 vss vss) n12 w=1.6u l=0.13u
MP2064 (n2060 n1850 vdd vdd) p12 w=2.4u l=0.13u
MP2065 (n2060 n2054 vdd vdd) p12 w=2.4u l=0.13u
MN2068 (n2066 n1877 n2067 vss) n12 w=1.6u l=0.13u
MN2069 (n2067 n2054 vss vss) n12 w=1.6u l=0.13u
MP2070 (n2066 n1877 vdd vdd) p12 w=2.4u l=0.13u
MP2071 (n2066 n2054 vdd vdd) p12 w=2.4u l=0.13u
MN2074 (n2072 n2060 n2073 vss) n12 w=1.6u l=0.13u
MN2075 (n2073 n2066 vss vss) n12 w=1.6u l=0.13u
MP2076 (n2072 n2060 vdd vdd) p12 w=2.4u l=0.13u
MP2077 (n2072 n2066 vdd vdd) p12 w=2.4u l=0.13u
MN2079 (delay2078 n596 vss vss) n12 w=0.8u l=0.13u
MP2080 (delay2078 n596 vdd vdd) p12 w=2.4u l=0.13u
MN2082 (delay2081 delay2078 vss vss) n12 w=0.8u l=0.13u
MP2083 (delay2081 delay2078 vdd vdd) p12 w=2.4u l=0.13u
MN2085 (delay2084 delay2081 vss vss) n12 w=0.8u l=0.13u
MP2086 (delay2084 delay2081 vdd vdd) p12 w=2.4u l=0.13u
MN2088 (delay2087 delay2084 vss vss) n12 w=0.8u l=0.13u
MP2089 (delay2087 delay2084 vdd vdd) p12 w=2.4u l=0.13u
MN2091 (delay2090 delay2087 vss vss) n12 w=0.8u l=0.13u
MP2092 (delay2090 delay2087 vdd vdd) p12 w=2.4u l=0.13u
MN2094 (delay2093 delay2090 vss vss) n12 w=0.8u l=0.13u
MP2095 (delay2093 delay2090 vdd vdd) p12 w=2.4u l=0.13u
MN2097 (n2096 n596 vss vss) n12 w=0.8u l=0.13u
MP2098 (n2096 n596 vdd vdd) p12 w=2.4u l=0.13u
MN2100 (n2099 delay2093 vss vss) n12 w=0.8u l=0.13u
MP2101 (n2099 delay2093 vdd vdd) p12 w=2.4u l=0.13u
MN2110 (n2106 n2096 n2107 vss) n12 w=3.2u l=0.13u
MP2111 (n2106 n2096 vdd vdd) p12 w=2.4u l=0.13u
MN2112 (n2107 n2099 n2108 vss) n12 w=3.2u l=0.13u
MP2113 (n2106 n2099 vdd vdd) p12 w=2.4u l=0.13u
MN2114 (n2108 clk_highb2105 n2109 vss) n12 w=3.2u l=0.13u
MP2115 (n2106 clk_highb2105 vdd vdd) p12 w=2.4u l=0.13u
MN2116 (n2109 n1226 vss vss) n12 w=3.2u l=0.13u
MP2117 (n2106 n1226 vdd vdd) p12 w=2.4u l=0.13u
MN2122 (n2118 n596 n2119 vss) n12 w=3.2u l=0.13u
MP2123 (n2118 n596 vdd vdd) p12 w=2.4u l=0.13u
MN2124 (n2119 delay2093 n2120 vss) n12 w=3.2u l=0.13u
MP2125 (n2118 delay2093 vdd vdd) p12 w=2.4u l=0.13u
MN2126 (n2120 clk_lowb2103 n2121 vss) n12 w=3.2u l=0.13u
MP2127 (n2118 clk_lowb2103 vdd vdd) p12 w=2.4u l=0.13u
MN2128 (n2121 n1226 vss vss) n12 w=3.2u l=0.13u
MP2129 (n2118 n1226 vdd vdd) p12 w=2.4u l=0.13u
MN2130 (clk_low2102 n2106 vss vss) n12 w=8u l=0.13u
MP2131 (clk_low2102 n2106 vdd vdd) p12 w=24u l=0.13u
MN2132 (clk_lowb2103 clk_low2102 vss vss) n12 w=8u l=0.13u
MP2133 (clk_lowb2103 clk_low2102 vdd vdd) p12 w=24u l=0.13u
MN2134 (clk_high2104 n2118 vss vss) n12 w=8u l=0.13u
MP2135 (clk_high2104 n2118 vdd vdd) p12 w=24u l=0.13u
MN2136 (clk_highb2105 clk_high2104 vss vss) n12 w=8u l=0.13u
MP2137 (clk_highb2105 clk_high2104 vdd vdd) p12 w=24u l=0.13u
MN2142 (n1904 clk_low2102 storage2141 vss) n12 w=1.2u l=0.13u
MP2143 (n1904 clk_lowb2103 storage2141 vdd) p12 w=3.6u l=0.13u
MN2144 (qm2138 clk_high2104 storage2141 vss) n12 w=1.2u l=0.13u
MP2145 (qm2138 clk_highb2105 storage2141 vdd) p12 w=3.6u l=0.13u
MN2146 (qmb2139 storage2141 vss vss) n12 w=0.5u l=0.13u
MP2147 (qmb2139 storage2141 vdd vdd) p12 w=1.5u l=0.13u
MN2148 (qm2138 qmb2139 vss vss) n12 w=0.5u l=0.13u
MP2149 (qm2138 qmb2139 vdd vdd) p12 w=1.5u l=0.13u
MN2150 (storage2141 reference_count_rst vss vss) n12 w=2u l=0.13u
MN2152 (qm2138 clk_high2104 storage2151 vss) n12 w=1.2u l=0.13u
MP2153 (qm2138 clk_highb2105 storage2151 vdd) p12 w=3.6u l=0.13u
MN2154 (lag_g0 clk_low2102 storage2151 vss) n12 w=1.2u l=0.13u
MP2155 (lag_g0 clk_lowb2103 storage2151 vdd) p12 w=3.6u l=0.13u
MN2156 (qb2140 storage2151 vss vss) n12 w=0.5u l=0.13u
MP2157 (qb2140 storage2151 vdd vdd) p12 w=1.5u l=0.13u
MN2158 (lag_g0 qb2140 vss vss) n12 w=0.5u l=0.13u
MP2159 (lag_g0 qb2140 vdd vdd) p12 w=1.5u l=0.13u
MN2160 (storage2151 reference_count_rst vss vss) n12 w=2u l=0.13u
MN2165 (n1928 clk_low2102 storage2164 vss) n12 w=1.2u l=0.13u
MP2166 (n1928 clk_lowb2103 storage2164 vdd) p12 w=3.6u l=0.13u
MN2167 (qm2161 clk_high2104 storage2164 vss) n12 w=1.2u l=0.13u
MP2168 (qm2161 clk_highb2105 storage2164 vdd) p12 w=3.6u l=0.13u
MN2169 (qmb2162 storage2164 vss vss) n12 w=0.5u l=0.13u
MP2170 (qmb2162 storage2164 vdd vdd) p12 w=1.5u l=0.13u
MN2171 (qm2161 qmb2162 vss vss) n12 w=0.5u l=0.13u
MP2172 (qm2161 qmb2162 vdd vdd) p12 w=1.5u l=0.13u
MN2173 (storage2164 reference_count_rst vss vss) n12 w=2u l=0.13u
MN2175 (qm2161 clk_high2104 storage2174 vss) n12 w=1.2u l=0.13u
MP2176 (qm2161 clk_highb2105 storage2174 vdd) p12 w=3.6u l=0.13u
MN2177 (lag_g1 clk_low2102 storage2174 vss) n12 w=1.2u l=0.13u
MP2178 (lag_g1 clk_lowb2103 storage2174 vdd) p12 w=3.6u l=0.13u
MN2179 (qb2163 storage2174 vss vss) n12 w=0.5u l=0.13u
MP2180 (qb2163 storage2174 vdd vdd) p12 w=1.5u l=0.13u
MN2181 (lag_g1 qb2163 vss vss) n12 w=0.5u l=0.13u
MP2182 (lag_g1 qb2163 vdd vdd) p12 w=1.5u l=0.13u
MN2183 (storage2174 reference_count_rst vss vss) n12 w=2u l=0.13u
MN2188 (n1952 clk_low2102 storage2187 vss) n12 w=1.2u l=0.13u
MP2189 (n1952 clk_lowb2103 storage2187 vdd) p12 w=3.6u l=0.13u
MN2190 (qm2184 clk_high2104 storage2187 vss) n12 w=1.2u l=0.13u
MP2191 (qm2184 clk_highb2105 storage2187 vdd) p12 w=3.6u l=0.13u
MN2192 (qmb2185 storage2187 vss vss) n12 w=0.5u l=0.13u
MP2193 (qmb2185 storage2187 vdd vdd) p12 w=1.5u l=0.13u
MN2194 (qm2184 qmb2185 vss vss) n12 w=0.5u l=0.13u
MP2195 (qm2184 qmb2185 vdd vdd) p12 w=1.5u l=0.13u
MN2196 (storage2187 reference_count_rst vss vss) n12 w=2u l=0.13u
MN2198 (qm2184 clk_high2104 storage2197 vss) n12 w=1.2u l=0.13u
MP2199 (qm2184 clk_highb2105 storage2197 vdd) p12 w=3.6u l=0.13u
MN2200 (lag_g2 clk_low2102 storage2197 vss) n12 w=1.2u l=0.13u
MP2201 (lag_g2 clk_lowb2103 storage2197 vdd) p12 w=3.6u l=0.13u
MN2202 (qb2186 storage2197 vss vss) n12 w=0.5u l=0.13u
MP2203 (qb2186 storage2197 vdd vdd) p12 w=1.5u l=0.13u
MN2204 (lag_g2 qb2186 vss vss) n12 w=0.5u l=0.13u
MP2205 (lag_g2 qb2186 vdd vdd) p12 w=1.5u l=0.13u
MN2206 (storage2197 reference_count_rst vss vss) n12 w=2u l=0.13u
MN2211 (n1976 clk_low2102 storage2210 vss) n12 w=1.2u l=0.13u
MP2212 (n1976 clk_lowb2103 storage2210 vdd) p12 w=3.6u l=0.13u
MN2213 (qm2207 clk_high2104 storage2210 vss) n12 w=1.2u l=0.13u
MP2214 (qm2207 clk_highb2105 storage2210 vdd) p12 w=3.6u l=0.13u
MN2215 (qmb2208 storage2210 vss vss) n12 w=0.5u l=0.13u
MP2216 (qmb2208 storage2210 vdd vdd) p12 w=1.5u l=0.13u
MN2217 (qm2207 qmb2208 vss vss) n12 w=0.5u l=0.13u
MP2218 (qm2207 qmb2208 vdd vdd) p12 w=1.5u l=0.13u
MN2219 (storage2210 reference_count_rst vss vss) n12 w=2u l=0.13u
MN2221 (qm2207 clk_high2104 storage2220 vss) n12 w=1.2u l=0.13u
MP2222 (qm2207 clk_highb2105 storage2220 vdd) p12 w=3.6u l=0.13u
MN2223 (lag_g3 clk_low2102 storage2220 vss) n12 w=1.2u l=0.13u
MP2224 (lag_g3 clk_lowb2103 storage2220 vdd) p12 w=3.6u l=0.13u
MN2225 (qb2209 storage2220 vss vss) n12 w=0.5u l=0.13u
MP2226 (qb2209 storage2220 vdd vdd) p12 w=1.5u l=0.13u
MN2227 (lag_g3 qb2209 vss vss) n12 w=0.5u l=0.13u
MP2228 (lag_g3 qb2209 vdd vdd) p12 w=1.5u l=0.13u
MN2229 (storage2220 reference_count_rst vss vss) n12 w=2u l=0.13u
MN2234 (n2000 clk_low2102 storage2233 vss) n12 w=1.2u l=0.13u
MP2235 (n2000 clk_lowb2103 storage2233 vdd) p12 w=3.6u l=0.13u
MN2236 (qm2230 clk_high2104 storage2233 vss) n12 w=1.2u l=0.13u
MP2237 (qm2230 clk_highb2105 storage2233 vdd) p12 w=3.6u l=0.13u
MN2238 (qmb2231 storage2233 vss vss) n12 w=0.5u l=0.13u
MP2239 (qmb2231 storage2233 vdd vdd) p12 w=1.5u l=0.13u
MN2240 (qm2230 qmb2231 vss vss) n12 w=0.5u l=0.13u
MP2241 (qm2230 qmb2231 vdd vdd) p12 w=1.5u l=0.13u
MN2242 (storage2233 reference_count_rst vss vss) n12 w=2u l=0.13u
MN2244 (qm2230 clk_high2104 storage2243 vss) n12 w=1.2u l=0.13u
MP2245 (qm2230 clk_highb2105 storage2243 vdd) p12 w=3.6u l=0.13u
MN2246 (lag_g4 clk_low2102 storage2243 vss) n12 w=1.2u l=0.13u
MP2247 (lag_g4 clk_lowb2103 storage2243 vdd) p12 w=3.6u l=0.13u
MN2248 (qb2232 storage2243 vss vss) n12 w=0.5u l=0.13u
MP2249 (qb2232 storage2243 vdd vdd) p12 w=1.5u l=0.13u
MN2250 (lag_g4 qb2232 vss vss) n12 w=0.5u l=0.13u
MP2251 (lag_g4 qb2232 vdd vdd) p12 w=1.5u l=0.13u
MN2252 (storage2243 reference_count_rst vss vss) n12 w=2u l=0.13u
MN2257 (n2024 clk_low2102 storage2256 vss) n12 w=1.2u l=0.13u
MP2258 (n2024 clk_lowb2103 storage2256 vdd) p12 w=3.6u l=0.13u
MN2259 (qm2253 clk_high2104 storage2256 vss) n12 w=1.2u l=0.13u
MP2260 (qm2253 clk_highb2105 storage2256 vdd) p12 w=3.6u l=0.13u
MN2261 (qmb2254 storage2256 vss vss) n12 w=0.5u l=0.13u
MP2262 (qmb2254 storage2256 vdd vdd) p12 w=1.5u l=0.13u
MN2263 (qm2253 qmb2254 vss vss) n12 w=0.5u l=0.13u
MP2264 (qm2253 qmb2254 vdd vdd) p12 w=1.5u l=0.13u
MN2265 (storage2256 reference_count_rst vss vss) n12 w=2u l=0.13u
MN2267 (qm2253 clk_high2104 storage2266 vss) n12 w=1.2u l=0.13u
MP2268 (qm2253 clk_highb2105 storage2266 vdd) p12 w=3.6u l=0.13u
MN2269 (lag_g5 clk_low2102 storage2266 vss) n12 w=1.2u l=0.13u
MP2270 (lag_g5 clk_lowb2103 storage2266 vdd) p12 w=3.6u l=0.13u
MN2271 (qb2255 storage2266 vss vss) n12 w=0.5u l=0.13u
MP2272 (qb2255 storage2266 vdd vdd) p12 w=1.5u l=0.13u
MN2273 (lag_g5 qb2255 vss vss) n12 w=0.5u l=0.13u
MP2274 (lag_g5 qb2255 vdd vdd) p12 w=1.5u l=0.13u
MN2275 (storage2266 reference_count_rst vss vss) n12 w=2u l=0.13u
MN2280 (n2048 clk_low2102 storage2279 vss) n12 w=1.2u l=0.13u
MP2281 (n2048 clk_lowb2103 storage2279 vdd) p12 w=3.6u l=0.13u
MN2282 (qm2276 clk_high2104 storage2279 vss) n12 w=1.2u l=0.13u
MP2283 (qm2276 clk_highb2105 storage2279 vdd) p12 w=3.6u l=0.13u
MN2284 (qmb2277 storage2279 vss vss) n12 w=0.5u l=0.13u
MP2285 (qmb2277 storage2279 vdd vdd) p12 w=1.5u l=0.13u
MN2286 (qm2276 qmb2277 vss vss) n12 w=0.5u l=0.13u
MP2287 (qm2276 qmb2277 vdd vdd) p12 w=1.5u l=0.13u
MN2288 (storage2279 reference_count_rst vss vss) n12 w=2u l=0.13u
MN2290 (qm2276 clk_high2104 storage2289 vss) n12 w=1.2u l=0.13u
MP2291 (qm2276 clk_highb2105 storage2289 vdd) p12 w=3.6u l=0.13u
MN2292 (lag_g6 clk_low2102 storage2289 vss) n12 w=1.2u l=0.13u
MP2293 (lag_g6 clk_lowb2103 storage2289 vdd) p12 w=3.6u l=0.13u
MN2294 (qb2278 storage2289 vss vss) n12 w=0.5u l=0.13u
MP2295 (qb2278 storage2289 vdd vdd) p12 w=1.5u l=0.13u
MN2296 (lag_g6 qb2278 vss vss) n12 w=0.5u l=0.13u
MP2297 (lag_g6 qb2278 vdd vdd) p12 w=1.5u l=0.13u
MN2298 (storage2289 reference_count_rst vss vss) n12 w=2u l=0.13u
MN2303 (n2072 clk_low2102 storage2302 vss) n12 w=1.2u l=0.13u
MP2304 (n2072 clk_lowb2103 storage2302 vdd) p12 w=3.6u l=0.13u
MN2305 (qm2299 clk_high2104 storage2302 vss) n12 w=1.2u l=0.13u
MP2306 (qm2299 clk_highb2105 storage2302 vdd) p12 w=3.6u l=0.13u
MN2307 (qmb2300 storage2302 vss vss) n12 w=0.5u l=0.13u
MP2308 (qmb2300 storage2302 vdd vdd) p12 w=1.5u l=0.13u
MN2309 (qm2299 qmb2300 vss vss) n12 w=0.5u l=0.13u
MP2310 (qm2299 qmb2300 vdd vdd) p12 w=1.5u l=0.13u
MN2311 (storage2302 reference_count_rst vss vss) n12 w=2u l=0.13u
MN2313 (qm2299 clk_high2104 storage2312 vss) n12 w=1.2u l=0.13u
MP2314 (qm2299 clk_highb2105 storage2312 vdd) p12 w=3.6u l=0.13u
MN2315 (lag_g7 clk_low2102 storage2312 vss) n12 w=1.2u l=0.13u
MP2316 (lag_g7 clk_lowb2103 storage2312 vdd) p12 w=3.6u l=0.13u
MN2317 (qb2301 storage2312 vss vss) n12 w=0.5u l=0.13u
MP2318 (qb2301 storage2312 vdd vdd) p12 w=1.5u l=0.13u
MN2319 (lag_g7 qb2301 vss vss) n12 w=0.5u l=0.13u
MP2320 (lag_g7 qb2301 vdd vdd) p12 w=1.5u l=0.13u
MN2321 (storage2312 reference_count_rst vss vss) n12 w=2u l=0.13u
MN2326 (n1877 clk_low2102 storage2325 vss) n12 w=1.2u l=0.13u
MP2327 (n1877 clk_lowb2103 storage2325 vdd) p12 w=3.6u l=0.13u
MN2328 (qm2322 clk_high2104 storage2325 vss) n12 w=1.2u l=0.13u
MP2329 (qm2322 clk_highb2105 storage2325 vdd) p12 w=3.6u l=0.13u
MN2330 (qmb2323 storage2325 vss vss) n12 w=0.5u l=0.13u
MP2331 (qmb2323 storage2325 vdd vdd) p12 w=1.5u l=0.13u
MN2332 (qm2322 qmb2323 vss vss) n12 w=0.5u l=0.13u
MP2333 (qm2322 qmb2323 vdd vdd) p12 w=1.5u l=0.13u
MN2334 (storage2325 reference_count_rst vss vss) n12 w=2u l=0.13u
MN2336 (qm2322 clk_high2104 storage2335 vss) n12 w=1.2u l=0.13u
MP2337 (qm2322 clk_highb2105 storage2335 vdd) p12 w=3.6u l=0.13u
MN2338 (lag_g8 clk_low2102 storage2335 vss) n12 w=1.2u l=0.13u
MP2339 (lag_g8 clk_lowb2103 storage2335 vdd) p12 w=3.6u l=0.13u
MN2340 (qb2324 storage2335 vss vss) n12 w=0.5u l=0.13u
MP2341 (qb2324 storage2335 vdd vdd) p12 w=1.5u l=0.13u
MN2342 (lag_g8 qb2324 vss vss) n12 w=0.5u l=0.13u
MP2343 (lag_g8 qb2324 vdd vdd) p12 w=1.5u l=0.13u
MN2344 (storage2335 reference_count_rst vss vss) n12 w=2u l=0.13u
MN2347 (n2345 div_g7 n2346 vss) n12 w=1.6u l=0.13u
MN2348 (n2346 div_g8 vss vss) n12 w=1.6u l=0.13u
MP2349 (n2345 div_g7 vdd vdd) p12 w=2.4u l=0.13u
MP2350 (n2345 div_g8 vdd vdd) p12 w=2.4u l=0.13u
MN2353 (n2351 div_g7 n2352 vss) n12 w=1.6u l=0.13u
MN2354 (n2352 n2345 vss vss) n12 w=1.6u l=0.13u
MP2355 (n2351 div_g7 vdd vdd) p12 w=2.4u l=0.13u
MP2356 (n2351 n2345 vdd vdd) p12 w=2.4u l=0.13u
MN2359 (n2357 div_g8 n2358 vss) n12 w=1.6u l=0.13u
MN2360 (n2358 n2345 vss vss) n12 w=1.6u l=0.13u
MP2361 (n2357 div_g8 vdd vdd) p12 w=2.4u l=0.13u
MP2362 (n2357 n2345 vdd vdd) p12 w=2.4u l=0.13u
MN2365 (n2363 n2351 n2364 vss) n12 w=1.6u l=0.13u
MN2366 (n2364 n2357 vss vss) n12 w=1.6u l=0.13u
MP2367 (n2363 n2351 vdd vdd) p12 w=2.4u l=0.13u
MP2368 (n2363 n2357 vdd vdd) p12 w=2.4u l=0.13u
MN2371 (n2369 div_g6 n2370 vss) n12 w=1.6u l=0.13u
MN2372 (n2370 n2363 vss vss) n12 w=1.6u l=0.13u
MP2373 (n2369 div_g6 vdd vdd) p12 w=2.4u l=0.13u
MP2374 (n2369 n2363 vdd vdd) p12 w=2.4u l=0.13u
MN2377 (n2375 div_g6 n2376 vss) n12 w=1.6u l=0.13u
MN2378 (n2376 n2369 vss vss) n12 w=1.6u l=0.13u
MP2379 (n2375 div_g6 vdd vdd) p12 w=2.4u l=0.13u
MP2380 (n2375 n2369 vdd vdd) p12 w=2.4u l=0.13u
MN2383 (n2381 n2363 n2382 vss) n12 w=1.6u l=0.13u
MN2384 (n2382 n2369 vss vss) n12 w=1.6u l=0.13u
MP2385 (n2381 n2363 vdd vdd) p12 w=2.4u l=0.13u
MP2386 (n2381 n2369 vdd vdd) p12 w=2.4u l=0.13u
MN2389 (n2387 n2375 n2388 vss) n12 w=1.6u l=0.13u
MN2390 (n2388 n2381 vss vss) n12 w=1.6u l=0.13u
MP2391 (n2387 n2375 vdd vdd) p12 w=2.4u l=0.13u
MP2392 (n2387 n2381 vdd vdd) p12 w=2.4u l=0.13u
MN2395 (n2393 div_g5 n2394 vss) n12 w=1.6u l=0.13u
MN2396 (n2394 n2387 vss vss) n12 w=1.6u l=0.13u
MP2397 (n2393 div_g5 vdd vdd) p12 w=2.4u l=0.13u
MP2398 (n2393 n2387 vdd vdd) p12 w=2.4u l=0.13u
MN2401 (n2399 div_g5 n2400 vss) n12 w=1.6u l=0.13u
MN2402 (n2400 n2393 vss vss) n12 w=1.6u l=0.13u
MP2403 (n2399 div_g5 vdd vdd) p12 w=2.4u l=0.13u
MP2404 (n2399 n2393 vdd vdd) p12 w=2.4u l=0.13u
MN2407 (n2405 n2387 n2406 vss) n12 w=1.6u l=0.13u
MN2408 (n2406 n2393 vss vss) n12 w=1.6u l=0.13u
MP2409 (n2405 n2387 vdd vdd) p12 w=2.4u l=0.13u
MP2410 (n2405 n2393 vdd vdd) p12 w=2.4u l=0.13u
MN2413 (n2411 n2399 n2412 vss) n12 w=1.6u l=0.13u
MN2414 (n2412 n2405 vss vss) n12 w=1.6u l=0.13u
MP2415 (n2411 n2399 vdd vdd) p12 w=2.4u l=0.13u
MP2416 (n2411 n2405 vdd vdd) p12 w=2.4u l=0.13u
MN2419 (n2417 div_g4 n2418 vss) n12 w=1.6u l=0.13u
MN2420 (n2418 n2411 vss vss) n12 w=1.6u l=0.13u
MP2421 (n2417 div_g4 vdd vdd) p12 w=2.4u l=0.13u
MP2422 (n2417 n2411 vdd vdd) p12 w=2.4u l=0.13u
MN2425 (n2423 div_g4 n2424 vss) n12 w=1.6u l=0.13u
MN2426 (n2424 n2417 vss vss) n12 w=1.6u l=0.13u
MP2427 (n2423 div_g4 vdd vdd) p12 w=2.4u l=0.13u
MP2428 (n2423 n2417 vdd vdd) p12 w=2.4u l=0.13u
MN2431 (n2429 n2411 n2430 vss) n12 w=1.6u l=0.13u
MN2432 (n2430 n2417 vss vss) n12 w=1.6u l=0.13u
MP2433 (n2429 n2411 vdd vdd) p12 w=2.4u l=0.13u
MP2434 (n2429 n2417 vdd vdd) p12 w=2.4u l=0.13u
MN2437 (n2435 n2423 n2436 vss) n12 w=1.6u l=0.13u
MN2438 (n2436 n2429 vss vss) n12 w=1.6u l=0.13u
MP2439 (n2435 n2423 vdd vdd) p12 w=2.4u l=0.13u
MP2440 (n2435 n2429 vdd vdd) p12 w=2.4u l=0.13u
MN2443 (n2441 div_g3 n2442 vss) n12 w=1.6u l=0.13u
MN2444 (n2442 n2435 vss vss) n12 w=1.6u l=0.13u
MP2445 (n2441 div_g3 vdd vdd) p12 w=2.4u l=0.13u
MP2446 (n2441 n2435 vdd vdd) p12 w=2.4u l=0.13u
MN2449 (n2447 div_g3 n2448 vss) n12 w=1.6u l=0.13u
MN2450 (n2448 n2441 vss vss) n12 w=1.6u l=0.13u
MP2451 (n2447 div_g3 vdd vdd) p12 w=2.4u l=0.13u
MP2452 (n2447 n2441 vdd vdd) p12 w=2.4u l=0.13u
MN2455 (n2453 n2435 n2454 vss) n12 w=1.6u l=0.13u
MN2456 (n2454 n2441 vss vss) n12 w=1.6u l=0.13u
MP2457 (n2453 n2435 vdd vdd) p12 w=2.4u l=0.13u
MP2458 (n2453 n2441 vdd vdd) p12 w=2.4u l=0.13u
MN2461 (n2459 n2447 n2460 vss) n12 w=1.6u l=0.13u
MN2462 (n2460 n2453 vss vss) n12 w=1.6u l=0.13u
MP2463 (n2459 n2447 vdd vdd) p12 w=2.4u l=0.13u
MP2464 (n2459 n2453 vdd vdd) p12 w=2.4u l=0.13u
MN2467 (n2465 div_g2 n2466 vss) n12 w=1.6u l=0.13u
MN2468 (n2466 n2459 vss vss) n12 w=1.6u l=0.13u
MP2469 (n2465 div_g2 vdd vdd) p12 w=2.4u l=0.13u
MP2470 (n2465 n2459 vdd vdd) p12 w=2.4u l=0.13u
MN2473 (n2471 div_g2 n2472 vss) n12 w=1.6u l=0.13u
MN2474 (n2472 n2465 vss vss) n12 w=1.6u l=0.13u
MP2475 (n2471 div_g2 vdd vdd) p12 w=2.4u l=0.13u
MP2476 (n2471 n2465 vdd vdd) p12 w=2.4u l=0.13u
MN2479 (n2477 n2459 n2478 vss) n12 w=1.6u l=0.13u
MN2480 (n2478 n2465 vss vss) n12 w=1.6u l=0.13u
MP2481 (n2477 n2459 vdd vdd) p12 w=2.4u l=0.13u
MP2482 (n2477 n2465 vdd vdd) p12 w=2.4u l=0.13u
MN2485 (n2483 n2471 n2484 vss) n12 w=1.6u l=0.13u
MN2486 (n2484 n2477 vss vss) n12 w=1.6u l=0.13u
MP2487 (n2483 n2471 vdd vdd) p12 w=2.4u l=0.13u
MP2488 (n2483 n2477 vdd vdd) p12 w=2.4u l=0.13u
MN2491 (n2489 div_g1 n2490 vss) n12 w=1.6u l=0.13u
MN2492 (n2490 n2483 vss vss) n12 w=1.6u l=0.13u
MP2493 (n2489 div_g1 vdd vdd) p12 w=2.4u l=0.13u
MP2494 (n2489 n2483 vdd vdd) p12 w=2.4u l=0.13u
MN2497 (n2495 div_g1 n2496 vss) n12 w=1.6u l=0.13u
MN2498 (n2496 n2489 vss vss) n12 w=1.6u l=0.13u
MP2499 (n2495 div_g1 vdd vdd) p12 w=2.4u l=0.13u
MP2500 (n2495 n2489 vdd vdd) p12 w=2.4u l=0.13u
MN2503 (n2501 n2483 n2502 vss) n12 w=1.6u l=0.13u
MN2504 (n2502 n2489 vss vss) n12 w=1.6u l=0.13u
MP2505 (n2501 n2483 vdd vdd) p12 w=2.4u l=0.13u
MP2506 (n2501 n2489 vdd vdd) p12 w=2.4u l=0.13u
MN2509 (n2507 n2495 n2508 vss) n12 w=1.6u l=0.13u
MN2510 (n2508 n2501 vss vss) n12 w=1.6u l=0.13u
MP2511 (n2507 n2495 vdd vdd) p12 w=2.4u l=0.13u
MP2512 (n2507 n2501 vdd vdd) p12 w=2.4u l=0.13u
MN2515 (n2513 div_g0 n2514 vss) n12 w=1.6u l=0.13u
MN2516 (n2514 n2507 vss vss) n12 w=1.6u l=0.13u
MP2517 (n2513 div_g0 vdd vdd) p12 w=2.4u l=0.13u
MP2518 (n2513 n2507 vdd vdd) p12 w=2.4u l=0.13u
MN2521 (n2519 div_g0 n2520 vss) n12 w=1.6u l=0.13u
MN2522 (n2520 n2513 vss vss) n12 w=1.6u l=0.13u
MP2523 (n2519 div_g0 vdd vdd) p12 w=2.4u l=0.13u
MP2524 (n2519 n2513 vdd vdd) p12 w=2.4u l=0.13u
MN2527 (n2525 n2507 n2526 vss) n12 w=1.6u l=0.13u
MN2528 (n2526 n2513 vss vss) n12 w=1.6u l=0.13u
MP2529 (n2525 n2507 vdd vdd) p12 w=2.4u l=0.13u
MP2530 (n2525 n2513 vdd vdd) p12 w=2.4u l=0.13u
MN2533 (n2531 n2519 n2532 vss) n12 w=1.6u l=0.13u
MN2534 (n2532 n2525 vss vss) n12 w=1.6u l=0.13u
MP2535 (n2531 n2519 vdd vdd) p12 w=2.4u l=0.13u
MP2536 (n2531 n2525 vdd vdd) p12 w=2.4u l=0.13u
MN2538 (n2537 n2531 vss vss) n12 w=0.8u l=0.13u
MP2539 (n2537 n2531 vdd vdd) p12 w=2.4u l=0.13u
MN2542 (n2540 n2507 n2541 vss) n12 w=1.6u l=0.13u
MN2543 (n2541 n2531 vss vss) n12 w=1.6u l=0.13u
MP2544 (n2540 n2507 vdd vdd) p12 w=2.4u l=0.13u
MP2545 (n2540 n2531 vdd vdd) p12 w=2.4u l=0.13u
MN2548 (n2546 n2507 n2547 vss) n12 w=1.6u l=0.13u
MN2549 (n2547 n2540 vss vss) n12 w=1.6u l=0.13u
MP2550 (n2546 n2507 vdd vdd) p12 w=2.4u l=0.13u
MP2551 (n2546 n2540 vdd vdd) p12 w=2.4u l=0.13u
MN2554 (n2552 n2531 n2553 vss) n12 w=1.6u l=0.13u
MN2555 (n2553 n2540 vss vss) n12 w=1.6u l=0.13u
MP2556 (n2552 n2531 vdd vdd) p12 w=2.4u l=0.13u
MP2557 (n2552 n2540 vdd vdd) p12 w=2.4u l=0.13u
MN2560 (n2558 n2546 n2559 vss) n12 w=1.6u l=0.13u
MN2561 (n2559 n2552 vss vss) n12 w=1.6u l=0.13u
MP2562 (n2558 n2546 vdd vdd) p12 w=2.4u l=0.13u
MP2563 (n2558 n2552 vdd vdd) p12 w=2.4u l=0.13u
MN2565 (n2564 n2540 vss vss) n12 w=0.8u l=0.13u
MP2566 (n2564 n2540 vdd vdd) p12 w=2.4u l=0.13u
MN2569 (n2567 n2483 n2568 vss) n12 w=1.6u l=0.13u
MN2570 (n2568 n2564 vss vss) n12 w=1.6u l=0.13u
MP2571 (n2567 n2483 vdd vdd) p12 w=2.4u l=0.13u
MP2572 (n2567 n2564 vdd vdd) p12 w=2.4u l=0.13u
MN2575 (n2573 n2483 n2574 vss) n12 w=1.6u l=0.13u
MN2576 (n2574 n2567 vss vss) n12 w=1.6u l=0.13u
MP2577 (n2573 n2483 vdd vdd) p12 w=2.4u l=0.13u
MP2578 (n2573 n2567 vdd vdd) p12 w=2.4u l=0.13u
MN2581 (n2579 n2564 n2580 vss) n12 w=1.6u l=0.13u
MN2582 (n2580 n2567 vss vss) n12 w=1.6u l=0.13u
MP2583 (n2579 n2564 vdd vdd) p12 w=2.4u l=0.13u
MP2584 (n2579 n2567 vdd vdd) p12 w=2.4u l=0.13u
MN2587 (n2585 n2573 n2586 vss) n12 w=1.6u l=0.13u
MN2588 (n2586 n2579 vss vss) n12 w=1.6u l=0.13u
MP2589 (n2585 n2573 vdd vdd) p12 w=2.4u l=0.13u
MP2590 (n2585 n2579 vdd vdd) p12 w=2.4u l=0.13u
MN2592 (n2591 n2567 vss vss) n12 w=0.8u l=0.13u
MP2593 (n2591 n2567 vdd vdd) p12 w=2.4u l=0.13u
MN2596 (n2594 n2459 n2595 vss) n12 w=1.6u l=0.13u
MN2597 (n2595 n2591 vss vss) n12 w=1.6u l=0.13u
MP2598 (n2594 n2459 vdd vdd) p12 w=2.4u l=0.13u
MP2599 (n2594 n2591 vdd vdd) p12 w=2.4u l=0.13u
MN2602 (n2600 n2459 n2601 vss) n12 w=1.6u l=0.13u
MN2603 (n2601 n2594 vss vss) n12 w=1.6u l=0.13u
MP2604 (n2600 n2459 vdd vdd) p12 w=2.4u l=0.13u
MP2605 (n2600 n2594 vdd vdd) p12 w=2.4u l=0.13u
MN2608 (n2606 n2591 n2607 vss) n12 w=1.6u l=0.13u
MN2609 (n2607 n2594 vss vss) n12 w=1.6u l=0.13u
MP2610 (n2606 n2591 vdd vdd) p12 w=2.4u l=0.13u
MP2611 (n2606 n2594 vdd vdd) p12 w=2.4u l=0.13u
MN2614 (n2612 n2600 n2613 vss) n12 w=1.6u l=0.13u
MN2615 (n2613 n2606 vss vss) n12 w=1.6u l=0.13u
MP2616 (n2612 n2600 vdd vdd) p12 w=2.4u l=0.13u
MP2617 (n2612 n2606 vdd vdd) p12 w=2.4u l=0.13u
MN2619 (n2618 n2594 vss vss) n12 w=0.8u l=0.13u
MP2620 (n2618 n2594 vdd vdd) p12 w=2.4u l=0.13u
MN2623 (n2621 n2435 n2622 vss) n12 w=1.6u l=0.13u
MN2624 (n2622 n2618 vss vss) n12 w=1.6u l=0.13u
MP2625 (n2621 n2435 vdd vdd) p12 w=2.4u l=0.13u
MP2626 (n2621 n2618 vdd vdd) p12 w=2.4u l=0.13u
MN2629 (n2627 n2435 n2628 vss) n12 w=1.6u l=0.13u
MN2630 (n2628 n2621 vss vss) n12 w=1.6u l=0.13u
MP2631 (n2627 n2435 vdd vdd) p12 w=2.4u l=0.13u
MP2632 (n2627 n2621 vdd vdd) p12 w=2.4u l=0.13u
MN2635 (n2633 n2618 n2634 vss) n12 w=1.6u l=0.13u
MN2636 (n2634 n2621 vss vss) n12 w=1.6u l=0.13u
MP2637 (n2633 n2618 vdd vdd) p12 w=2.4u l=0.13u
MP2638 (n2633 n2621 vdd vdd) p12 w=2.4u l=0.13u
MN2641 (n2639 n2627 n2640 vss) n12 w=1.6u l=0.13u
MN2642 (n2640 n2633 vss vss) n12 w=1.6u l=0.13u
MP2643 (n2639 n2627 vdd vdd) p12 w=2.4u l=0.13u
MP2644 (n2639 n2633 vdd vdd) p12 w=2.4u l=0.13u
MN2646 (n2645 n2621 vss vss) n12 w=0.8u l=0.13u
MP2647 (n2645 n2621 vdd vdd) p12 w=2.4u l=0.13u
MN2650 (n2648 n2411 n2649 vss) n12 w=1.6u l=0.13u
MN2651 (n2649 n2645 vss vss) n12 w=1.6u l=0.13u
MP2652 (n2648 n2411 vdd vdd) p12 w=2.4u l=0.13u
MP2653 (n2648 n2645 vdd vdd) p12 w=2.4u l=0.13u
MN2656 (n2654 n2411 n2655 vss) n12 w=1.6u l=0.13u
MN2657 (n2655 n2648 vss vss) n12 w=1.6u l=0.13u
MP2658 (n2654 n2411 vdd vdd) p12 w=2.4u l=0.13u
MP2659 (n2654 n2648 vdd vdd) p12 w=2.4u l=0.13u
MN2662 (n2660 n2645 n2661 vss) n12 w=1.6u l=0.13u
MN2663 (n2661 n2648 vss vss) n12 w=1.6u l=0.13u
MP2664 (n2660 n2645 vdd vdd) p12 w=2.4u l=0.13u
MP2665 (n2660 n2648 vdd vdd) p12 w=2.4u l=0.13u
MN2668 (n2666 n2654 n2667 vss) n12 w=1.6u l=0.13u
MN2669 (n2667 n2660 vss vss) n12 w=1.6u l=0.13u
MP2670 (n2666 n2654 vdd vdd) p12 w=2.4u l=0.13u
MP2671 (n2666 n2660 vdd vdd) p12 w=2.4u l=0.13u
MN2673 (n2672 n2648 vss vss) n12 w=0.8u l=0.13u
MP2674 (n2672 n2648 vdd vdd) p12 w=2.4u l=0.13u
MN2677 (n2675 n2387 n2676 vss) n12 w=1.6u l=0.13u
MN2678 (n2676 n2672 vss vss) n12 w=1.6u l=0.13u
MP2679 (n2675 n2387 vdd vdd) p12 w=2.4u l=0.13u
MP2680 (n2675 n2672 vdd vdd) p12 w=2.4u l=0.13u
MN2683 (n2681 n2387 n2682 vss) n12 w=1.6u l=0.13u
MN2684 (n2682 n2675 vss vss) n12 w=1.6u l=0.13u
MP2685 (n2681 n2387 vdd vdd) p12 w=2.4u l=0.13u
MP2686 (n2681 n2675 vdd vdd) p12 w=2.4u l=0.13u
MN2689 (n2687 n2672 n2688 vss) n12 w=1.6u l=0.13u
MN2690 (n2688 n2675 vss vss) n12 w=1.6u l=0.13u
MP2691 (n2687 n2672 vdd vdd) p12 w=2.4u l=0.13u
MP2692 (n2687 n2675 vdd vdd) p12 w=2.4u l=0.13u
MN2695 (n2693 n2681 n2694 vss) n12 w=1.6u l=0.13u
MN2696 (n2694 n2687 vss vss) n12 w=1.6u l=0.13u
MP2697 (n2693 n2681 vdd vdd) p12 w=2.4u l=0.13u
MP2698 (n2693 n2687 vdd vdd) p12 w=2.4u l=0.13u
MN2700 (n2699 n2675 vss vss) n12 w=0.8u l=0.13u
MP2701 (n2699 n2675 vdd vdd) p12 w=2.4u l=0.13u
MN2704 (n2702 n2363 n2703 vss) n12 w=1.6u l=0.13u
MN2705 (n2703 n2699 vss vss) n12 w=1.6u l=0.13u
MP2706 (n2702 n2363 vdd vdd) p12 w=2.4u l=0.13u
MP2707 (n2702 n2699 vdd vdd) p12 w=2.4u l=0.13u
MN2710 (n2708 n2363 n2709 vss) n12 w=1.6u l=0.13u
MN2711 (n2709 n2702 vss vss) n12 w=1.6u l=0.13u
MP2712 (n2708 n2363 vdd vdd) p12 w=2.4u l=0.13u
MP2713 (n2708 n2702 vdd vdd) p12 w=2.4u l=0.13u
MN2716 (n2714 n2699 n2715 vss) n12 w=1.6u l=0.13u
MN2717 (n2715 n2702 vss vss) n12 w=1.6u l=0.13u
MP2718 (n2714 n2699 vdd vdd) p12 w=2.4u l=0.13u
MP2719 (n2714 n2702 vdd vdd) p12 w=2.4u l=0.13u
MN2722 (n2720 n2708 n2721 vss) n12 w=1.6u l=0.13u
MN2723 (n2721 n2714 vss vss) n12 w=1.6u l=0.13u
MP2724 (n2720 n2708 vdd vdd) p12 w=2.4u l=0.13u
MP2725 (n2720 n2714 vdd vdd) p12 w=2.4u l=0.13u
MN2727 (n2726 n2702 vss vss) n12 w=0.8u l=0.13u
MP2728 (n2726 n2702 vdd vdd) p12 w=2.4u l=0.13u
MN2731 (n2729 div_g8 n2730 vss) n12 w=1.6u l=0.13u
MN2732 (n2730 n2726 vss vss) n12 w=1.6u l=0.13u
MP2733 (n2729 div_g8 vdd vdd) p12 w=2.4u l=0.13u
MP2734 (n2729 n2726 vdd vdd) p12 w=2.4u l=0.13u
MN2737 (n2735 div_g8 n2736 vss) n12 w=1.6u l=0.13u
MN2738 (n2736 n2729 vss vss) n12 w=1.6u l=0.13u
MP2739 (n2735 div_g8 vdd vdd) p12 w=2.4u l=0.13u
MP2740 (n2735 n2729 vdd vdd) p12 w=2.4u l=0.13u
MN2743 (n2741 n2726 n2742 vss) n12 w=1.6u l=0.13u
MN2744 (n2742 n2729 vss vss) n12 w=1.6u l=0.13u
MP2745 (n2741 n2726 vdd vdd) p12 w=2.4u l=0.13u
MP2746 (n2741 n2729 vdd vdd) p12 w=2.4u l=0.13u
MN2749 (n2747 n2735 n2748 vss) n12 w=1.6u l=0.13u
MN2750 (n2748 n2741 vss vss) n12 w=1.6u l=0.13u
MP2751 (n2747 n2735 vdd vdd) p12 w=2.4u l=0.13u
MP2752 (n2747 n2741 vdd vdd) p12 w=2.4u l=0.13u
MN2754 (n2753 n2729 vss vss) n12 w=0.8u l=0.13u
MP2755 (n2753 n2729 vdd vdd) p12 w=2.4u l=0.13u
MN2758 (n2756 n2537 n2757 vss) n12 w=1.6u l=0.13u
MN2759 (n2757 n2558 vss vss) n12 w=1.6u l=0.13u
MP2760 (n2756 n2537 vdd vdd) p12 w=2.4u l=0.13u
MP2761 (n2756 n2558 vdd vdd) p12 w=2.4u l=0.13u
MN2764 (n2762 n2537 n2763 vss) n12 w=1.6u l=0.13u
MN2765 (n2763 n2756 vss vss) n12 w=1.6u l=0.13u
MP2766 (n2762 n2537 vdd vdd) p12 w=2.4u l=0.13u
MP2767 (n2762 n2756 vdd vdd) p12 w=2.4u l=0.13u
MN2770 (n2768 n2558 n2769 vss) n12 w=1.6u l=0.13u
MN2771 (n2769 n2756 vss vss) n12 w=1.6u l=0.13u
MP2772 (n2768 n2558 vdd vdd) p12 w=2.4u l=0.13u
MP2773 (n2768 n2756 vdd vdd) p12 w=2.4u l=0.13u
MN2776 (n2774 n2762 n2775 vss) n12 w=1.6u l=0.13u
MN2777 (n2775 n2768 vss vss) n12 w=1.6u l=0.13u
MP2778 (n2774 n2762 vdd vdd) p12 w=2.4u l=0.13u
MP2779 (n2774 n2768 vdd vdd) p12 w=2.4u l=0.13u
MN2782 (n2780 n2558 n2781 vss) n12 w=1.6u l=0.13u
MN2783 (n2781 n2585 vss vss) n12 w=1.6u l=0.13u
MP2784 (n2780 n2558 vdd vdd) p12 w=2.4u l=0.13u
MP2785 (n2780 n2585 vdd vdd) p12 w=2.4u l=0.13u
MN2788 (n2786 n2558 n2787 vss) n12 w=1.6u l=0.13u
MN2789 (n2787 n2780 vss vss) n12 w=1.6u l=0.13u
MP2790 (n2786 n2558 vdd vdd) p12 w=2.4u l=0.13u
MP2791 (n2786 n2780 vdd vdd) p12 w=2.4u l=0.13u
MN2794 (n2792 n2585 n2793 vss) n12 w=1.6u l=0.13u
MN2795 (n2793 n2780 vss vss) n12 w=1.6u l=0.13u
MP2796 (n2792 n2585 vdd vdd) p12 w=2.4u l=0.13u
MP2797 (n2792 n2780 vdd vdd) p12 w=2.4u l=0.13u
MN2800 (n2798 n2786 n2799 vss) n12 w=1.6u l=0.13u
MN2801 (n2799 n2792 vss vss) n12 w=1.6u l=0.13u
MP2802 (n2798 n2786 vdd vdd) p12 w=2.4u l=0.13u
MP2803 (n2798 n2792 vdd vdd) p12 w=2.4u l=0.13u
MN2806 (n2804 n2585 n2805 vss) n12 w=1.6u l=0.13u
MN2807 (n2805 n2612 vss vss) n12 w=1.6u l=0.13u
MP2808 (n2804 n2585 vdd vdd) p12 w=2.4u l=0.13u
MP2809 (n2804 n2612 vdd vdd) p12 w=2.4u l=0.13u
MN2812 (n2810 n2585 n2811 vss) n12 w=1.6u l=0.13u
MN2813 (n2811 n2804 vss vss) n12 w=1.6u l=0.13u
MP2814 (n2810 n2585 vdd vdd) p12 w=2.4u l=0.13u
MP2815 (n2810 n2804 vdd vdd) p12 w=2.4u l=0.13u
MN2818 (n2816 n2612 n2817 vss) n12 w=1.6u l=0.13u
MN2819 (n2817 n2804 vss vss) n12 w=1.6u l=0.13u
MP2820 (n2816 n2612 vdd vdd) p12 w=2.4u l=0.13u
MP2821 (n2816 n2804 vdd vdd) p12 w=2.4u l=0.13u
MN2824 (n2822 n2810 n2823 vss) n12 w=1.6u l=0.13u
MN2825 (n2823 n2816 vss vss) n12 w=1.6u l=0.13u
MP2826 (n2822 n2810 vdd vdd) p12 w=2.4u l=0.13u
MP2827 (n2822 n2816 vdd vdd) p12 w=2.4u l=0.13u
MN2830 (n2828 n2612 n2829 vss) n12 w=1.6u l=0.13u
MN2831 (n2829 n2639 vss vss) n12 w=1.6u l=0.13u
MP2832 (n2828 n2612 vdd vdd) p12 w=2.4u l=0.13u
MP2833 (n2828 n2639 vdd vdd) p12 w=2.4u l=0.13u
MN2836 (n2834 n2612 n2835 vss) n12 w=1.6u l=0.13u
MN2837 (n2835 n2828 vss vss) n12 w=1.6u l=0.13u
MP2838 (n2834 n2612 vdd vdd) p12 w=2.4u l=0.13u
MP2839 (n2834 n2828 vdd vdd) p12 w=2.4u l=0.13u
MN2842 (n2840 n2639 n2841 vss) n12 w=1.6u l=0.13u
MN2843 (n2841 n2828 vss vss) n12 w=1.6u l=0.13u
MP2844 (n2840 n2639 vdd vdd) p12 w=2.4u l=0.13u
MP2845 (n2840 n2828 vdd vdd) p12 w=2.4u l=0.13u
MN2848 (n2846 n2834 n2847 vss) n12 w=1.6u l=0.13u
MN2849 (n2847 n2840 vss vss) n12 w=1.6u l=0.13u
MP2850 (n2846 n2834 vdd vdd) p12 w=2.4u l=0.13u
MP2851 (n2846 n2840 vdd vdd) p12 w=2.4u l=0.13u
MN2854 (n2852 n2639 n2853 vss) n12 w=1.6u l=0.13u
MN2855 (n2853 n2666 vss vss) n12 w=1.6u l=0.13u
MP2856 (n2852 n2639 vdd vdd) p12 w=2.4u l=0.13u
MP2857 (n2852 n2666 vdd vdd) p12 w=2.4u l=0.13u
MN2860 (n2858 n2639 n2859 vss) n12 w=1.6u l=0.13u
MN2861 (n2859 n2852 vss vss) n12 w=1.6u l=0.13u
MP2862 (n2858 n2639 vdd vdd) p12 w=2.4u l=0.13u
MP2863 (n2858 n2852 vdd vdd) p12 w=2.4u l=0.13u
MN2866 (n2864 n2666 n2865 vss) n12 w=1.6u l=0.13u
MN2867 (n2865 n2852 vss vss) n12 w=1.6u l=0.13u
MP2868 (n2864 n2666 vdd vdd) p12 w=2.4u l=0.13u
MP2869 (n2864 n2852 vdd vdd) p12 w=2.4u l=0.13u
MN2872 (n2870 n2858 n2871 vss) n12 w=1.6u l=0.13u
MN2873 (n2871 n2864 vss vss) n12 w=1.6u l=0.13u
MP2874 (n2870 n2858 vdd vdd) p12 w=2.4u l=0.13u
MP2875 (n2870 n2864 vdd vdd) p12 w=2.4u l=0.13u
MN2878 (n2876 n2666 n2877 vss) n12 w=1.6u l=0.13u
MN2879 (n2877 n2693 vss vss) n12 w=1.6u l=0.13u
MP2880 (n2876 n2666 vdd vdd) p12 w=2.4u l=0.13u
MP2881 (n2876 n2693 vdd vdd) p12 w=2.4u l=0.13u
MN2884 (n2882 n2666 n2883 vss) n12 w=1.6u l=0.13u
MN2885 (n2883 n2876 vss vss) n12 w=1.6u l=0.13u
MP2886 (n2882 n2666 vdd vdd) p12 w=2.4u l=0.13u
MP2887 (n2882 n2876 vdd vdd) p12 w=2.4u l=0.13u
MN2890 (n2888 n2693 n2889 vss) n12 w=1.6u l=0.13u
MN2891 (n2889 n2876 vss vss) n12 w=1.6u l=0.13u
MP2892 (n2888 n2693 vdd vdd) p12 w=2.4u l=0.13u
MP2893 (n2888 n2876 vdd vdd) p12 w=2.4u l=0.13u
MN2896 (n2894 n2882 n2895 vss) n12 w=1.6u l=0.13u
MN2897 (n2895 n2888 vss vss) n12 w=1.6u l=0.13u
MP2898 (n2894 n2882 vdd vdd) p12 w=2.4u l=0.13u
MP2899 (n2894 n2888 vdd vdd) p12 w=2.4u l=0.13u
MN2902 (n2900 n2693 n2901 vss) n12 w=1.6u l=0.13u
MN2903 (n2901 n2720 vss vss) n12 w=1.6u l=0.13u
MP2904 (n2900 n2693 vdd vdd) p12 w=2.4u l=0.13u
MP2905 (n2900 n2720 vdd vdd) p12 w=2.4u l=0.13u
MN2908 (n2906 n2693 n2907 vss) n12 w=1.6u l=0.13u
MN2909 (n2907 n2900 vss vss) n12 w=1.6u l=0.13u
MP2910 (n2906 n2693 vdd vdd) p12 w=2.4u l=0.13u
MP2911 (n2906 n2900 vdd vdd) p12 w=2.4u l=0.13u
MN2914 (n2912 n2720 n2913 vss) n12 w=1.6u l=0.13u
MN2915 (n2913 n2900 vss vss) n12 w=1.6u l=0.13u
MP2916 (n2912 n2720 vdd vdd) p12 w=2.4u l=0.13u
MP2917 (n2912 n2900 vdd vdd) p12 w=2.4u l=0.13u
MN2920 (n2918 n2906 n2919 vss) n12 w=1.6u l=0.13u
MN2921 (n2919 n2912 vss vss) n12 w=1.6u l=0.13u
MP2922 (n2918 n2906 vdd vdd) p12 w=2.4u l=0.13u
MP2923 (n2918 n2912 vdd vdd) p12 w=2.4u l=0.13u
MN2926 (n2924 n2720 n2925 vss) n12 w=1.6u l=0.13u
MN2927 (n2925 n2747 vss vss) n12 w=1.6u l=0.13u
MP2928 (n2924 n2720 vdd vdd) p12 w=2.4u l=0.13u
MP2929 (n2924 n2747 vdd vdd) p12 w=2.4u l=0.13u
MN2932 (n2930 n2720 n2931 vss) n12 w=1.6u l=0.13u
MN2933 (n2931 n2924 vss vss) n12 w=1.6u l=0.13u
MP2934 (n2930 n2720 vdd vdd) p12 w=2.4u l=0.13u
MP2935 (n2930 n2924 vdd vdd) p12 w=2.4u l=0.13u
MN2938 (n2936 n2747 n2937 vss) n12 w=1.6u l=0.13u
MN2939 (n2937 n2924 vss vss) n12 w=1.6u l=0.13u
MP2940 (n2936 n2747 vdd vdd) p12 w=2.4u l=0.13u
MP2941 (n2936 n2924 vdd vdd) p12 w=2.4u l=0.13u
MN2944 (n2942 n2930 n2943 vss) n12 w=1.6u l=0.13u
MN2945 (n2943 n2936 vss vss) n12 w=1.6u l=0.13u
MP2946 (n2942 n2930 vdd vdd) p12 w=2.4u l=0.13u
MP2947 (n2942 n2936 vdd vdd) p12 w=2.4u l=0.13u
MN2952 (n2774 clk_low340 storage2951 vss) n12 w=1.2u l=0.13u
MP2953 (n2774 clk_lowb341 storage2951 vdd) p12 w=3.6u l=0.13u
MN2954 (qm2948 clk_high342 storage2951 vss) n12 w=1.2u l=0.13u
MP2955 (qm2948 clk_highb343 storage2951 vdd) p12 w=3.6u l=0.13u
MN2956 (qmb2949 storage2951 vss vss) n12 w=0.5u l=0.13u
MP2957 (qmb2949 storage2951 vdd vdd) p12 w=1.5u l=0.13u
MN2958 (qm2948 qmb2949 vss vss) n12 w=0.5u l=0.13u
MP2959 (qm2948 qmb2949 vdd vdd) p12 w=1.5u l=0.13u
MN2960 (storage2951 count_rst vss vss) n12 w=2u l=0.13u
MN2962 (qm2948 clk_high342 storage2961 vss) n12 w=1.2u l=0.13u
MP2963 (qm2948 clk_highb343 storage2961 vdd) p12 w=3.6u l=0.13u
MN2964 (div_g0 clk_low340 storage2961 vss) n12 w=1.2u l=0.13u
MP2965 (div_g0 clk_lowb341 storage2961 vdd) p12 w=3.6u l=0.13u
MN2966 (qb2950 storage2961 vss vss) n12 w=0.5u l=0.13u
MP2967 (qb2950 storage2961 vdd vdd) p12 w=1.5u l=0.13u
MN2968 (div_g0 qb2950 vss vss) n12 w=0.5u l=0.13u
MP2969 (div_g0 qb2950 vdd vdd) p12 w=1.5u l=0.13u
MN2970 (storage2961 count_rst vss vss) n12 w=2u l=0.13u
MN2975 (n2798 clk_low340 storage2974 vss) n12 w=1.2u l=0.13u
MP2976 (n2798 clk_lowb341 storage2974 vdd) p12 w=3.6u l=0.13u
MN2977 (qm2971 clk_high342 storage2974 vss) n12 w=1.2u l=0.13u
MP2978 (qm2971 clk_highb343 storage2974 vdd) p12 w=3.6u l=0.13u
MN2979 (qmb2972 storage2974 vss vss) n12 w=0.5u l=0.13u
MP2980 (qmb2972 storage2974 vdd vdd) p12 w=1.5u l=0.13u
MN2981 (qm2971 qmb2972 vss vss) n12 w=0.5u l=0.13u
MP2982 (qm2971 qmb2972 vdd vdd) p12 w=1.5u l=0.13u
MN2983 (storage2974 count_rst vss vss) n12 w=2u l=0.13u
MN2985 (qm2971 clk_high342 storage2984 vss) n12 w=1.2u l=0.13u
MP2986 (qm2971 clk_highb343 storage2984 vdd) p12 w=3.6u l=0.13u
MN2987 (div_g1 clk_low340 storage2984 vss) n12 w=1.2u l=0.13u
MP2988 (div_g1 clk_lowb341 storage2984 vdd) p12 w=3.6u l=0.13u
MN2989 (qb2973 storage2984 vss vss) n12 w=0.5u l=0.13u
MP2990 (qb2973 storage2984 vdd vdd) p12 w=1.5u l=0.13u
MN2991 (div_g1 qb2973 vss vss) n12 w=0.5u l=0.13u
MP2992 (div_g1 qb2973 vdd vdd) p12 w=1.5u l=0.13u
MN2993 (storage2984 count_rst vss vss) n12 w=2u l=0.13u
MN2998 (n2822 clk_low340 storage2997 vss) n12 w=1.2u l=0.13u
MP2999 (n2822 clk_lowb341 storage2997 vdd) p12 w=3.6u l=0.13u
MN3000 (qm2994 clk_high342 storage2997 vss) n12 w=1.2u l=0.13u
MP3001 (qm2994 clk_highb343 storage2997 vdd) p12 w=3.6u l=0.13u
MN3002 (qmb2995 storage2997 vss vss) n12 w=0.5u l=0.13u
MP3003 (qmb2995 storage2997 vdd vdd) p12 w=1.5u l=0.13u
MN3004 (qm2994 qmb2995 vss vss) n12 w=0.5u l=0.13u
MP3005 (qm2994 qmb2995 vdd vdd) p12 w=1.5u l=0.13u
MN3006 (storage2997 count_rst vss vss) n12 w=2u l=0.13u
MN3008 (qm2994 clk_high342 storage3007 vss) n12 w=1.2u l=0.13u
MP3009 (qm2994 clk_highb343 storage3007 vdd) p12 w=3.6u l=0.13u
MN3010 (div_g2 clk_low340 storage3007 vss) n12 w=1.2u l=0.13u
MP3011 (div_g2 clk_lowb341 storage3007 vdd) p12 w=3.6u l=0.13u
MN3012 (qb2996 storage3007 vss vss) n12 w=0.5u l=0.13u
MP3013 (qb2996 storage3007 vdd vdd) p12 w=1.5u l=0.13u
MN3014 (div_g2 qb2996 vss vss) n12 w=0.5u l=0.13u
MP3015 (div_g2 qb2996 vdd vdd) p12 w=1.5u l=0.13u
MN3016 (storage3007 count_rst vss vss) n12 w=2u l=0.13u
MN3021 (n2846 clk_low340 storage3020 vss) n12 w=1.2u l=0.13u
MP3022 (n2846 clk_lowb341 storage3020 vdd) p12 w=3.6u l=0.13u
MN3023 (qm3017 clk_high342 storage3020 vss) n12 w=1.2u l=0.13u
MP3024 (qm3017 clk_highb343 storage3020 vdd) p12 w=3.6u l=0.13u
MN3025 (qmb3018 storage3020 vss vss) n12 w=0.5u l=0.13u
MP3026 (qmb3018 storage3020 vdd vdd) p12 w=1.5u l=0.13u
MN3027 (qm3017 qmb3018 vss vss) n12 w=0.5u l=0.13u
MP3028 (qm3017 qmb3018 vdd vdd) p12 w=1.5u l=0.13u
MN3029 (storage3020 count_rst vss vss) n12 w=2u l=0.13u
MN3031 (qm3017 clk_high342 storage3030 vss) n12 w=1.2u l=0.13u
MP3032 (qm3017 clk_highb343 storage3030 vdd) p12 w=3.6u l=0.13u
MN3033 (div_g3 clk_low340 storage3030 vss) n12 w=1.2u l=0.13u
MP3034 (div_g3 clk_lowb341 storage3030 vdd) p12 w=3.6u l=0.13u
MN3035 (qb3019 storage3030 vss vss) n12 w=0.5u l=0.13u
MP3036 (qb3019 storage3030 vdd vdd) p12 w=1.5u l=0.13u
MN3037 (div_g3 qb3019 vss vss) n12 w=0.5u l=0.13u
MP3038 (div_g3 qb3019 vdd vdd) p12 w=1.5u l=0.13u
MN3039 (storage3030 count_rst vss vss) n12 w=2u l=0.13u
MN3044 (n2870 clk_low340 storage3043 vss) n12 w=1.2u l=0.13u
MP3045 (n2870 clk_lowb341 storage3043 vdd) p12 w=3.6u l=0.13u
MN3046 (qm3040 clk_high342 storage3043 vss) n12 w=1.2u l=0.13u
MP3047 (qm3040 clk_highb343 storage3043 vdd) p12 w=3.6u l=0.13u
MN3048 (qmb3041 storage3043 vss vss) n12 w=0.5u l=0.13u
MP3049 (qmb3041 storage3043 vdd vdd) p12 w=1.5u l=0.13u
MN3050 (qm3040 qmb3041 vss vss) n12 w=0.5u l=0.13u
MP3051 (qm3040 qmb3041 vdd vdd) p12 w=1.5u l=0.13u
MN3052 (storage3043 count_rst vss vss) n12 w=2u l=0.13u
MN3054 (qm3040 clk_high342 storage3053 vss) n12 w=1.2u l=0.13u
MP3055 (qm3040 clk_highb343 storage3053 vdd) p12 w=3.6u l=0.13u
MN3056 (div_g4 clk_low340 storage3053 vss) n12 w=1.2u l=0.13u
MP3057 (div_g4 clk_lowb341 storage3053 vdd) p12 w=3.6u l=0.13u
MN3058 (qb3042 storage3053 vss vss) n12 w=0.5u l=0.13u
MP3059 (qb3042 storage3053 vdd vdd) p12 w=1.5u l=0.13u
MN3060 (div_g4 qb3042 vss vss) n12 w=0.5u l=0.13u
MP3061 (div_g4 qb3042 vdd vdd) p12 w=1.5u l=0.13u
MN3062 (storage3053 count_rst vss vss) n12 w=2u l=0.13u
MN3067 (n2894 clk_low340 storage3066 vss) n12 w=1.2u l=0.13u
MP3068 (n2894 clk_lowb341 storage3066 vdd) p12 w=3.6u l=0.13u
MN3069 (qm3063 clk_high342 storage3066 vss) n12 w=1.2u l=0.13u
MP3070 (qm3063 clk_highb343 storage3066 vdd) p12 w=3.6u l=0.13u
MN3071 (qmb3064 storage3066 vss vss) n12 w=0.5u l=0.13u
MP3072 (qmb3064 storage3066 vdd vdd) p12 w=1.5u l=0.13u
MN3073 (qm3063 qmb3064 vss vss) n12 w=0.5u l=0.13u
MP3074 (qm3063 qmb3064 vdd vdd) p12 w=1.5u l=0.13u
MN3075 (storage3066 count_rst vss vss) n12 w=2u l=0.13u
MN3077 (qm3063 clk_high342 storage3076 vss) n12 w=1.2u l=0.13u
MP3078 (qm3063 clk_highb343 storage3076 vdd) p12 w=3.6u l=0.13u
MN3079 (div_g5 clk_low340 storage3076 vss) n12 w=1.2u l=0.13u
MP3080 (div_g5 clk_lowb341 storage3076 vdd) p12 w=3.6u l=0.13u
MN3081 (qb3065 storage3076 vss vss) n12 w=0.5u l=0.13u
MP3082 (qb3065 storage3076 vdd vdd) p12 w=1.5u l=0.13u
MN3083 (div_g5 qb3065 vss vss) n12 w=0.5u l=0.13u
MP3084 (div_g5 qb3065 vdd vdd) p12 w=1.5u l=0.13u
MN3085 (storage3076 count_rst vss vss) n12 w=2u l=0.13u
MN3090 (n2918 clk_low340 storage3089 vss) n12 w=1.2u l=0.13u
MP3091 (n2918 clk_lowb341 storage3089 vdd) p12 w=3.6u l=0.13u
MN3092 (qm3086 clk_high342 storage3089 vss) n12 w=1.2u l=0.13u
MP3093 (qm3086 clk_highb343 storage3089 vdd) p12 w=3.6u l=0.13u
MN3094 (qmb3087 storage3089 vss vss) n12 w=0.5u l=0.13u
MP3095 (qmb3087 storage3089 vdd vdd) p12 w=1.5u l=0.13u
MN3096 (qm3086 qmb3087 vss vss) n12 w=0.5u l=0.13u
MP3097 (qm3086 qmb3087 vdd vdd) p12 w=1.5u l=0.13u
MN3098 (storage3089 count_rst vss vss) n12 w=2u l=0.13u
MN3100 (qm3086 clk_high342 storage3099 vss) n12 w=1.2u l=0.13u
MP3101 (qm3086 clk_highb343 storage3099 vdd) p12 w=3.6u l=0.13u
MN3102 (div_g6 clk_low340 storage3099 vss) n12 w=1.2u l=0.13u
MP3103 (div_g6 clk_lowb341 storage3099 vdd) p12 w=3.6u l=0.13u
MN3104 (qb3088 storage3099 vss vss) n12 w=0.5u l=0.13u
MP3105 (qb3088 storage3099 vdd vdd) p12 w=1.5u l=0.13u
MN3106 (div_g6 qb3088 vss vss) n12 w=0.5u l=0.13u
MP3107 (div_g6 qb3088 vdd vdd) p12 w=1.5u l=0.13u
MN3108 (storage3099 count_rst vss vss) n12 w=2u l=0.13u
MN3113 (n2942 clk_low340 storage3112 vss) n12 w=1.2u l=0.13u
MP3114 (n2942 clk_lowb341 storage3112 vdd) p12 w=3.6u l=0.13u
MN3115 (qm3109 clk_high342 storage3112 vss) n12 w=1.2u l=0.13u
MP3116 (qm3109 clk_highb343 storage3112 vdd) p12 w=3.6u l=0.13u
MN3117 (qmb3110 storage3112 vss vss) n12 w=0.5u l=0.13u
MP3118 (qmb3110 storage3112 vdd vdd) p12 w=1.5u l=0.13u
MN3119 (qm3109 qmb3110 vss vss) n12 w=0.5u l=0.13u
MP3120 (qm3109 qmb3110 vdd vdd) p12 w=1.5u l=0.13u
MN3121 (storage3112 count_rst vss vss) n12 w=2u l=0.13u
MN3123 (qm3109 clk_high342 storage3122 vss) n12 w=1.2u l=0.13u
MP3124 (qm3109 clk_highb343 storage3122 vdd) p12 w=3.6u l=0.13u
MN3125 (div_g7 clk_low340 storage3122 vss) n12 w=1.2u l=0.13u
MP3126 (div_g7 clk_lowb341 storage3122 vdd) p12 w=3.6u l=0.13u
MN3127 (qb3111 storage3122 vss vss) n12 w=0.5u l=0.13u
MP3128 (qb3111 storage3122 vdd vdd) p12 w=1.5u l=0.13u
MN3129 (div_g7 qb3111 vss vss) n12 w=0.5u l=0.13u
MP3130 (div_g7 qb3111 vdd vdd) p12 w=1.5u l=0.13u
MN3131 (storage3122 count_rst vss vss) n12 w=2u l=0.13u
MN3136 (n2747 clk_low340 storage3135 vss) n12 w=1.2u l=0.13u
MP3137 (n2747 clk_lowb341 storage3135 vdd) p12 w=3.6u l=0.13u
MN3138 (qm3132 clk_high342 storage3135 vss) n12 w=1.2u l=0.13u
MP3139 (qm3132 clk_highb343 storage3135 vdd) p12 w=3.6u l=0.13u
MN3140 (qmb3133 storage3135 vss vss) n12 w=0.5u l=0.13u
MP3141 (qmb3133 storage3135 vdd vdd) p12 w=1.5u l=0.13u
MN3142 (qm3132 qmb3133 vss vss) n12 w=0.5u l=0.13u
MP3143 (qm3132 qmb3133 vdd vdd) p12 w=1.5u l=0.13u
MN3144 (storage3135 count_rst vss vss) n12 w=2u l=0.13u
MN3146 (qm3132 clk_high342 storage3145 vss) n12 w=1.2u l=0.13u
MP3147 (qm3132 clk_highb343 storage3145 vdd) p12 w=3.6u l=0.13u
MN3148 (div_g8 clk_low340 storage3145 vss) n12 w=1.2u l=0.13u
MP3149 (div_g8 clk_lowb341 storage3145 vdd) p12 w=3.6u l=0.13u
MN3150 (qb3134 storage3145 vss vss) n12 w=0.5u l=0.13u
MP3151 (qb3134 storage3145 vdd vdd) p12 w=1.5u l=0.13u
MN3152 (div_g8 qb3134 vss vss) n12 w=0.5u l=0.13u
MP3153 (div_g8 qb3134 vdd vdd) p12 w=1.5u l=0.13u
MN3154 (storage3145 count_rst vss vss) n12 w=2u l=0.13u
MN3163 (n3159 n22 n3160 vss) n12 w=3.2u l=0.13u
MP3164 (n3159 n22 vdd vdd) p12 w=2.4u l=0.13u
MN3165 (n3160 n102 n3161 vss) n12 w=3.2u l=0.13u
MP3166 (n3159 n102 vdd vdd) p12 w=2.4u l=0.13u
MN3167 (n3161 clk_highb3158 n3162 vss) n12 w=3.2u l=0.13u
MP3168 (n3159 clk_highb3158 vdd vdd) p12 w=2.4u l=0.13u
MN3169 (n3162 n337 vss vss) n12 w=3.2u l=0.13u
MP3170 (n3159 n337 vdd vdd) p12 w=2.4u l=0.13u
MN3175 (n3171 n19 n3172 vss) n12 w=3.2u l=0.13u
MP3176 (n3171 n19 vdd vdd) p12 w=2.4u l=0.13u
MN3177 (n3172 delay99 n3173 vss) n12 w=3.2u l=0.13u
MP3178 (n3171 delay99 vdd vdd) p12 w=2.4u l=0.13u
MN3179 (n3173 clk_lowb3156 n3174 vss) n12 w=3.2u l=0.13u
MP3180 (n3171 clk_lowb3156 vdd vdd) p12 w=2.4u l=0.13u
MN3181 (n3174 n337 vss vss) n12 w=3.2u l=0.13u
MP3182 (n3171 n337 vdd vdd) p12 w=2.4u l=0.13u
MN3183 (clk_low3155 n3159 vss vss) n12 w=8u l=0.13u
MP3184 (clk_low3155 n3159 vdd vdd) p12 w=24u l=0.13u
MN3185 (clk_lowb3156 clk_low3155 vss vss) n12 w=8u l=0.13u
MP3186 (clk_lowb3156 clk_low3155 vdd vdd) p12 w=24u l=0.13u
MN3187 (clk_high3157 n3171 vss vss) n12 w=8u l=0.13u
MP3188 (clk_high3157 n3171 vdd vdd) p12 w=24u l=0.13u
MN3189 (clk_highb3158 clk_high3157 vss vss) n12 w=8u l=0.13u
MP3190 (clk_highb3158 clk_high3157 vdd vdd) p12 w=24u l=0.13u
MN3195 (lead_g0 clk_low3155 storage3194 vss) n12 w=1.2u l=0.13u
MP3196 (lead_g0 clk_lowb3156 storage3194 vdd) p12 w=3.6u l=0.13u
MN3197 (qm3191 clk_high3157 storage3194 vss) n12 w=1.2u l=0.13u
MP3198 (qm3191 clk_highb3158 storage3194 vdd) p12 w=3.6u l=0.13u
MN3199 (qmb3192 storage3194 vss vss) n12 w=0.5u l=0.13u
MP3200 (qmb3192 storage3194 vdd vdd) p12 w=1.5u l=0.13u
MN3201 (qm3191 qmb3192 vss vss) n12 w=0.5u l=0.13u
MP3202 (qm3191 qmb3192 vdd vdd) p12 w=1.5u l=0.13u
MN3203 (storage3194 count_rst vss vss) n12 w=2u l=0.13u
MN3205 (qm3191 clk_high3157 storage3204 vss) n12 w=1.2u l=0.13u
MP3206 (qm3191 clk_highb3158 storage3204 vdd) p12 w=3.6u l=0.13u
MN3207 (lead_sync1_0 clk_low3155 storage3204 vss) n12 w=1.2u l=0.13u
MP3208 (lead_sync1_0 clk_lowb3156 storage3204 vdd) p12 w=3.6u l=0.13u
MN3209 (qb3193 storage3204 vss vss) n12 w=0.5u l=0.13u
MP3210 (qb3193 storage3204 vdd vdd) p12 w=1.5u l=0.13u
MN3211 (lead_sync1_0 qb3193 vss vss) n12 w=0.5u l=0.13u
MP3212 (lead_sync1_0 qb3193 vdd vdd) p12 w=1.5u l=0.13u
MN3213 (storage3204 count_rst vss vss) n12 w=2u l=0.13u
MN3218 (lead_sync1_0 clk_low3155 storage3217 vss) n12 w=1.2u l=0.13u
MP3219 (lead_sync1_0 clk_lowb3156 storage3217 vdd) p12 w=3.6u l=0.13u
MN3220 (qm3214 clk_high3157 storage3217 vss) n12 w=1.2u l=0.13u
MP3221 (qm3214 clk_highb3158 storage3217 vdd) p12 w=3.6u l=0.13u
MN3222 (qmb3215 storage3217 vss vss) n12 w=0.5u l=0.13u
MP3223 (qmb3215 storage3217 vdd vdd) p12 w=1.5u l=0.13u
MN3224 (qm3214 qmb3215 vss vss) n12 w=0.5u l=0.13u
MP3225 (qm3214 qmb3215 vdd vdd) p12 w=1.5u l=0.13u
MN3226 (storage3217 count_rst vss vss) n12 w=2u l=0.13u
MN3228 (qm3214 clk_high3157 storage3227 vss) n12 w=1.2u l=0.13u
MP3229 (qm3214 clk_highb3158 storage3227 vdd) p12 w=3.6u l=0.13u
MN3230 (lead_sync2_0 clk_low3155 storage3227 vss) n12 w=1.2u l=0.13u
MP3231 (lead_sync2_0 clk_lowb3156 storage3227 vdd) p12 w=3.6u l=0.13u
MN3232 (qb3216 storage3227 vss vss) n12 w=0.5u l=0.13u
MP3233 (qb3216 storage3227 vdd vdd) p12 w=1.5u l=0.13u
MN3234 (lead_sync2_0 qb3216 vss vss) n12 w=0.5u l=0.13u
MP3235 (lead_sync2_0 qb3216 vdd vdd) p12 w=1.5u l=0.13u
MN3236 (storage3227 count_rst vss vss) n12 w=2u l=0.13u
MN3241 (lead_g1 clk_low3155 storage3240 vss) n12 w=1.2u l=0.13u
MP3242 (lead_g1 clk_lowb3156 storage3240 vdd) p12 w=3.6u l=0.13u
MN3243 (qm3237 clk_high3157 storage3240 vss) n12 w=1.2u l=0.13u
MP3244 (qm3237 clk_highb3158 storage3240 vdd) p12 w=3.6u l=0.13u
MN3245 (qmb3238 storage3240 vss vss) n12 w=0.5u l=0.13u
MP3246 (qmb3238 storage3240 vdd vdd) p12 w=1.5u l=0.13u
MN3247 (qm3237 qmb3238 vss vss) n12 w=0.5u l=0.13u
MP3248 (qm3237 qmb3238 vdd vdd) p12 w=1.5u l=0.13u
MN3249 (storage3240 count_rst vss vss) n12 w=2u l=0.13u
MN3251 (qm3237 clk_high3157 storage3250 vss) n12 w=1.2u l=0.13u
MP3252 (qm3237 clk_highb3158 storage3250 vdd) p12 w=3.6u l=0.13u
MN3253 (lead_sync1_1 clk_low3155 storage3250 vss) n12 w=1.2u l=0.13u
MP3254 (lead_sync1_1 clk_lowb3156 storage3250 vdd) p12 w=3.6u l=0.13u
MN3255 (qb3239 storage3250 vss vss) n12 w=0.5u l=0.13u
MP3256 (qb3239 storage3250 vdd vdd) p12 w=1.5u l=0.13u
MN3257 (lead_sync1_1 qb3239 vss vss) n12 w=0.5u l=0.13u
MP3258 (lead_sync1_1 qb3239 vdd vdd) p12 w=1.5u l=0.13u
MN3259 (storage3250 count_rst vss vss) n12 w=2u l=0.13u
MN3264 (lead_sync1_1 clk_low3155 storage3263 vss) n12 w=1.2u l=0.13u
MP3265 (lead_sync1_1 clk_lowb3156 storage3263 vdd) p12 w=3.6u l=0.13u
MN3266 (qm3260 clk_high3157 storage3263 vss) n12 w=1.2u l=0.13u
MP3267 (qm3260 clk_highb3158 storage3263 vdd) p12 w=3.6u l=0.13u
MN3268 (qmb3261 storage3263 vss vss) n12 w=0.5u l=0.13u
MP3269 (qmb3261 storage3263 vdd vdd) p12 w=1.5u l=0.13u
MN3270 (qm3260 qmb3261 vss vss) n12 w=0.5u l=0.13u
MP3271 (qm3260 qmb3261 vdd vdd) p12 w=1.5u l=0.13u
MN3272 (storage3263 count_rst vss vss) n12 w=2u l=0.13u
MN3274 (qm3260 clk_high3157 storage3273 vss) n12 w=1.2u l=0.13u
MP3275 (qm3260 clk_highb3158 storage3273 vdd) p12 w=3.6u l=0.13u
MN3276 (lead_sync2_1 clk_low3155 storage3273 vss) n12 w=1.2u l=0.13u
MP3277 (lead_sync2_1 clk_lowb3156 storage3273 vdd) p12 w=3.6u l=0.13u
MN3278 (qb3262 storage3273 vss vss) n12 w=0.5u l=0.13u
MP3279 (qb3262 storage3273 vdd vdd) p12 w=1.5u l=0.13u
MN3280 (lead_sync2_1 qb3262 vss vss) n12 w=0.5u l=0.13u
MP3281 (lead_sync2_1 qb3262 vdd vdd) p12 w=1.5u l=0.13u
MN3282 (storage3273 count_rst vss vss) n12 w=2u l=0.13u
MN3287 (lead_g2 clk_low3155 storage3286 vss) n12 w=1.2u l=0.13u
MP3288 (lead_g2 clk_lowb3156 storage3286 vdd) p12 w=3.6u l=0.13u
MN3289 (qm3283 clk_high3157 storage3286 vss) n12 w=1.2u l=0.13u
MP3290 (qm3283 clk_highb3158 storage3286 vdd) p12 w=3.6u l=0.13u
MN3291 (qmb3284 storage3286 vss vss) n12 w=0.5u l=0.13u
MP3292 (qmb3284 storage3286 vdd vdd) p12 w=1.5u l=0.13u
MN3293 (qm3283 qmb3284 vss vss) n12 w=0.5u l=0.13u
MP3294 (qm3283 qmb3284 vdd vdd) p12 w=1.5u l=0.13u
MN3295 (storage3286 count_rst vss vss) n12 w=2u l=0.13u
MN3297 (qm3283 clk_high3157 storage3296 vss) n12 w=1.2u l=0.13u
MP3298 (qm3283 clk_highb3158 storage3296 vdd) p12 w=3.6u l=0.13u
MN3299 (lead_sync1_2 clk_low3155 storage3296 vss) n12 w=1.2u l=0.13u
MP3300 (lead_sync1_2 clk_lowb3156 storage3296 vdd) p12 w=3.6u l=0.13u
MN3301 (qb3285 storage3296 vss vss) n12 w=0.5u l=0.13u
MP3302 (qb3285 storage3296 vdd vdd) p12 w=1.5u l=0.13u
MN3303 (lead_sync1_2 qb3285 vss vss) n12 w=0.5u l=0.13u
MP3304 (lead_sync1_2 qb3285 vdd vdd) p12 w=1.5u l=0.13u
MN3305 (storage3296 count_rst vss vss) n12 w=2u l=0.13u
MN3310 (lead_sync1_2 clk_low3155 storage3309 vss) n12 w=1.2u l=0.13u
MP3311 (lead_sync1_2 clk_lowb3156 storage3309 vdd) p12 w=3.6u l=0.13u
MN3312 (qm3306 clk_high3157 storage3309 vss) n12 w=1.2u l=0.13u
MP3313 (qm3306 clk_highb3158 storage3309 vdd) p12 w=3.6u l=0.13u
MN3314 (qmb3307 storage3309 vss vss) n12 w=0.5u l=0.13u
MP3315 (qmb3307 storage3309 vdd vdd) p12 w=1.5u l=0.13u
MN3316 (qm3306 qmb3307 vss vss) n12 w=0.5u l=0.13u
MP3317 (qm3306 qmb3307 vdd vdd) p12 w=1.5u l=0.13u
MN3318 (storage3309 count_rst vss vss) n12 w=2u l=0.13u
MN3320 (qm3306 clk_high3157 storage3319 vss) n12 w=1.2u l=0.13u
MP3321 (qm3306 clk_highb3158 storage3319 vdd) p12 w=3.6u l=0.13u
MN3322 (lead_sync2_2 clk_low3155 storage3319 vss) n12 w=1.2u l=0.13u
MP3323 (lead_sync2_2 clk_lowb3156 storage3319 vdd) p12 w=3.6u l=0.13u
MN3324 (qb3308 storage3319 vss vss) n12 w=0.5u l=0.13u
MP3325 (qb3308 storage3319 vdd vdd) p12 w=1.5u l=0.13u
MN3326 (lead_sync2_2 qb3308 vss vss) n12 w=0.5u l=0.13u
MP3327 (lead_sync2_2 qb3308 vdd vdd) p12 w=1.5u l=0.13u
MN3328 (storage3319 count_rst vss vss) n12 w=2u l=0.13u
MN3333 (lead_g3 clk_low3155 storage3332 vss) n12 w=1.2u l=0.13u
MP3334 (lead_g3 clk_lowb3156 storage3332 vdd) p12 w=3.6u l=0.13u
MN3335 (qm3329 clk_high3157 storage3332 vss) n12 w=1.2u l=0.13u
MP3336 (qm3329 clk_highb3158 storage3332 vdd) p12 w=3.6u l=0.13u
MN3337 (qmb3330 storage3332 vss vss) n12 w=0.5u l=0.13u
MP3338 (qmb3330 storage3332 vdd vdd) p12 w=1.5u l=0.13u
MN3339 (qm3329 qmb3330 vss vss) n12 w=0.5u l=0.13u
MP3340 (qm3329 qmb3330 vdd vdd) p12 w=1.5u l=0.13u
MN3341 (storage3332 count_rst vss vss) n12 w=2u l=0.13u
MN3343 (qm3329 clk_high3157 storage3342 vss) n12 w=1.2u l=0.13u
MP3344 (qm3329 clk_highb3158 storage3342 vdd) p12 w=3.6u l=0.13u
MN3345 (lead_sync1_3 clk_low3155 storage3342 vss) n12 w=1.2u l=0.13u
MP3346 (lead_sync1_3 clk_lowb3156 storage3342 vdd) p12 w=3.6u l=0.13u
MN3347 (qb3331 storage3342 vss vss) n12 w=0.5u l=0.13u
MP3348 (qb3331 storage3342 vdd vdd) p12 w=1.5u l=0.13u
MN3349 (lead_sync1_3 qb3331 vss vss) n12 w=0.5u l=0.13u
MP3350 (lead_sync1_3 qb3331 vdd vdd) p12 w=1.5u l=0.13u
MN3351 (storage3342 count_rst vss vss) n12 w=2u l=0.13u
MN3356 (lead_sync1_3 clk_low3155 storage3355 vss) n12 w=1.2u l=0.13u
MP3357 (lead_sync1_3 clk_lowb3156 storage3355 vdd) p12 w=3.6u l=0.13u
MN3358 (qm3352 clk_high3157 storage3355 vss) n12 w=1.2u l=0.13u
MP3359 (qm3352 clk_highb3158 storage3355 vdd) p12 w=3.6u l=0.13u
MN3360 (qmb3353 storage3355 vss vss) n12 w=0.5u l=0.13u
MP3361 (qmb3353 storage3355 vdd vdd) p12 w=1.5u l=0.13u
MN3362 (qm3352 qmb3353 vss vss) n12 w=0.5u l=0.13u
MP3363 (qm3352 qmb3353 vdd vdd) p12 w=1.5u l=0.13u
MN3364 (storage3355 count_rst vss vss) n12 w=2u l=0.13u
MN3366 (qm3352 clk_high3157 storage3365 vss) n12 w=1.2u l=0.13u
MP3367 (qm3352 clk_highb3158 storage3365 vdd) p12 w=3.6u l=0.13u
MN3368 (lead_sync2_3 clk_low3155 storage3365 vss) n12 w=1.2u l=0.13u
MP3369 (lead_sync2_3 clk_lowb3156 storage3365 vdd) p12 w=3.6u l=0.13u
MN3370 (qb3354 storage3365 vss vss) n12 w=0.5u l=0.13u
MP3371 (qb3354 storage3365 vdd vdd) p12 w=1.5u l=0.13u
MN3372 (lead_sync2_3 qb3354 vss vss) n12 w=0.5u l=0.13u
MP3373 (lead_sync2_3 qb3354 vdd vdd) p12 w=1.5u l=0.13u
MN3374 (storage3365 count_rst vss vss) n12 w=2u l=0.13u
MN3379 (lead_g4 clk_low3155 storage3378 vss) n12 w=1.2u l=0.13u
MP3380 (lead_g4 clk_lowb3156 storage3378 vdd) p12 w=3.6u l=0.13u
MN3381 (qm3375 clk_high3157 storage3378 vss) n12 w=1.2u l=0.13u
MP3382 (qm3375 clk_highb3158 storage3378 vdd) p12 w=3.6u l=0.13u
MN3383 (qmb3376 storage3378 vss vss) n12 w=0.5u l=0.13u
MP3384 (qmb3376 storage3378 vdd vdd) p12 w=1.5u l=0.13u
MN3385 (qm3375 qmb3376 vss vss) n12 w=0.5u l=0.13u
MP3386 (qm3375 qmb3376 vdd vdd) p12 w=1.5u l=0.13u
MN3387 (storage3378 count_rst vss vss) n12 w=2u l=0.13u
MN3389 (qm3375 clk_high3157 storage3388 vss) n12 w=1.2u l=0.13u
MP3390 (qm3375 clk_highb3158 storage3388 vdd) p12 w=3.6u l=0.13u
MN3391 (lead_sync1_4 clk_low3155 storage3388 vss) n12 w=1.2u l=0.13u
MP3392 (lead_sync1_4 clk_lowb3156 storage3388 vdd) p12 w=3.6u l=0.13u
MN3393 (qb3377 storage3388 vss vss) n12 w=0.5u l=0.13u
MP3394 (qb3377 storage3388 vdd vdd) p12 w=1.5u l=0.13u
MN3395 (lead_sync1_4 qb3377 vss vss) n12 w=0.5u l=0.13u
MP3396 (lead_sync1_4 qb3377 vdd vdd) p12 w=1.5u l=0.13u
MN3397 (storage3388 count_rst vss vss) n12 w=2u l=0.13u
MN3402 (lead_sync1_4 clk_low3155 storage3401 vss) n12 w=1.2u l=0.13u
MP3403 (lead_sync1_4 clk_lowb3156 storage3401 vdd) p12 w=3.6u l=0.13u
MN3404 (qm3398 clk_high3157 storage3401 vss) n12 w=1.2u l=0.13u
MP3405 (qm3398 clk_highb3158 storage3401 vdd) p12 w=3.6u l=0.13u
MN3406 (qmb3399 storage3401 vss vss) n12 w=0.5u l=0.13u
MP3407 (qmb3399 storage3401 vdd vdd) p12 w=1.5u l=0.13u
MN3408 (qm3398 qmb3399 vss vss) n12 w=0.5u l=0.13u
MP3409 (qm3398 qmb3399 vdd vdd) p12 w=1.5u l=0.13u
MN3410 (storage3401 count_rst vss vss) n12 w=2u l=0.13u
MN3412 (qm3398 clk_high3157 storage3411 vss) n12 w=1.2u l=0.13u
MP3413 (qm3398 clk_highb3158 storage3411 vdd) p12 w=3.6u l=0.13u
MN3414 (lead_sync2_4 clk_low3155 storage3411 vss) n12 w=1.2u l=0.13u
MP3415 (lead_sync2_4 clk_lowb3156 storage3411 vdd) p12 w=3.6u l=0.13u
MN3416 (qb3400 storage3411 vss vss) n12 w=0.5u l=0.13u
MP3417 (qb3400 storage3411 vdd vdd) p12 w=1.5u l=0.13u
MN3418 (lead_sync2_4 qb3400 vss vss) n12 w=0.5u l=0.13u
MP3419 (lead_sync2_4 qb3400 vdd vdd) p12 w=1.5u l=0.13u
MN3420 (storage3411 count_rst vss vss) n12 w=2u l=0.13u
MN3425 (lead_g5 clk_low3155 storage3424 vss) n12 w=1.2u l=0.13u
MP3426 (lead_g5 clk_lowb3156 storage3424 vdd) p12 w=3.6u l=0.13u
MN3427 (qm3421 clk_high3157 storage3424 vss) n12 w=1.2u l=0.13u
MP3428 (qm3421 clk_highb3158 storage3424 vdd) p12 w=3.6u l=0.13u
MN3429 (qmb3422 storage3424 vss vss) n12 w=0.5u l=0.13u
MP3430 (qmb3422 storage3424 vdd vdd) p12 w=1.5u l=0.13u
MN3431 (qm3421 qmb3422 vss vss) n12 w=0.5u l=0.13u
MP3432 (qm3421 qmb3422 vdd vdd) p12 w=1.5u l=0.13u
MN3433 (storage3424 count_rst vss vss) n12 w=2u l=0.13u
MN3435 (qm3421 clk_high3157 storage3434 vss) n12 w=1.2u l=0.13u
MP3436 (qm3421 clk_highb3158 storage3434 vdd) p12 w=3.6u l=0.13u
MN3437 (lead_sync1_5 clk_low3155 storage3434 vss) n12 w=1.2u l=0.13u
MP3438 (lead_sync1_5 clk_lowb3156 storage3434 vdd) p12 w=3.6u l=0.13u
MN3439 (qb3423 storage3434 vss vss) n12 w=0.5u l=0.13u
MP3440 (qb3423 storage3434 vdd vdd) p12 w=1.5u l=0.13u
MN3441 (lead_sync1_5 qb3423 vss vss) n12 w=0.5u l=0.13u
MP3442 (lead_sync1_5 qb3423 vdd vdd) p12 w=1.5u l=0.13u
MN3443 (storage3434 count_rst vss vss) n12 w=2u l=0.13u
MN3448 (lead_sync1_5 clk_low3155 storage3447 vss) n12 w=1.2u l=0.13u
MP3449 (lead_sync1_5 clk_lowb3156 storage3447 vdd) p12 w=3.6u l=0.13u
MN3450 (qm3444 clk_high3157 storage3447 vss) n12 w=1.2u l=0.13u
MP3451 (qm3444 clk_highb3158 storage3447 vdd) p12 w=3.6u l=0.13u
MN3452 (qmb3445 storage3447 vss vss) n12 w=0.5u l=0.13u
MP3453 (qmb3445 storage3447 vdd vdd) p12 w=1.5u l=0.13u
MN3454 (qm3444 qmb3445 vss vss) n12 w=0.5u l=0.13u
MP3455 (qm3444 qmb3445 vdd vdd) p12 w=1.5u l=0.13u
MN3456 (storage3447 count_rst vss vss) n12 w=2u l=0.13u
MN3458 (qm3444 clk_high3157 storage3457 vss) n12 w=1.2u l=0.13u
MP3459 (qm3444 clk_highb3158 storage3457 vdd) p12 w=3.6u l=0.13u
MN3460 (lead_sync2_5 clk_low3155 storage3457 vss) n12 w=1.2u l=0.13u
MP3461 (lead_sync2_5 clk_lowb3156 storage3457 vdd) p12 w=3.6u l=0.13u
MN3462 (qb3446 storage3457 vss vss) n12 w=0.5u l=0.13u
MP3463 (qb3446 storage3457 vdd vdd) p12 w=1.5u l=0.13u
MN3464 (lead_sync2_5 qb3446 vss vss) n12 w=0.5u l=0.13u
MP3465 (lead_sync2_5 qb3446 vdd vdd) p12 w=1.5u l=0.13u
MN3466 (storage3457 count_rst vss vss) n12 w=2u l=0.13u
MN3471 (lead_g6 clk_low3155 storage3470 vss) n12 w=1.2u l=0.13u
MP3472 (lead_g6 clk_lowb3156 storage3470 vdd) p12 w=3.6u l=0.13u
MN3473 (qm3467 clk_high3157 storage3470 vss) n12 w=1.2u l=0.13u
MP3474 (qm3467 clk_highb3158 storage3470 vdd) p12 w=3.6u l=0.13u
MN3475 (qmb3468 storage3470 vss vss) n12 w=0.5u l=0.13u
MP3476 (qmb3468 storage3470 vdd vdd) p12 w=1.5u l=0.13u
MN3477 (qm3467 qmb3468 vss vss) n12 w=0.5u l=0.13u
MP3478 (qm3467 qmb3468 vdd vdd) p12 w=1.5u l=0.13u
MN3479 (storage3470 count_rst vss vss) n12 w=2u l=0.13u
MN3481 (qm3467 clk_high3157 storage3480 vss) n12 w=1.2u l=0.13u
MP3482 (qm3467 clk_highb3158 storage3480 vdd) p12 w=3.6u l=0.13u
MN3483 (lead_sync1_6 clk_low3155 storage3480 vss) n12 w=1.2u l=0.13u
MP3484 (lead_sync1_6 clk_lowb3156 storage3480 vdd) p12 w=3.6u l=0.13u
MN3485 (qb3469 storage3480 vss vss) n12 w=0.5u l=0.13u
MP3486 (qb3469 storage3480 vdd vdd) p12 w=1.5u l=0.13u
MN3487 (lead_sync1_6 qb3469 vss vss) n12 w=0.5u l=0.13u
MP3488 (lead_sync1_6 qb3469 vdd vdd) p12 w=1.5u l=0.13u
MN3489 (storage3480 count_rst vss vss) n12 w=2u l=0.13u
MN3494 (lead_sync1_6 clk_low3155 storage3493 vss) n12 w=1.2u l=0.13u
MP3495 (lead_sync1_6 clk_lowb3156 storage3493 vdd) p12 w=3.6u l=0.13u
MN3496 (qm3490 clk_high3157 storage3493 vss) n12 w=1.2u l=0.13u
MP3497 (qm3490 clk_highb3158 storage3493 vdd) p12 w=3.6u l=0.13u
MN3498 (qmb3491 storage3493 vss vss) n12 w=0.5u l=0.13u
MP3499 (qmb3491 storage3493 vdd vdd) p12 w=1.5u l=0.13u
MN3500 (qm3490 qmb3491 vss vss) n12 w=0.5u l=0.13u
MP3501 (qm3490 qmb3491 vdd vdd) p12 w=1.5u l=0.13u
MN3502 (storage3493 count_rst vss vss) n12 w=2u l=0.13u
MN3504 (qm3490 clk_high3157 storage3503 vss) n12 w=1.2u l=0.13u
MP3505 (qm3490 clk_highb3158 storage3503 vdd) p12 w=3.6u l=0.13u
MN3506 (lead_sync2_6 clk_low3155 storage3503 vss) n12 w=1.2u l=0.13u
MP3507 (lead_sync2_6 clk_lowb3156 storage3503 vdd) p12 w=3.6u l=0.13u
MN3508 (qb3492 storage3503 vss vss) n12 w=0.5u l=0.13u
MP3509 (qb3492 storage3503 vdd vdd) p12 w=1.5u l=0.13u
MN3510 (lead_sync2_6 qb3492 vss vss) n12 w=0.5u l=0.13u
MP3511 (lead_sync2_6 qb3492 vdd vdd) p12 w=1.5u l=0.13u
MN3512 (storage3503 count_rst vss vss) n12 w=2u l=0.13u
MN3517 (lead_g7 clk_low3155 storage3516 vss) n12 w=1.2u l=0.13u
MP3518 (lead_g7 clk_lowb3156 storage3516 vdd) p12 w=3.6u l=0.13u
MN3519 (qm3513 clk_high3157 storage3516 vss) n12 w=1.2u l=0.13u
MP3520 (qm3513 clk_highb3158 storage3516 vdd) p12 w=3.6u l=0.13u
MN3521 (qmb3514 storage3516 vss vss) n12 w=0.5u l=0.13u
MP3522 (qmb3514 storage3516 vdd vdd) p12 w=1.5u l=0.13u
MN3523 (qm3513 qmb3514 vss vss) n12 w=0.5u l=0.13u
MP3524 (qm3513 qmb3514 vdd vdd) p12 w=1.5u l=0.13u
MN3525 (storage3516 count_rst vss vss) n12 w=2u l=0.13u
MN3527 (qm3513 clk_high3157 storage3526 vss) n12 w=1.2u l=0.13u
MP3528 (qm3513 clk_highb3158 storage3526 vdd) p12 w=3.6u l=0.13u
MN3529 (lead_sync1_7 clk_low3155 storage3526 vss) n12 w=1.2u l=0.13u
MP3530 (lead_sync1_7 clk_lowb3156 storage3526 vdd) p12 w=3.6u l=0.13u
MN3531 (qb3515 storage3526 vss vss) n12 w=0.5u l=0.13u
MP3532 (qb3515 storage3526 vdd vdd) p12 w=1.5u l=0.13u
MN3533 (lead_sync1_7 qb3515 vss vss) n12 w=0.5u l=0.13u
MP3534 (lead_sync1_7 qb3515 vdd vdd) p12 w=1.5u l=0.13u
MN3535 (storage3526 count_rst vss vss) n12 w=2u l=0.13u
MN3540 (lead_sync1_7 clk_low3155 storage3539 vss) n12 w=1.2u l=0.13u
MP3541 (lead_sync1_7 clk_lowb3156 storage3539 vdd) p12 w=3.6u l=0.13u
MN3542 (qm3536 clk_high3157 storage3539 vss) n12 w=1.2u l=0.13u
MP3543 (qm3536 clk_highb3158 storage3539 vdd) p12 w=3.6u l=0.13u
MN3544 (qmb3537 storage3539 vss vss) n12 w=0.5u l=0.13u
MP3545 (qmb3537 storage3539 vdd vdd) p12 w=1.5u l=0.13u
MN3546 (qm3536 qmb3537 vss vss) n12 w=0.5u l=0.13u
MP3547 (qm3536 qmb3537 vdd vdd) p12 w=1.5u l=0.13u
MN3548 (storage3539 count_rst vss vss) n12 w=2u l=0.13u
MN3550 (qm3536 clk_high3157 storage3549 vss) n12 w=1.2u l=0.13u
MP3551 (qm3536 clk_highb3158 storage3549 vdd) p12 w=3.6u l=0.13u
MN3552 (lead_sync2_7 clk_low3155 storage3549 vss) n12 w=1.2u l=0.13u
MP3553 (lead_sync2_7 clk_lowb3156 storage3549 vdd) p12 w=3.6u l=0.13u
MN3554 (qb3538 storage3549 vss vss) n12 w=0.5u l=0.13u
MP3555 (qb3538 storage3549 vdd vdd) p12 w=1.5u l=0.13u
MN3556 (lead_sync2_7 qb3538 vss vss) n12 w=0.5u l=0.13u
MP3557 (lead_sync2_7 qb3538 vdd vdd) p12 w=1.5u l=0.13u
MN3558 (storage3549 count_rst vss vss) n12 w=2u l=0.13u
MN3563 (lead_g8 clk_low3155 storage3562 vss) n12 w=1.2u l=0.13u
MP3564 (lead_g8 clk_lowb3156 storage3562 vdd) p12 w=3.6u l=0.13u
MN3565 (qm3559 clk_high3157 storage3562 vss) n12 w=1.2u l=0.13u
MP3566 (qm3559 clk_highb3158 storage3562 vdd) p12 w=3.6u l=0.13u
MN3567 (qmb3560 storage3562 vss vss) n12 w=0.5u l=0.13u
MP3568 (qmb3560 storage3562 vdd vdd) p12 w=1.5u l=0.13u
MN3569 (qm3559 qmb3560 vss vss) n12 w=0.5u l=0.13u
MP3570 (qm3559 qmb3560 vdd vdd) p12 w=1.5u l=0.13u
MN3571 (storage3562 count_rst vss vss) n12 w=2u l=0.13u
MN3573 (qm3559 clk_high3157 storage3572 vss) n12 w=1.2u l=0.13u
MP3574 (qm3559 clk_highb3158 storage3572 vdd) p12 w=3.6u l=0.13u
MN3575 (lead_sync1_8 clk_low3155 storage3572 vss) n12 w=1.2u l=0.13u
MP3576 (lead_sync1_8 clk_lowb3156 storage3572 vdd) p12 w=3.6u l=0.13u
MN3577 (qb3561 storage3572 vss vss) n12 w=0.5u l=0.13u
MP3578 (qb3561 storage3572 vdd vdd) p12 w=1.5u l=0.13u
MN3579 (lead_sync1_8 qb3561 vss vss) n12 w=0.5u l=0.13u
MP3580 (lead_sync1_8 qb3561 vdd vdd) p12 w=1.5u l=0.13u
MN3581 (storage3572 count_rst vss vss) n12 w=2u l=0.13u
MN3586 (lead_sync1_8 clk_low3155 storage3585 vss) n12 w=1.2u l=0.13u
MP3587 (lead_sync1_8 clk_lowb3156 storage3585 vdd) p12 w=3.6u l=0.13u
MN3588 (qm3582 clk_high3157 storage3585 vss) n12 w=1.2u l=0.13u
MP3589 (qm3582 clk_highb3158 storage3585 vdd) p12 w=3.6u l=0.13u
MN3590 (qmb3583 storage3585 vss vss) n12 w=0.5u l=0.13u
MP3591 (qmb3583 storage3585 vdd vdd) p12 w=1.5u l=0.13u
MN3592 (qm3582 qmb3583 vss vss) n12 w=0.5u l=0.13u
MP3593 (qm3582 qmb3583 vdd vdd) p12 w=1.5u l=0.13u
MN3594 (storage3585 count_rst vss vss) n12 w=2u l=0.13u
MN3596 (qm3582 clk_high3157 storage3595 vss) n12 w=1.2u l=0.13u
MP3597 (qm3582 clk_highb3158 storage3595 vdd) p12 w=3.6u l=0.13u
MN3598 (lead_sync2_8 clk_low3155 storage3595 vss) n12 w=1.2u l=0.13u
MP3599 (lead_sync2_8 clk_lowb3156 storage3595 vdd) p12 w=3.6u l=0.13u
MN3600 (qb3584 storage3595 vss vss) n12 w=0.5u l=0.13u
MP3601 (qb3584 storage3595 vdd vdd) p12 w=1.5u l=0.13u
MN3602 (lead_sync2_8 qb3584 vss vss) n12 w=0.5u l=0.13u
MP3603 (lead_sync2_8 qb3584 vdd vdd) p12 w=1.5u l=0.13u
MN3604 (storage3595 count_rst vss vss) n12 w=2u l=0.13u
MN3609 (lag_g0 clk_low3155 storage3608 vss) n12 w=1.2u l=0.13u
MP3610 (lag_g0 clk_lowb3156 storage3608 vdd) p12 w=3.6u l=0.13u
MN3611 (qm3605 clk_high3157 storage3608 vss) n12 w=1.2u l=0.13u
MP3612 (qm3605 clk_highb3158 storage3608 vdd) p12 w=3.6u l=0.13u
MN3613 (qmb3606 storage3608 vss vss) n12 w=0.5u l=0.13u
MP3614 (qmb3606 storage3608 vdd vdd) p12 w=1.5u l=0.13u
MN3615 (qm3605 qmb3606 vss vss) n12 w=0.5u l=0.13u
MP3616 (qm3605 qmb3606 vdd vdd) p12 w=1.5u l=0.13u
MN3617 (storage3608 count_rst vss vss) n12 w=2u l=0.13u
MN3619 (qm3605 clk_high3157 storage3618 vss) n12 w=1.2u l=0.13u
MP3620 (qm3605 clk_highb3158 storage3618 vdd) p12 w=3.6u l=0.13u
MN3621 (lag_sync1_0 clk_low3155 storage3618 vss) n12 w=1.2u l=0.13u
MP3622 (lag_sync1_0 clk_lowb3156 storage3618 vdd) p12 w=3.6u l=0.13u
MN3623 (qb3607 storage3618 vss vss) n12 w=0.5u l=0.13u
MP3624 (qb3607 storage3618 vdd vdd) p12 w=1.5u l=0.13u
MN3625 (lag_sync1_0 qb3607 vss vss) n12 w=0.5u l=0.13u
MP3626 (lag_sync1_0 qb3607 vdd vdd) p12 w=1.5u l=0.13u
MN3627 (storage3618 count_rst vss vss) n12 w=2u l=0.13u
MN3632 (lag_sync1_0 clk_low3155 storage3631 vss) n12 w=1.2u l=0.13u
MP3633 (lag_sync1_0 clk_lowb3156 storage3631 vdd) p12 w=3.6u l=0.13u
MN3634 (qm3628 clk_high3157 storage3631 vss) n12 w=1.2u l=0.13u
MP3635 (qm3628 clk_highb3158 storage3631 vdd) p12 w=3.6u l=0.13u
MN3636 (qmb3629 storage3631 vss vss) n12 w=0.5u l=0.13u
MP3637 (qmb3629 storage3631 vdd vdd) p12 w=1.5u l=0.13u
MN3638 (qm3628 qmb3629 vss vss) n12 w=0.5u l=0.13u
MP3639 (qm3628 qmb3629 vdd vdd) p12 w=1.5u l=0.13u
MN3640 (storage3631 count_rst vss vss) n12 w=2u l=0.13u
MN3642 (qm3628 clk_high3157 storage3641 vss) n12 w=1.2u l=0.13u
MP3643 (qm3628 clk_highb3158 storage3641 vdd) p12 w=3.6u l=0.13u
MN3644 (lag_sync2_0 clk_low3155 storage3641 vss) n12 w=1.2u l=0.13u
MP3645 (lag_sync2_0 clk_lowb3156 storage3641 vdd) p12 w=3.6u l=0.13u
MN3646 (qb3630 storage3641 vss vss) n12 w=0.5u l=0.13u
MP3647 (qb3630 storage3641 vdd vdd) p12 w=1.5u l=0.13u
MN3648 (lag_sync2_0 qb3630 vss vss) n12 w=0.5u l=0.13u
MP3649 (lag_sync2_0 qb3630 vdd vdd) p12 w=1.5u l=0.13u
MN3650 (storage3641 count_rst vss vss) n12 w=2u l=0.13u
MN3655 (lag_g1 clk_low3155 storage3654 vss) n12 w=1.2u l=0.13u
MP3656 (lag_g1 clk_lowb3156 storage3654 vdd) p12 w=3.6u l=0.13u
MN3657 (qm3651 clk_high3157 storage3654 vss) n12 w=1.2u l=0.13u
MP3658 (qm3651 clk_highb3158 storage3654 vdd) p12 w=3.6u l=0.13u
MN3659 (qmb3652 storage3654 vss vss) n12 w=0.5u l=0.13u
MP3660 (qmb3652 storage3654 vdd vdd) p12 w=1.5u l=0.13u
MN3661 (qm3651 qmb3652 vss vss) n12 w=0.5u l=0.13u
MP3662 (qm3651 qmb3652 vdd vdd) p12 w=1.5u l=0.13u
MN3663 (storage3654 count_rst vss vss) n12 w=2u l=0.13u
MN3665 (qm3651 clk_high3157 storage3664 vss) n12 w=1.2u l=0.13u
MP3666 (qm3651 clk_highb3158 storage3664 vdd) p12 w=3.6u l=0.13u
MN3667 (lag_sync1_1 clk_low3155 storage3664 vss) n12 w=1.2u l=0.13u
MP3668 (lag_sync1_1 clk_lowb3156 storage3664 vdd) p12 w=3.6u l=0.13u
MN3669 (qb3653 storage3664 vss vss) n12 w=0.5u l=0.13u
MP3670 (qb3653 storage3664 vdd vdd) p12 w=1.5u l=0.13u
MN3671 (lag_sync1_1 qb3653 vss vss) n12 w=0.5u l=0.13u
MP3672 (lag_sync1_1 qb3653 vdd vdd) p12 w=1.5u l=0.13u
MN3673 (storage3664 count_rst vss vss) n12 w=2u l=0.13u
MN3678 (lag_sync1_1 clk_low3155 storage3677 vss) n12 w=1.2u l=0.13u
MP3679 (lag_sync1_1 clk_lowb3156 storage3677 vdd) p12 w=3.6u l=0.13u
MN3680 (qm3674 clk_high3157 storage3677 vss) n12 w=1.2u l=0.13u
MP3681 (qm3674 clk_highb3158 storage3677 vdd) p12 w=3.6u l=0.13u
MN3682 (qmb3675 storage3677 vss vss) n12 w=0.5u l=0.13u
MP3683 (qmb3675 storage3677 vdd vdd) p12 w=1.5u l=0.13u
MN3684 (qm3674 qmb3675 vss vss) n12 w=0.5u l=0.13u
MP3685 (qm3674 qmb3675 vdd vdd) p12 w=1.5u l=0.13u
MN3686 (storage3677 count_rst vss vss) n12 w=2u l=0.13u
MN3688 (qm3674 clk_high3157 storage3687 vss) n12 w=1.2u l=0.13u
MP3689 (qm3674 clk_highb3158 storage3687 vdd) p12 w=3.6u l=0.13u
MN3690 (lag_sync2_1 clk_low3155 storage3687 vss) n12 w=1.2u l=0.13u
MP3691 (lag_sync2_1 clk_lowb3156 storage3687 vdd) p12 w=3.6u l=0.13u
MN3692 (qb3676 storage3687 vss vss) n12 w=0.5u l=0.13u
MP3693 (qb3676 storage3687 vdd vdd) p12 w=1.5u l=0.13u
MN3694 (lag_sync2_1 qb3676 vss vss) n12 w=0.5u l=0.13u
MP3695 (lag_sync2_1 qb3676 vdd vdd) p12 w=1.5u l=0.13u
MN3696 (storage3687 count_rst vss vss) n12 w=2u l=0.13u
MN3701 (lag_g2 clk_low3155 storage3700 vss) n12 w=1.2u l=0.13u
MP3702 (lag_g2 clk_lowb3156 storage3700 vdd) p12 w=3.6u l=0.13u
MN3703 (qm3697 clk_high3157 storage3700 vss) n12 w=1.2u l=0.13u
MP3704 (qm3697 clk_highb3158 storage3700 vdd) p12 w=3.6u l=0.13u
MN3705 (qmb3698 storage3700 vss vss) n12 w=0.5u l=0.13u
MP3706 (qmb3698 storage3700 vdd vdd) p12 w=1.5u l=0.13u
MN3707 (qm3697 qmb3698 vss vss) n12 w=0.5u l=0.13u
MP3708 (qm3697 qmb3698 vdd vdd) p12 w=1.5u l=0.13u
MN3709 (storage3700 count_rst vss vss) n12 w=2u l=0.13u
MN3711 (qm3697 clk_high3157 storage3710 vss) n12 w=1.2u l=0.13u
MP3712 (qm3697 clk_highb3158 storage3710 vdd) p12 w=3.6u l=0.13u
MN3713 (lag_sync1_2 clk_low3155 storage3710 vss) n12 w=1.2u l=0.13u
MP3714 (lag_sync1_2 clk_lowb3156 storage3710 vdd) p12 w=3.6u l=0.13u
MN3715 (qb3699 storage3710 vss vss) n12 w=0.5u l=0.13u
MP3716 (qb3699 storage3710 vdd vdd) p12 w=1.5u l=0.13u
MN3717 (lag_sync1_2 qb3699 vss vss) n12 w=0.5u l=0.13u
MP3718 (lag_sync1_2 qb3699 vdd vdd) p12 w=1.5u l=0.13u
MN3719 (storage3710 count_rst vss vss) n12 w=2u l=0.13u
MN3724 (lag_sync1_2 clk_low3155 storage3723 vss) n12 w=1.2u l=0.13u
MP3725 (lag_sync1_2 clk_lowb3156 storage3723 vdd) p12 w=3.6u l=0.13u
MN3726 (qm3720 clk_high3157 storage3723 vss) n12 w=1.2u l=0.13u
MP3727 (qm3720 clk_highb3158 storage3723 vdd) p12 w=3.6u l=0.13u
MN3728 (qmb3721 storage3723 vss vss) n12 w=0.5u l=0.13u
MP3729 (qmb3721 storage3723 vdd vdd) p12 w=1.5u l=0.13u
MN3730 (qm3720 qmb3721 vss vss) n12 w=0.5u l=0.13u
MP3731 (qm3720 qmb3721 vdd vdd) p12 w=1.5u l=0.13u
MN3732 (storage3723 count_rst vss vss) n12 w=2u l=0.13u
MN3734 (qm3720 clk_high3157 storage3733 vss) n12 w=1.2u l=0.13u
MP3735 (qm3720 clk_highb3158 storage3733 vdd) p12 w=3.6u l=0.13u
MN3736 (lag_sync2_2 clk_low3155 storage3733 vss) n12 w=1.2u l=0.13u
MP3737 (lag_sync2_2 clk_lowb3156 storage3733 vdd) p12 w=3.6u l=0.13u
MN3738 (qb3722 storage3733 vss vss) n12 w=0.5u l=0.13u
MP3739 (qb3722 storage3733 vdd vdd) p12 w=1.5u l=0.13u
MN3740 (lag_sync2_2 qb3722 vss vss) n12 w=0.5u l=0.13u
MP3741 (lag_sync2_2 qb3722 vdd vdd) p12 w=1.5u l=0.13u
MN3742 (storage3733 count_rst vss vss) n12 w=2u l=0.13u
MN3747 (lag_g3 clk_low3155 storage3746 vss) n12 w=1.2u l=0.13u
MP3748 (lag_g3 clk_lowb3156 storage3746 vdd) p12 w=3.6u l=0.13u
MN3749 (qm3743 clk_high3157 storage3746 vss) n12 w=1.2u l=0.13u
MP3750 (qm3743 clk_highb3158 storage3746 vdd) p12 w=3.6u l=0.13u
MN3751 (qmb3744 storage3746 vss vss) n12 w=0.5u l=0.13u
MP3752 (qmb3744 storage3746 vdd vdd) p12 w=1.5u l=0.13u
MN3753 (qm3743 qmb3744 vss vss) n12 w=0.5u l=0.13u
MP3754 (qm3743 qmb3744 vdd vdd) p12 w=1.5u l=0.13u
MN3755 (storage3746 count_rst vss vss) n12 w=2u l=0.13u
MN3757 (qm3743 clk_high3157 storage3756 vss) n12 w=1.2u l=0.13u
MP3758 (qm3743 clk_highb3158 storage3756 vdd) p12 w=3.6u l=0.13u
MN3759 (lag_sync1_3 clk_low3155 storage3756 vss) n12 w=1.2u l=0.13u
MP3760 (lag_sync1_3 clk_lowb3156 storage3756 vdd) p12 w=3.6u l=0.13u
MN3761 (qb3745 storage3756 vss vss) n12 w=0.5u l=0.13u
MP3762 (qb3745 storage3756 vdd vdd) p12 w=1.5u l=0.13u
MN3763 (lag_sync1_3 qb3745 vss vss) n12 w=0.5u l=0.13u
MP3764 (lag_sync1_3 qb3745 vdd vdd) p12 w=1.5u l=0.13u
MN3765 (storage3756 count_rst vss vss) n12 w=2u l=0.13u
MN3770 (lag_sync1_3 clk_low3155 storage3769 vss) n12 w=1.2u l=0.13u
MP3771 (lag_sync1_3 clk_lowb3156 storage3769 vdd) p12 w=3.6u l=0.13u
MN3772 (qm3766 clk_high3157 storage3769 vss) n12 w=1.2u l=0.13u
MP3773 (qm3766 clk_highb3158 storage3769 vdd) p12 w=3.6u l=0.13u
MN3774 (qmb3767 storage3769 vss vss) n12 w=0.5u l=0.13u
MP3775 (qmb3767 storage3769 vdd vdd) p12 w=1.5u l=0.13u
MN3776 (qm3766 qmb3767 vss vss) n12 w=0.5u l=0.13u
MP3777 (qm3766 qmb3767 vdd vdd) p12 w=1.5u l=0.13u
MN3778 (storage3769 count_rst vss vss) n12 w=2u l=0.13u
MN3780 (qm3766 clk_high3157 storage3779 vss) n12 w=1.2u l=0.13u
MP3781 (qm3766 clk_highb3158 storage3779 vdd) p12 w=3.6u l=0.13u
MN3782 (lag_sync2_3 clk_low3155 storage3779 vss) n12 w=1.2u l=0.13u
MP3783 (lag_sync2_3 clk_lowb3156 storage3779 vdd) p12 w=3.6u l=0.13u
MN3784 (qb3768 storage3779 vss vss) n12 w=0.5u l=0.13u
MP3785 (qb3768 storage3779 vdd vdd) p12 w=1.5u l=0.13u
MN3786 (lag_sync2_3 qb3768 vss vss) n12 w=0.5u l=0.13u
MP3787 (lag_sync2_3 qb3768 vdd vdd) p12 w=1.5u l=0.13u
MN3788 (storage3779 count_rst vss vss) n12 w=2u l=0.13u
MN3793 (lag_g4 clk_low3155 storage3792 vss) n12 w=1.2u l=0.13u
MP3794 (lag_g4 clk_lowb3156 storage3792 vdd) p12 w=3.6u l=0.13u
MN3795 (qm3789 clk_high3157 storage3792 vss) n12 w=1.2u l=0.13u
MP3796 (qm3789 clk_highb3158 storage3792 vdd) p12 w=3.6u l=0.13u
MN3797 (qmb3790 storage3792 vss vss) n12 w=0.5u l=0.13u
MP3798 (qmb3790 storage3792 vdd vdd) p12 w=1.5u l=0.13u
MN3799 (qm3789 qmb3790 vss vss) n12 w=0.5u l=0.13u
MP3800 (qm3789 qmb3790 vdd vdd) p12 w=1.5u l=0.13u
MN3801 (storage3792 count_rst vss vss) n12 w=2u l=0.13u
MN3803 (qm3789 clk_high3157 storage3802 vss) n12 w=1.2u l=0.13u
MP3804 (qm3789 clk_highb3158 storage3802 vdd) p12 w=3.6u l=0.13u
MN3805 (lag_sync1_4 clk_low3155 storage3802 vss) n12 w=1.2u l=0.13u
MP3806 (lag_sync1_4 clk_lowb3156 storage3802 vdd) p12 w=3.6u l=0.13u
MN3807 (qb3791 storage3802 vss vss) n12 w=0.5u l=0.13u
MP3808 (qb3791 storage3802 vdd vdd) p12 w=1.5u l=0.13u
MN3809 (lag_sync1_4 qb3791 vss vss) n12 w=0.5u l=0.13u
MP3810 (lag_sync1_4 qb3791 vdd vdd) p12 w=1.5u l=0.13u
MN3811 (storage3802 count_rst vss vss) n12 w=2u l=0.13u
MN3816 (lag_sync1_4 clk_low3155 storage3815 vss) n12 w=1.2u l=0.13u
MP3817 (lag_sync1_4 clk_lowb3156 storage3815 vdd) p12 w=3.6u l=0.13u
MN3818 (qm3812 clk_high3157 storage3815 vss) n12 w=1.2u l=0.13u
MP3819 (qm3812 clk_highb3158 storage3815 vdd) p12 w=3.6u l=0.13u
MN3820 (qmb3813 storage3815 vss vss) n12 w=0.5u l=0.13u
MP3821 (qmb3813 storage3815 vdd vdd) p12 w=1.5u l=0.13u
MN3822 (qm3812 qmb3813 vss vss) n12 w=0.5u l=0.13u
MP3823 (qm3812 qmb3813 vdd vdd) p12 w=1.5u l=0.13u
MN3824 (storage3815 count_rst vss vss) n12 w=2u l=0.13u
MN3826 (qm3812 clk_high3157 storage3825 vss) n12 w=1.2u l=0.13u
MP3827 (qm3812 clk_highb3158 storage3825 vdd) p12 w=3.6u l=0.13u
MN3828 (lag_sync2_4 clk_low3155 storage3825 vss) n12 w=1.2u l=0.13u
MP3829 (lag_sync2_4 clk_lowb3156 storage3825 vdd) p12 w=3.6u l=0.13u
MN3830 (qb3814 storage3825 vss vss) n12 w=0.5u l=0.13u
MP3831 (qb3814 storage3825 vdd vdd) p12 w=1.5u l=0.13u
MN3832 (lag_sync2_4 qb3814 vss vss) n12 w=0.5u l=0.13u
MP3833 (lag_sync2_4 qb3814 vdd vdd) p12 w=1.5u l=0.13u
MN3834 (storage3825 count_rst vss vss) n12 w=2u l=0.13u
MN3839 (lag_g5 clk_low3155 storage3838 vss) n12 w=1.2u l=0.13u
MP3840 (lag_g5 clk_lowb3156 storage3838 vdd) p12 w=3.6u l=0.13u
MN3841 (qm3835 clk_high3157 storage3838 vss) n12 w=1.2u l=0.13u
MP3842 (qm3835 clk_highb3158 storage3838 vdd) p12 w=3.6u l=0.13u
MN3843 (qmb3836 storage3838 vss vss) n12 w=0.5u l=0.13u
MP3844 (qmb3836 storage3838 vdd vdd) p12 w=1.5u l=0.13u
MN3845 (qm3835 qmb3836 vss vss) n12 w=0.5u l=0.13u
MP3846 (qm3835 qmb3836 vdd vdd) p12 w=1.5u l=0.13u
MN3847 (storage3838 count_rst vss vss) n12 w=2u l=0.13u
MN3849 (qm3835 clk_high3157 storage3848 vss) n12 w=1.2u l=0.13u
MP3850 (qm3835 clk_highb3158 storage3848 vdd) p12 w=3.6u l=0.13u
MN3851 (lag_sync1_5 clk_low3155 storage3848 vss) n12 w=1.2u l=0.13u
MP3852 (lag_sync1_5 clk_lowb3156 storage3848 vdd) p12 w=3.6u l=0.13u
MN3853 (qb3837 storage3848 vss vss) n12 w=0.5u l=0.13u
MP3854 (qb3837 storage3848 vdd vdd) p12 w=1.5u l=0.13u
MN3855 (lag_sync1_5 qb3837 vss vss) n12 w=0.5u l=0.13u
MP3856 (lag_sync1_5 qb3837 vdd vdd) p12 w=1.5u l=0.13u
MN3857 (storage3848 count_rst vss vss) n12 w=2u l=0.13u
MN3862 (lag_sync1_5 clk_low3155 storage3861 vss) n12 w=1.2u l=0.13u
MP3863 (lag_sync1_5 clk_lowb3156 storage3861 vdd) p12 w=3.6u l=0.13u
MN3864 (qm3858 clk_high3157 storage3861 vss) n12 w=1.2u l=0.13u
MP3865 (qm3858 clk_highb3158 storage3861 vdd) p12 w=3.6u l=0.13u
MN3866 (qmb3859 storage3861 vss vss) n12 w=0.5u l=0.13u
MP3867 (qmb3859 storage3861 vdd vdd) p12 w=1.5u l=0.13u
MN3868 (qm3858 qmb3859 vss vss) n12 w=0.5u l=0.13u
MP3869 (qm3858 qmb3859 vdd vdd) p12 w=1.5u l=0.13u
MN3870 (storage3861 count_rst vss vss) n12 w=2u l=0.13u
MN3872 (qm3858 clk_high3157 storage3871 vss) n12 w=1.2u l=0.13u
MP3873 (qm3858 clk_highb3158 storage3871 vdd) p12 w=3.6u l=0.13u
MN3874 (lag_sync2_5 clk_low3155 storage3871 vss) n12 w=1.2u l=0.13u
MP3875 (lag_sync2_5 clk_lowb3156 storage3871 vdd) p12 w=3.6u l=0.13u
MN3876 (qb3860 storage3871 vss vss) n12 w=0.5u l=0.13u
MP3877 (qb3860 storage3871 vdd vdd) p12 w=1.5u l=0.13u
MN3878 (lag_sync2_5 qb3860 vss vss) n12 w=0.5u l=0.13u
MP3879 (lag_sync2_5 qb3860 vdd vdd) p12 w=1.5u l=0.13u
MN3880 (storage3871 count_rst vss vss) n12 w=2u l=0.13u
MN3885 (lag_g6 clk_low3155 storage3884 vss) n12 w=1.2u l=0.13u
MP3886 (lag_g6 clk_lowb3156 storage3884 vdd) p12 w=3.6u l=0.13u
MN3887 (qm3881 clk_high3157 storage3884 vss) n12 w=1.2u l=0.13u
MP3888 (qm3881 clk_highb3158 storage3884 vdd) p12 w=3.6u l=0.13u
MN3889 (qmb3882 storage3884 vss vss) n12 w=0.5u l=0.13u
MP3890 (qmb3882 storage3884 vdd vdd) p12 w=1.5u l=0.13u
MN3891 (qm3881 qmb3882 vss vss) n12 w=0.5u l=0.13u
MP3892 (qm3881 qmb3882 vdd vdd) p12 w=1.5u l=0.13u
MN3893 (storage3884 count_rst vss vss) n12 w=2u l=0.13u
MN3895 (qm3881 clk_high3157 storage3894 vss) n12 w=1.2u l=0.13u
MP3896 (qm3881 clk_highb3158 storage3894 vdd) p12 w=3.6u l=0.13u
MN3897 (lag_sync1_6 clk_low3155 storage3894 vss) n12 w=1.2u l=0.13u
MP3898 (lag_sync1_6 clk_lowb3156 storage3894 vdd) p12 w=3.6u l=0.13u
MN3899 (qb3883 storage3894 vss vss) n12 w=0.5u l=0.13u
MP3900 (qb3883 storage3894 vdd vdd) p12 w=1.5u l=0.13u
MN3901 (lag_sync1_6 qb3883 vss vss) n12 w=0.5u l=0.13u
MP3902 (lag_sync1_6 qb3883 vdd vdd) p12 w=1.5u l=0.13u
MN3903 (storage3894 count_rst vss vss) n12 w=2u l=0.13u
MN3908 (lag_sync1_6 clk_low3155 storage3907 vss) n12 w=1.2u l=0.13u
MP3909 (lag_sync1_6 clk_lowb3156 storage3907 vdd) p12 w=3.6u l=0.13u
MN3910 (qm3904 clk_high3157 storage3907 vss) n12 w=1.2u l=0.13u
MP3911 (qm3904 clk_highb3158 storage3907 vdd) p12 w=3.6u l=0.13u
MN3912 (qmb3905 storage3907 vss vss) n12 w=0.5u l=0.13u
MP3913 (qmb3905 storage3907 vdd vdd) p12 w=1.5u l=0.13u
MN3914 (qm3904 qmb3905 vss vss) n12 w=0.5u l=0.13u
MP3915 (qm3904 qmb3905 vdd vdd) p12 w=1.5u l=0.13u
MN3916 (storage3907 count_rst vss vss) n12 w=2u l=0.13u
MN3918 (qm3904 clk_high3157 storage3917 vss) n12 w=1.2u l=0.13u
MP3919 (qm3904 clk_highb3158 storage3917 vdd) p12 w=3.6u l=0.13u
MN3920 (lag_sync2_6 clk_low3155 storage3917 vss) n12 w=1.2u l=0.13u
MP3921 (lag_sync2_6 clk_lowb3156 storage3917 vdd) p12 w=3.6u l=0.13u
MN3922 (qb3906 storage3917 vss vss) n12 w=0.5u l=0.13u
MP3923 (qb3906 storage3917 vdd vdd) p12 w=1.5u l=0.13u
MN3924 (lag_sync2_6 qb3906 vss vss) n12 w=0.5u l=0.13u
MP3925 (lag_sync2_6 qb3906 vdd vdd) p12 w=1.5u l=0.13u
MN3926 (storage3917 count_rst vss vss) n12 w=2u l=0.13u
MN3931 (lag_g7 clk_low3155 storage3930 vss) n12 w=1.2u l=0.13u
MP3932 (lag_g7 clk_lowb3156 storage3930 vdd) p12 w=3.6u l=0.13u
MN3933 (qm3927 clk_high3157 storage3930 vss) n12 w=1.2u l=0.13u
MP3934 (qm3927 clk_highb3158 storage3930 vdd) p12 w=3.6u l=0.13u
MN3935 (qmb3928 storage3930 vss vss) n12 w=0.5u l=0.13u
MP3936 (qmb3928 storage3930 vdd vdd) p12 w=1.5u l=0.13u
MN3937 (qm3927 qmb3928 vss vss) n12 w=0.5u l=0.13u
MP3938 (qm3927 qmb3928 vdd vdd) p12 w=1.5u l=0.13u
MN3939 (storage3930 count_rst vss vss) n12 w=2u l=0.13u
MN3941 (qm3927 clk_high3157 storage3940 vss) n12 w=1.2u l=0.13u
MP3942 (qm3927 clk_highb3158 storage3940 vdd) p12 w=3.6u l=0.13u
MN3943 (lag_sync1_7 clk_low3155 storage3940 vss) n12 w=1.2u l=0.13u
MP3944 (lag_sync1_7 clk_lowb3156 storage3940 vdd) p12 w=3.6u l=0.13u
MN3945 (qb3929 storage3940 vss vss) n12 w=0.5u l=0.13u
MP3946 (qb3929 storage3940 vdd vdd) p12 w=1.5u l=0.13u
MN3947 (lag_sync1_7 qb3929 vss vss) n12 w=0.5u l=0.13u
MP3948 (lag_sync1_7 qb3929 vdd vdd) p12 w=1.5u l=0.13u
MN3949 (storage3940 count_rst vss vss) n12 w=2u l=0.13u
MN3954 (lag_sync1_7 clk_low3155 storage3953 vss) n12 w=1.2u l=0.13u
MP3955 (lag_sync1_7 clk_lowb3156 storage3953 vdd) p12 w=3.6u l=0.13u
MN3956 (qm3950 clk_high3157 storage3953 vss) n12 w=1.2u l=0.13u
MP3957 (qm3950 clk_highb3158 storage3953 vdd) p12 w=3.6u l=0.13u
MN3958 (qmb3951 storage3953 vss vss) n12 w=0.5u l=0.13u
MP3959 (qmb3951 storage3953 vdd vdd) p12 w=1.5u l=0.13u
MN3960 (qm3950 qmb3951 vss vss) n12 w=0.5u l=0.13u
MP3961 (qm3950 qmb3951 vdd vdd) p12 w=1.5u l=0.13u
MN3962 (storage3953 count_rst vss vss) n12 w=2u l=0.13u
MN3964 (qm3950 clk_high3157 storage3963 vss) n12 w=1.2u l=0.13u
MP3965 (qm3950 clk_highb3158 storage3963 vdd) p12 w=3.6u l=0.13u
MN3966 (lag_sync2_7 clk_low3155 storage3963 vss) n12 w=1.2u l=0.13u
MP3967 (lag_sync2_7 clk_lowb3156 storage3963 vdd) p12 w=3.6u l=0.13u
MN3968 (qb3952 storage3963 vss vss) n12 w=0.5u l=0.13u
MP3969 (qb3952 storage3963 vdd vdd) p12 w=1.5u l=0.13u
MN3970 (lag_sync2_7 qb3952 vss vss) n12 w=0.5u l=0.13u
MP3971 (lag_sync2_7 qb3952 vdd vdd) p12 w=1.5u l=0.13u
MN3972 (storage3963 count_rst vss vss) n12 w=2u l=0.13u
MN3977 (lag_g8 clk_low3155 storage3976 vss) n12 w=1.2u l=0.13u
MP3978 (lag_g8 clk_lowb3156 storage3976 vdd) p12 w=3.6u l=0.13u
MN3979 (qm3973 clk_high3157 storage3976 vss) n12 w=1.2u l=0.13u
MP3980 (qm3973 clk_highb3158 storage3976 vdd) p12 w=3.6u l=0.13u
MN3981 (qmb3974 storage3976 vss vss) n12 w=0.5u l=0.13u
MP3982 (qmb3974 storage3976 vdd vdd) p12 w=1.5u l=0.13u
MN3983 (qm3973 qmb3974 vss vss) n12 w=0.5u l=0.13u
MP3984 (qm3973 qmb3974 vdd vdd) p12 w=1.5u l=0.13u
MN3985 (storage3976 count_rst vss vss) n12 w=2u l=0.13u
MN3987 (qm3973 clk_high3157 storage3986 vss) n12 w=1.2u l=0.13u
MP3988 (qm3973 clk_highb3158 storage3986 vdd) p12 w=3.6u l=0.13u
MN3989 (lag_sync1_8 clk_low3155 storage3986 vss) n12 w=1.2u l=0.13u
MP3990 (lag_sync1_8 clk_lowb3156 storage3986 vdd) p12 w=3.6u l=0.13u
MN3991 (qb3975 storage3986 vss vss) n12 w=0.5u l=0.13u
MP3992 (qb3975 storage3986 vdd vdd) p12 w=1.5u l=0.13u
MN3993 (lag_sync1_8 qb3975 vss vss) n12 w=0.5u l=0.13u
MP3994 (lag_sync1_8 qb3975 vdd vdd) p12 w=1.5u l=0.13u
MN3995 (storage3986 count_rst vss vss) n12 w=2u l=0.13u
MN4000 (lag_sync1_8 clk_low3155 storage3999 vss) n12 w=1.2u l=0.13u
MP4001 (lag_sync1_8 clk_lowb3156 storage3999 vdd) p12 w=3.6u l=0.13u
MN4002 (qm3996 clk_high3157 storage3999 vss) n12 w=1.2u l=0.13u
MP4003 (qm3996 clk_highb3158 storage3999 vdd) p12 w=3.6u l=0.13u
MN4004 (qmb3997 storage3999 vss vss) n12 w=0.5u l=0.13u
MP4005 (qmb3997 storage3999 vdd vdd) p12 w=1.5u l=0.13u
MN4006 (qm3996 qmb3997 vss vss) n12 w=0.5u l=0.13u
MP4007 (qm3996 qmb3997 vdd vdd) p12 w=1.5u l=0.13u
MN4008 (storage3999 count_rst vss vss) n12 w=2u l=0.13u
MN4010 (qm3996 clk_high3157 storage4009 vss) n12 w=1.2u l=0.13u
MP4011 (qm3996 clk_highb3158 storage4009 vdd) p12 w=3.6u l=0.13u
MN4012 (lag_sync2_8 clk_low3155 storage4009 vss) n12 w=1.2u l=0.13u
MP4013 (lag_sync2_8 clk_lowb3156 storage4009 vdd) p12 w=3.6u l=0.13u
MN4014 (qb3998 storage4009 vss vss) n12 w=0.5u l=0.13u
MP4015 (qb3998 storage4009 vdd vdd) p12 w=1.5u l=0.13u
MN4016 (lag_sync2_8 qb3998 vss vss) n12 w=0.5u l=0.13u
MP4017 (lag_sync2_8 qb3998 vdd vdd) p12 w=1.5u l=0.13u
MN4018 (storage4009 count_rst vss vss) n12 w=2u l=0.13u
MN4023 (div_g0 clk_low3155 storage4022 vss) n12 w=1.2u l=0.13u
MP4024 (div_g0 clk_lowb3156 storage4022 vdd) p12 w=3.6u l=0.13u
MN4025 (qm4019 clk_high3157 storage4022 vss) n12 w=1.2u l=0.13u
MP4026 (qm4019 clk_highb3158 storage4022 vdd) p12 w=3.6u l=0.13u
MN4027 (qmb4020 storage4022 vss vss) n12 w=0.5u l=0.13u
MP4028 (qmb4020 storage4022 vdd vdd) p12 w=1.5u l=0.13u
MN4029 (qm4019 qmb4020 vss vss) n12 w=0.5u l=0.13u
MP4030 (qm4019 qmb4020 vdd vdd) p12 w=1.5u l=0.13u
MN4031 (storage4022 count_rst vss vss) n12 w=2u l=0.13u
MN4033 (qm4019 clk_high3157 storage4032 vss) n12 w=1.2u l=0.13u
MP4034 (qm4019 clk_highb3158 storage4032 vdd) p12 w=3.6u l=0.13u
MN4035 (div_sync1_0 clk_low3155 storage4032 vss) n12 w=1.2u l=0.13u
MP4036 (div_sync1_0 clk_lowb3156 storage4032 vdd) p12 w=3.6u l=0.13u
MN4037 (qb4021 storage4032 vss vss) n12 w=0.5u l=0.13u
MP4038 (qb4021 storage4032 vdd vdd) p12 w=1.5u l=0.13u
MN4039 (div_sync1_0 qb4021 vss vss) n12 w=0.5u l=0.13u
MP4040 (div_sync1_0 qb4021 vdd vdd) p12 w=1.5u l=0.13u
MN4041 (storage4032 count_rst vss vss) n12 w=2u l=0.13u
MN4046 (div_sync1_0 clk_low3155 storage4045 vss) n12 w=1.2u l=0.13u
MP4047 (div_sync1_0 clk_lowb3156 storage4045 vdd) p12 w=3.6u l=0.13u
MN4048 (qm4042 clk_high3157 storage4045 vss) n12 w=1.2u l=0.13u
MP4049 (qm4042 clk_highb3158 storage4045 vdd) p12 w=3.6u l=0.13u
MN4050 (qmb4043 storage4045 vss vss) n12 w=0.5u l=0.13u
MP4051 (qmb4043 storage4045 vdd vdd) p12 w=1.5u l=0.13u
MN4052 (qm4042 qmb4043 vss vss) n12 w=0.5u l=0.13u
MP4053 (qm4042 qmb4043 vdd vdd) p12 w=1.5u l=0.13u
MN4054 (storage4045 count_rst vss vss) n12 w=2u l=0.13u
MN4056 (qm4042 clk_high3157 storage4055 vss) n12 w=1.2u l=0.13u
MP4057 (qm4042 clk_highb3158 storage4055 vdd) p12 w=3.6u l=0.13u
MN4058 (div_sync2_0 clk_low3155 storage4055 vss) n12 w=1.2u l=0.13u
MP4059 (div_sync2_0 clk_lowb3156 storage4055 vdd) p12 w=3.6u l=0.13u
MN4060 (qb4044 storage4055 vss vss) n12 w=0.5u l=0.13u
MP4061 (qb4044 storage4055 vdd vdd) p12 w=1.5u l=0.13u
MN4062 (div_sync2_0 qb4044 vss vss) n12 w=0.5u l=0.13u
MP4063 (div_sync2_0 qb4044 vdd vdd) p12 w=1.5u l=0.13u
MN4064 (storage4055 count_rst vss vss) n12 w=2u l=0.13u
MN4069 (div_g1 clk_low3155 storage4068 vss) n12 w=1.2u l=0.13u
MP4070 (div_g1 clk_lowb3156 storage4068 vdd) p12 w=3.6u l=0.13u
MN4071 (qm4065 clk_high3157 storage4068 vss) n12 w=1.2u l=0.13u
MP4072 (qm4065 clk_highb3158 storage4068 vdd) p12 w=3.6u l=0.13u
MN4073 (qmb4066 storage4068 vss vss) n12 w=0.5u l=0.13u
MP4074 (qmb4066 storage4068 vdd vdd) p12 w=1.5u l=0.13u
MN4075 (qm4065 qmb4066 vss vss) n12 w=0.5u l=0.13u
MP4076 (qm4065 qmb4066 vdd vdd) p12 w=1.5u l=0.13u
MN4077 (storage4068 count_rst vss vss) n12 w=2u l=0.13u
MN4079 (qm4065 clk_high3157 storage4078 vss) n12 w=1.2u l=0.13u
MP4080 (qm4065 clk_highb3158 storage4078 vdd) p12 w=3.6u l=0.13u
MN4081 (div_sync1_1 clk_low3155 storage4078 vss) n12 w=1.2u l=0.13u
MP4082 (div_sync1_1 clk_lowb3156 storage4078 vdd) p12 w=3.6u l=0.13u
MN4083 (qb4067 storage4078 vss vss) n12 w=0.5u l=0.13u
MP4084 (qb4067 storage4078 vdd vdd) p12 w=1.5u l=0.13u
MN4085 (div_sync1_1 qb4067 vss vss) n12 w=0.5u l=0.13u
MP4086 (div_sync1_1 qb4067 vdd vdd) p12 w=1.5u l=0.13u
MN4087 (storage4078 count_rst vss vss) n12 w=2u l=0.13u
MN4092 (div_sync1_1 clk_low3155 storage4091 vss) n12 w=1.2u l=0.13u
MP4093 (div_sync1_1 clk_lowb3156 storage4091 vdd) p12 w=3.6u l=0.13u
MN4094 (qm4088 clk_high3157 storage4091 vss) n12 w=1.2u l=0.13u
MP4095 (qm4088 clk_highb3158 storage4091 vdd) p12 w=3.6u l=0.13u
MN4096 (qmb4089 storage4091 vss vss) n12 w=0.5u l=0.13u
MP4097 (qmb4089 storage4091 vdd vdd) p12 w=1.5u l=0.13u
MN4098 (qm4088 qmb4089 vss vss) n12 w=0.5u l=0.13u
MP4099 (qm4088 qmb4089 vdd vdd) p12 w=1.5u l=0.13u
MN4100 (storage4091 count_rst vss vss) n12 w=2u l=0.13u
MN4102 (qm4088 clk_high3157 storage4101 vss) n12 w=1.2u l=0.13u
MP4103 (qm4088 clk_highb3158 storage4101 vdd) p12 w=3.6u l=0.13u
MN4104 (div_sync2_1 clk_low3155 storage4101 vss) n12 w=1.2u l=0.13u
MP4105 (div_sync2_1 clk_lowb3156 storage4101 vdd) p12 w=3.6u l=0.13u
MN4106 (qb4090 storage4101 vss vss) n12 w=0.5u l=0.13u
MP4107 (qb4090 storage4101 vdd vdd) p12 w=1.5u l=0.13u
MN4108 (div_sync2_1 qb4090 vss vss) n12 w=0.5u l=0.13u
MP4109 (div_sync2_1 qb4090 vdd vdd) p12 w=1.5u l=0.13u
MN4110 (storage4101 count_rst vss vss) n12 w=2u l=0.13u
MN4115 (div_g2 clk_low3155 storage4114 vss) n12 w=1.2u l=0.13u
MP4116 (div_g2 clk_lowb3156 storage4114 vdd) p12 w=3.6u l=0.13u
MN4117 (qm4111 clk_high3157 storage4114 vss) n12 w=1.2u l=0.13u
MP4118 (qm4111 clk_highb3158 storage4114 vdd) p12 w=3.6u l=0.13u
MN4119 (qmb4112 storage4114 vss vss) n12 w=0.5u l=0.13u
MP4120 (qmb4112 storage4114 vdd vdd) p12 w=1.5u l=0.13u
MN4121 (qm4111 qmb4112 vss vss) n12 w=0.5u l=0.13u
MP4122 (qm4111 qmb4112 vdd vdd) p12 w=1.5u l=0.13u
MN4123 (storage4114 count_rst vss vss) n12 w=2u l=0.13u
MN4125 (qm4111 clk_high3157 storage4124 vss) n12 w=1.2u l=0.13u
MP4126 (qm4111 clk_highb3158 storage4124 vdd) p12 w=3.6u l=0.13u
MN4127 (div_sync1_2 clk_low3155 storage4124 vss) n12 w=1.2u l=0.13u
MP4128 (div_sync1_2 clk_lowb3156 storage4124 vdd) p12 w=3.6u l=0.13u
MN4129 (qb4113 storage4124 vss vss) n12 w=0.5u l=0.13u
MP4130 (qb4113 storage4124 vdd vdd) p12 w=1.5u l=0.13u
MN4131 (div_sync1_2 qb4113 vss vss) n12 w=0.5u l=0.13u
MP4132 (div_sync1_2 qb4113 vdd vdd) p12 w=1.5u l=0.13u
MN4133 (storage4124 count_rst vss vss) n12 w=2u l=0.13u
MN4138 (div_sync1_2 clk_low3155 storage4137 vss) n12 w=1.2u l=0.13u
MP4139 (div_sync1_2 clk_lowb3156 storage4137 vdd) p12 w=3.6u l=0.13u
MN4140 (qm4134 clk_high3157 storage4137 vss) n12 w=1.2u l=0.13u
MP4141 (qm4134 clk_highb3158 storage4137 vdd) p12 w=3.6u l=0.13u
MN4142 (qmb4135 storage4137 vss vss) n12 w=0.5u l=0.13u
MP4143 (qmb4135 storage4137 vdd vdd) p12 w=1.5u l=0.13u
MN4144 (qm4134 qmb4135 vss vss) n12 w=0.5u l=0.13u
MP4145 (qm4134 qmb4135 vdd vdd) p12 w=1.5u l=0.13u
MN4146 (storage4137 count_rst vss vss) n12 w=2u l=0.13u
MN4148 (qm4134 clk_high3157 storage4147 vss) n12 w=1.2u l=0.13u
MP4149 (qm4134 clk_highb3158 storage4147 vdd) p12 w=3.6u l=0.13u
MN4150 (div_sync2_2 clk_low3155 storage4147 vss) n12 w=1.2u l=0.13u
MP4151 (div_sync2_2 clk_lowb3156 storage4147 vdd) p12 w=3.6u l=0.13u
MN4152 (qb4136 storage4147 vss vss) n12 w=0.5u l=0.13u
MP4153 (qb4136 storage4147 vdd vdd) p12 w=1.5u l=0.13u
MN4154 (div_sync2_2 qb4136 vss vss) n12 w=0.5u l=0.13u
MP4155 (div_sync2_2 qb4136 vdd vdd) p12 w=1.5u l=0.13u
MN4156 (storage4147 count_rst vss vss) n12 w=2u l=0.13u
MN4161 (div_g3 clk_low3155 storage4160 vss) n12 w=1.2u l=0.13u
MP4162 (div_g3 clk_lowb3156 storage4160 vdd) p12 w=3.6u l=0.13u
MN4163 (qm4157 clk_high3157 storage4160 vss) n12 w=1.2u l=0.13u
MP4164 (qm4157 clk_highb3158 storage4160 vdd) p12 w=3.6u l=0.13u
MN4165 (qmb4158 storage4160 vss vss) n12 w=0.5u l=0.13u
MP4166 (qmb4158 storage4160 vdd vdd) p12 w=1.5u l=0.13u
MN4167 (qm4157 qmb4158 vss vss) n12 w=0.5u l=0.13u
MP4168 (qm4157 qmb4158 vdd vdd) p12 w=1.5u l=0.13u
MN4169 (storage4160 count_rst vss vss) n12 w=2u l=0.13u
MN4171 (qm4157 clk_high3157 storage4170 vss) n12 w=1.2u l=0.13u
MP4172 (qm4157 clk_highb3158 storage4170 vdd) p12 w=3.6u l=0.13u
MN4173 (div_sync1_3 clk_low3155 storage4170 vss) n12 w=1.2u l=0.13u
MP4174 (div_sync1_3 clk_lowb3156 storage4170 vdd) p12 w=3.6u l=0.13u
MN4175 (qb4159 storage4170 vss vss) n12 w=0.5u l=0.13u
MP4176 (qb4159 storage4170 vdd vdd) p12 w=1.5u l=0.13u
MN4177 (div_sync1_3 qb4159 vss vss) n12 w=0.5u l=0.13u
MP4178 (div_sync1_3 qb4159 vdd vdd) p12 w=1.5u l=0.13u
MN4179 (storage4170 count_rst vss vss) n12 w=2u l=0.13u
MN4184 (div_sync1_3 clk_low3155 storage4183 vss) n12 w=1.2u l=0.13u
MP4185 (div_sync1_3 clk_lowb3156 storage4183 vdd) p12 w=3.6u l=0.13u
MN4186 (qm4180 clk_high3157 storage4183 vss) n12 w=1.2u l=0.13u
MP4187 (qm4180 clk_highb3158 storage4183 vdd) p12 w=3.6u l=0.13u
MN4188 (qmb4181 storage4183 vss vss) n12 w=0.5u l=0.13u
MP4189 (qmb4181 storage4183 vdd vdd) p12 w=1.5u l=0.13u
MN4190 (qm4180 qmb4181 vss vss) n12 w=0.5u l=0.13u
MP4191 (qm4180 qmb4181 vdd vdd) p12 w=1.5u l=0.13u
MN4192 (storage4183 count_rst vss vss) n12 w=2u l=0.13u
MN4194 (qm4180 clk_high3157 storage4193 vss) n12 w=1.2u l=0.13u
MP4195 (qm4180 clk_highb3158 storage4193 vdd) p12 w=3.6u l=0.13u
MN4196 (div_sync2_3 clk_low3155 storage4193 vss) n12 w=1.2u l=0.13u
MP4197 (div_sync2_3 clk_lowb3156 storage4193 vdd) p12 w=3.6u l=0.13u
MN4198 (qb4182 storage4193 vss vss) n12 w=0.5u l=0.13u
MP4199 (qb4182 storage4193 vdd vdd) p12 w=1.5u l=0.13u
MN4200 (div_sync2_3 qb4182 vss vss) n12 w=0.5u l=0.13u
MP4201 (div_sync2_3 qb4182 vdd vdd) p12 w=1.5u l=0.13u
MN4202 (storage4193 count_rst vss vss) n12 w=2u l=0.13u
MN4207 (div_g4 clk_low3155 storage4206 vss) n12 w=1.2u l=0.13u
MP4208 (div_g4 clk_lowb3156 storage4206 vdd) p12 w=3.6u l=0.13u
MN4209 (qm4203 clk_high3157 storage4206 vss) n12 w=1.2u l=0.13u
MP4210 (qm4203 clk_highb3158 storage4206 vdd) p12 w=3.6u l=0.13u
MN4211 (qmb4204 storage4206 vss vss) n12 w=0.5u l=0.13u
MP4212 (qmb4204 storage4206 vdd vdd) p12 w=1.5u l=0.13u
MN4213 (qm4203 qmb4204 vss vss) n12 w=0.5u l=0.13u
MP4214 (qm4203 qmb4204 vdd vdd) p12 w=1.5u l=0.13u
MN4215 (storage4206 count_rst vss vss) n12 w=2u l=0.13u
MN4217 (qm4203 clk_high3157 storage4216 vss) n12 w=1.2u l=0.13u
MP4218 (qm4203 clk_highb3158 storage4216 vdd) p12 w=3.6u l=0.13u
MN4219 (div_sync1_4 clk_low3155 storage4216 vss) n12 w=1.2u l=0.13u
MP4220 (div_sync1_4 clk_lowb3156 storage4216 vdd) p12 w=3.6u l=0.13u
MN4221 (qb4205 storage4216 vss vss) n12 w=0.5u l=0.13u
MP4222 (qb4205 storage4216 vdd vdd) p12 w=1.5u l=0.13u
MN4223 (div_sync1_4 qb4205 vss vss) n12 w=0.5u l=0.13u
MP4224 (div_sync1_4 qb4205 vdd vdd) p12 w=1.5u l=0.13u
MN4225 (storage4216 count_rst vss vss) n12 w=2u l=0.13u
MN4230 (div_sync1_4 clk_low3155 storage4229 vss) n12 w=1.2u l=0.13u
MP4231 (div_sync1_4 clk_lowb3156 storage4229 vdd) p12 w=3.6u l=0.13u
MN4232 (qm4226 clk_high3157 storage4229 vss) n12 w=1.2u l=0.13u
MP4233 (qm4226 clk_highb3158 storage4229 vdd) p12 w=3.6u l=0.13u
MN4234 (qmb4227 storage4229 vss vss) n12 w=0.5u l=0.13u
MP4235 (qmb4227 storage4229 vdd vdd) p12 w=1.5u l=0.13u
MN4236 (qm4226 qmb4227 vss vss) n12 w=0.5u l=0.13u
MP4237 (qm4226 qmb4227 vdd vdd) p12 w=1.5u l=0.13u
MN4238 (storage4229 count_rst vss vss) n12 w=2u l=0.13u
MN4240 (qm4226 clk_high3157 storage4239 vss) n12 w=1.2u l=0.13u
MP4241 (qm4226 clk_highb3158 storage4239 vdd) p12 w=3.6u l=0.13u
MN4242 (div_sync2_4 clk_low3155 storage4239 vss) n12 w=1.2u l=0.13u
MP4243 (div_sync2_4 clk_lowb3156 storage4239 vdd) p12 w=3.6u l=0.13u
MN4244 (qb4228 storage4239 vss vss) n12 w=0.5u l=0.13u
MP4245 (qb4228 storage4239 vdd vdd) p12 w=1.5u l=0.13u
MN4246 (div_sync2_4 qb4228 vss vss) n12 w=0.5u l=0.13u
MP4247 (div_sync2_4 qb4228 vdd vdd) p12 w=1.5u l=0.13u
MN4248 (storage4239 count_rst vss vss) n12 w=2u l=0.13u
MN4253 (div_g5 clk_low3155 storage4252 vss) n12 w=1.2u l=0.13u
MP4254 (div_g5 clk_lowb3156 storage4252 vdd) p12 w=3.6u l=0.13u
MN4255 (qm4249 clk_high3157 storage4252 vss) n12 w=1.2u l=0.13u
MP4256 (qm4249 clk_highb3158 storage4252 vdd) p12 w=3.6u l=0.13u
MN4257 (qmb4250 storage4252 vss vss) n12 w=0.5u l=0.13u
MP4258 (qmb4250 storage4252 vdd vdd) p12 w=1.5u l=0.13u
MN4259 (qm4249 qmb4250 vss vss) n12 w=0.5u l=0.13u
MP4260 (qm4249 qmb4250 vdd vdd) p12 w=1.5u l=0.13u
MN4261 (storage4252 count_rst vss vss) n12 w=2u l=0.13u
MN4263 (qm4249 clk_high3157 storage4262 vss) n12 w=1.2u l=0.13u
MP4264 (qm4249 clk_highb3158 storage4262 vdd) p12 w=3.6u l=0.13u
MN4265 (div_sync1_5 clk_low3155 storage4262 vss) n12 w=1.2u l=0.13u
MP4266 (div_sync1_5 clk_lowb3156 storage4262 vdd) p12 w=3.6u l=0.13u
MN4267 (qb4251 storage4262 vss vss) n12 w=0.5u l=0.13u
MP4268 (qb4251 storage4262 vdd vdd) p12 w=1.5u l=0.13u
MN4269 (div_sync1_5 qb4251 vss vss) n12 w=0.5u l=0.13u
MP4270 (div_sync1_5 qb4251 vdd vdd) p12 w=1.5u l=0.13u
MN4271 (storage4262 count_rst vss vss) n12 w=2u l=0.13u
MN4276 (div_sync1_5 clk_low3155 storage4275 vss) n12 w=1.2u l=0.13u
MP4277 (div_sync1_5 clk_lowb3156 storage4275 vdd) p12 w=3.6u l=0.13u
MN4278 (qm4272 clk_high3157 storage4275 vss) n12 w=1.2u l=0.13u
MP4279 (qm4272 clk_highb3158 storage4275 vdd) p12 w=3.6u l=0.13u
MN4280 (qmb4273 storage4275 vss vss) n12 w=0.5u l=0.13u
MP4281 (qmb4273 storage4275 vdd vdd) p12 w=1.5u l=0.13u
MN4282 (qm4272 qmb4273 vss vss) n12 w=0.5u l=0.13u
MP4283 (qm4272 qmb4273 vdd vdd) p12 w=1.5u l=0.13u
MN4284 (storage4275 count_rst vss vss) n12 w=2u l=0.13u
MN4286 (qm4272 clk_high3157 storage4285 vss) n12 w=1.2u l=0.13u
MP4287 (qm4272 clk_highb3158 storage4285 vdd) p12 w=3.6u l=0.13u
MN4288 (div_sync2_5 clk_low3155 storage4285 vss) n12 w=1.2u l=0.13u
MP4289 (div_sync2_5 clk_lowb3156 storage4285 vdd) p12 w=3.6u l=0.13u
MN4290 (qb4274 storage4285 vss vss) n12 w=0.5u l=0.13u
MP4291 (qb4274 storage4285 vdd vdd) p12 w=1.5u l=0.13u
MN4292 (div_sync2_5 qb4274 vss vss) n12 w=0.5u l=0.13u
MP4293 (div_sync2_5 qb4274 vdd vdd) p12 w=1.5u l=0.13u
MN4294 (storage4285 count_rst vss vss) n12 w=2u l=0.13u
MN4299 (div_g6 clk_low3155 storage4298 vss) n12 w=1.2u l=0.13u
MP4300 (div_g6 clk_lowb3156 storage4298 vdd) p12 w=3.6u l=0.13u
MN4301 (qm4295 clk_high3157 storage4298 vss) n12 w=1.2u l=0.13u
MP4302 (qm4295 clk_highb3158 storage4298 vdd) p12 w=3.6u l=0.13u
MN4303 (qmb4296 storage4298 vss vss) n12 w=0.5u l=0.13u
MP4304 (qmb4296 storage4298 vdd vdd) p12 w=1.5u l=0.13u
MN4305 (qm4295 qmb4296 vss vss) n12 w=0.5u l=0.13u
MP4306 (qm4295 qmb4296 vdd vdd) p12 w=1.5u l=0.13u
MN4307 (storage4298 count_rst vss vss) n12 w=2u l=0.13u
MN4309 (qm4295 clk_high3157 storage4308 vss) n12 w=1.2u l=0.13u
MP4310 (qm4295 clk_highb3158 storage4308 vdd) p12 w=3.6u l=0.13u
MN4311 (div_sync1_6 clk_low3155 storage4308 vss) n12 w=1.2u l=0.13u
MP4312 (div_sync1_6 clk_lowb3156 storage4308 vdd) p12 w=3.6u l=0.13u
MN4313 (qb4297 storage4308 vss vss) n12 w=0.5u l=0.13u
MP4314 (qb4297 storage4308 vdd vdd) p12 w=1.5u l=0.13u
MN4315 (div_sync1_6 qb4297 vss vss) n12 w=0.5u l=0.13u
MP4316 (div_sync1_6 qb4297 vdd vdd) p12 w=1.5u l=0.13u
MN4317 (storage4308 count_rst vss vss) n12 w=2u l=0.13u
MN4322 (div_sync1_6 clk_low3155 storage4321 vss) n12 w=1.2u l=0.13u
MP4323 (div_sync1_6 clk_lowb3156 storage4321 vdd) p12 w=3.6u l=0.13u
MN4324 (qm4318 clk_high3157 storage4321 vss) n12 w=1.2u l=0.13u
MP4325 (qm4318 clk_highb3158 storage4321 vdd) p12 w=3.6u l=0.13u
MN4326 (qmb4319 storage4321 vss vss) n12 w=0.5u l=0.13u
MP4327 (qmb4319 storage4321 vdd vdd) p12 w=1.5u l=0.13u
MN4328 (qm4318 qmb4319 vss vss) n12 w=0.5u l=0.13u
MP4329 (qm4318 qmb4319 vdd vdd) p12 w=1.5u l=0.13u
MN4330 (storage4321 count_rst vss vss) n12 w=2u l=0.13u
MN4332 (qm4318 clk_high3157 storage4331 vss) n12 w=1.2u l=0.13u
MP4333 (qm4318 clk_highb3158 storage4331 vdd) p12 w=3.6u l=0.13u
MN4334 (div_sync2_6 clk_low3155 storage4331 vss) n12 w=1.2u l=0.13u
MP4335 (div_sync2_6 clk_lowb3156 storage4331 vdd) p12 w=3.6u l=0.13u
MN4336 (qb4320 storage4331 vss vss) n12 w=0.5u l=0.13u
MP4337 (qb4320 storage4331 vdd vdd) p12 w=1.5u l=0.13u
MN4338 (div_sync2_6 qb4320 vss vss) n12 w=0.5u l=0.13u
MP4339 (div_sync2_6 qb4320 vdd vdd) p12 w=1.5u l=0.13u
MN4340 (storage4331 count_rst vss vss) n12 w=2u l=0.13u
MN4345 (div_g7 clk_low3155 storage4344 vss) n12 w=1.2u l=0.13u
MP4346 (div_g7 clk_lowb3156 storage4344 vdd) p12 w=3.6u l=0.13u
MN4347 (qm4341 clk_high3157 storage4344 vss) n12 w=1.2u l=0.13u
MP4348 (qm4341 clk_highb3158 storage4344 vdd) p12 w=3.6u l=0.13u
MN4349 (qmb4342 storage4344 vss vss) n12 w=0.5u l=0.13u
MP4350 (qmb4342 storage4344 vdd vdd) p12 w=1.5u l=0.13u
MN4351 (qm4341 qmb4342 vss vss) n12 w=0.5u l=0.13u
MP4352 (qm4341 qmb4342 vdd vdd) p12 w=1.5u l=0.13u
MN4353 (storage4344 count_rst vss vss) n12 w=2u l=0.13u
MN4355 (qm4341 clk_high3157 storage4354 vss) n12 w=1.2u l=0.13u
MP4356 (qm4341 clk_highb3158 storage4354 vdd) p12 w=3.6u l=0.13u
MN4357 (div_sync1_7 clk_low3155 storage4354 vss) n12 w=1.2u l=0.13u
MP4358 (div_sync1_7 clk_lowb3156 storage4354 vdd) p12 w=3.6u l=0.13u
MN4359 (qb4343 storage4354 vss vss) n12 w=0.5u l=0.13u
MP4360 (qb4343 storage4354 vdd vdd) p12 w=1.5u l=0.13u
MN4361 (div_sync1_7 qb4343 vss vss) n12 w=0.5u l=0.13u
MP4362 (div_sync1_7 qb4343 vdd vdd) p12 w=1.5u l=0.13u
MN4363 (storage4354 count_rst vss vss) n12 w=2u l=0.13u
MN4368 (div_sync1_7 clk_low3155 storage4367 vss) n12 w=1.2u l=0.13u
MP4369 (div_sync1_7 clk_lowb3156 storage4367 vdd) p12 w=3.6u l=0.13u
MN4370 (qm4364 clk_high3157 storage4367 vss) n12 w=1.2u l=0.13u
MP4371 (qm4364 clk_highb3158 storage4367 vdd) p12 w=3.6u l=0.13u
MN4372 (qmb4365 storage4367 vss vss) n12 w=0.5u l=0.13u
MP4373 (qmb4365 storage4367 vdd vdd) p12 w=1.5u l=0.13u
MN4374 (qm4364 qmb4365 vss vss) n12 w=0.5u l=0.13u
MP4375 (qm4364 qmb4365 vdd vdd) p12 w=1.5u l=0.13u
MN4376 (storage4367 count_rst vss vss) n12 w=2u l=0.13u
MN4378 (qm4364 clk_high3157 storage4377 vss) n12 w=1.2u l=0.13u
MP4379 (qm4364 clk_highb3158 storage4377 vdd) p12 w=3.6u l=0.13u
MN4380 (div_sync2_7 clk_low3155 storage4377 vss) n12 w=1.2u l=0.13u
MP4381 (div_sync2_7 clk_lowb3156 storage4377 vdd) p12 w=3.6u l=0.13u
MN4382 (qb4366 storage4377 vss vss) n12 w=0.5u l=0.13u
MP4383 (qb4366 storage4377 vdd vdd) p12 w=1.5u l=0.13u
MN4384 (div_sync2_7 qb4366 vss vss) n12 w=0.5u l=0.13u
MP4385 (div_sync2_7 qb4366 vdd vdd) p12 w=1.5u l=0.13u
MN4386 (storage4377 count_rst vss vss) n12 w=2u l=0.13u
MN4391 (div_g8 clk_low3155 storage4390 vss) n12 w=1.2u l=0.13u
MP4392 (div_g8 clk_lowb3156 storage4390 vdd) p12 w=3.6u l=0.13u
MN4393 (qm4387 clk_high3157 storage4390 vss) n12 w=1.2u l=0.13u
MP4394 (qm4387 clk_highb3158 storage4390 vdd) p12 w=3.6u l=0.13u
MN4395 (qmb4388 storage4390 vss vss) n12 w=0.5u l=0.13u
MP4396 (qmb4388 storage4390 vdd vdd) p12 w=1.5u l=0.13u
MN4397 (qm4387 qmb4388 vss vss) n12 w=0.5u l=0.13u
MP4398 (qm4387 qmb4388 vdd vdd) p12 w=1.5u l=0.13u
MN4399 (storage4390 count_rst vss vss) n12 w=2u l=0.13u
MN4401 (qm4387 clk_high3157 storage4400 vss) n12 w=1.2u l=0.13u
MP4402 (qm4387 clk_highb3158 storage4400 vdd) p12 w=3.6u l=0.13u
MN4403 (div_sync1_8 clk_low3155 storage4400 vss) n12 w=1.2u l=0.13u
MP4404 (div_sync1_8 clk_lowb3156 storage4400 vdd) p12 w=3.6u l=0.13u
MN4405 (qb4389 storage4400 vss vss) n12 w=0.5u l=0.13u
MP4406 (qb4389 storage4400 vdd vdd) p12 w=1.5u l=0.13u
MN4407 (div_sync1_8 qb4389 vss vss) n12 w=0.5u l=0.13u
MP4408 (div_sync1_8 qb4389 vdd vdd) p12 w=1.5u l=0.13u
MN4409 (storage4400 count_rst vss vss) n12 w=2u l=0.13u
MN4414 (div_sync1_8 clk_low3155 storage4413 vss) n12 w=1.2u l=0.13u
MP4415 (div_sync1_8 clk_lowb3156 storage4413 vdd) p12 w=3.6u l=0.13u
MN4416 (qm4410 clk_high3157 storage4413 vss) n12 w=1.2u l=0.13u
MP4417 (qm4410 clk_highb3158 storage4413 vdd) p12 w=3.6u l=0.13u
MN4418 (qmb4411 storage4413 vss vss) n12 w=0.5u l=0.13u
MP4419 (qmb4411 storage4413 vdd vdd) p12 w=1.5u l=0.13u
MN4420 (qm4410 qmb4411 vss vss) n12 w=0.5u l=0.13u
MP4421 (qm4410 qmb4411 vdd vdd) p12 w=1.5u l=0.13u
MN4422 (storage4413 count_rst vss vss) n12 w=2u l=0.13u
MN4424 (qm4410 clk_high3157 storage4423 vss) n12 w=1.2u l=0.13u
MP4425 (qm4410 clk_highb3158 storage4423 vdd) p12 w=3.6u l=0.13u
MN4426 (div_sync2_8 clk_low3155 storage4423 vss) n12 w=1.2u l=0.13u
MP4427 (div_sync2_8 clk_lowb3156 storage4423 vdd) p12 w=3.6u l=0.13u
MN4428 (qb4412 storage4423 vss vss) n12 w=0.5u l=0.13u
MP4429 (qb4412 storage4423 vdd vdd) p12 w=1.5u l=0.13u
MN4430 (div_sync2_8 qb4412 vss vss) n12 w=0.5u l=0.13u
MP4431 (div_sync2_8 qb4412 vdd vdd) p12 w=1.5u l=0.13u
MN4432 (storage4423 count_rst vss vss) n12 w=2u l=0.13u
MN4435 (n4433 lead_sync2_7 n4434 vss) n12 w=1.6u l=0.13u
MN4436 (n4434 lead_sync2_8 vss vss) n12 w=1.6u l=0.13u
MP4437 (n4433 lead_sync2_7 vdd vdd) p12 w=2.4u l=0.13u
MP4438 (n4433 lead_sync2_8 vdd vdd) p12 w=2.4u l=0.13u
MN4441 (n4439 lead_sync2_7 n4440 vss) n12 w=1.6u l=0.13u
MN4442 (n4440 n4433 vss vss) n12 w=1.6u l=0.13u
MP4443 (n4439 lead_sync2_7 vdd vdd) p12 w=2.4u l=0.13u
MP4444 (n4439 n4433 vdd vdd) p12 w=2.4u l=0.13u
MN4447 (n4445 lead_sync2_8 n4446 vss) n12 w=1.6u l=0.13u
MN4448 (n4446 n4433 vss vss) n12 w=1.6u l=0.13u
MP4449 (n4445 lead_sync2_8 vdd vdd) p12 w=2.4u l=0.13u
MP4450 (n4445 n4433 vdd vdd) p12 w=2.4u l=0.13u
MN4453 (n4451 n4439 n4452 vss) n12 w=1.6u l=0.13u
MN4454 (n4452 n4445 vss vss) n12 w=1.6u l=0.13u
MP4455 (n4451 n4439 vdd vdd) p12 w=2.4u l=0.13u
MP4456 (n4451 n4445 vdd vdd) p12 w=2.4u l=0.13u
MN4459 (n4457 lead_sync2_6 n4458 vss) n12 w=1.6u l=0.13u
MN4460 (n4458 n4451 vss vss) n12 w=1.6u l=0.13u
MP4461 (n4457 lead_sync2_6 vdd vdd) p12 w=2.4u l=0.13u
MP4462 (n4457 n4451 vdd vdd) p12 w=2.4u l=0.13u
MN4465 (n4463 lead_sync2_6 n4464 vss) n12 w=1.6u l=0.13u
MN4466 (n4464 n4457 vss vss) n12 w=1.6u l=0.13u
MP4467 (n4463 lead_sync2_6 vdd vdd) p12 w=2.4u l=0.13u
MP4468 (n4463 n4457 vdd vdd) p12 w=2.4u l=0.13u
MN4471 (n4469 n4451 n4470 vss) n12 w=1.6u l=0.13u
MN4472 (n4470 n4457 vss vss) n12 w=1.6u l=0.13u
MP4473 (n4469 n4451 vdd vdd) p12 w=2.4u l=0.13u
MP4474 (n4469 n4457 vdd vdd) p12 w=2.4u l=0.13u
MN4477 (n4475 n4463 n4476 vss) n12 w=1.6u l=0.13u
MN4478 (n4476 n4469 vss vss) n12 w=1.6u l=0.13u
MP4479 (n4475 n4463 vdd vdd) p12 w=2.4u l=0.13u
MP4480 (n4475 n4469 vdd vdd) p12 w=2.4u l=0.13u
MN4483 (n4481 lead_sync2_5 n4482 vss) n12 w=1.6u l=0.13u
MN4484 (n4482 n4475 vss vss) n12 w=1.6u l=0.13u
MP4485 (n4481 lead_sync2_5 vdd vdd) p12 w=2.4u l=0.13u
MP4486 (n4481 n4475 vdd vdd) p12 w=2.4u l=0.13u
MN4489 (n4487 lead_sync2_5 n4488 vss) n12 w=1.6u l=0.13u
MN4490 (n4488 n4481 vss vss) n12 w=1.6u l=0.13u
MP4491 (n4487 lead_sync2_5 vdd vdd) p12 w=2.4u l=0.13u
MP4492 (n4487 n4481 vdd vdd) p12 w=2.4u l=0.13u
MN4495 (n4493 n4475 n4494 vss) n12 w=1.6u l=0.13u
MN4496 (n4494 n4481 vss vss) n12 w=1.6u l=0.13u
MP4497 (n4493 n4475 vdd vdd) p12 w=2.4u l=0.13u
MP4498 (n4493 n4481 vdd vdd) p12 w=2.4u l=0.13u
MN4501 (n4499 n4487 n4500 vss) n12 w=1.6u l=0.13u
MN4502 (n4500 n4493 vss vss) n12 w=1.6u l=0.13u
MP4503 (n4499 n4487 vdd vdd) p12 w=2.4u l=0.13u
MP4504 (n4499 n4493 vdd vdd) p12 w=2.4u l=0.13u
MN4507 (n4505 lead_sync2_4 n4506 vss) n12 w=1.6u l=0.13u
MN4508 (n4506 n4499 vss vss) n12 w=1.6u l=0.13u
MP4509 (n4505 lead_sync2_4 vdd vdd) p12 w=2.4u l=0.13u
MP4510 (n4505 n4499 vdd vdd) p12 w=2.4u l=0.13u
MN4513 (n4511 lead_sync2_4 n4512 vss) n12 w=1.6u l=0.13u
MN4514 (n4512 n4505 vss vss) n12 w=1.6u l=0.13u
MP4515 (n4511 lead_sync2_4 vdd vdd) p12 w=2.4u l=0.13u
MP4516 (n4511 n4505 vdd vdd) p12 w=2.4u l=0.13u
MN4519 (n4517 n4499 n4518 vss) n12 w=1.6u l=0.13u
MN4520 (n4518 n4505 vss vss) n12 w=1.6u l=0.13u
MP4521 (n4517 n4499 vdd vdd) p12 w=2.4u l=0.13u
MP4522 (n4517 n4505 vdd vdd) p12 w=2.4u l=0.13u
MN4525 (n4523 n4511 n4524 vss) n12 w=1.6u l=0.13u
MN4526 (n4524 n4517 vss vss) n12 w=1.6u l=0.13u
MP4527 (n4523 n4511 vdd vdd) p12 w=2.4u l=0.13u
MP4528 (n4523 n4517 vdd vdd) p12 w=2.4u l=0.13u
MN4531 (n4529 lead_sync2_3 n4530 vss) n12 w=1.6u l=0.13u
MN4532 (n4530 n4523 vss vss) n12 w=1.6u l=0.13u
MP4533 (n4529 lead_sync2_3 vdd vdd) p12 w=2.4u l=0.13u
MP4534 (n4529 n4523 vdd vdd) p12 w=2.4u l=0.13u
MN4537 (n4535 lead_sync2_3 n4536 vss) n12 w=1.6u l=0.13u
MN4538 (n4536 n4529 vss vss) n12 w=1.6u l=0.13u
MP4539 (n4535 lead_sync2_3 vdd vdd) p12 w=2.4u l=0.13u
MP4540 (n4535 n4529 vdd vdd) p12 w=2.4u l=0.13u
MN4543 (n4541 n4523 n4542 vss) n12 w=1.6u l=0.13u
MN4544 (n4542 n4529 vss vss) n12 w=1.6u l=0.13u
MP4545 (n4541 n4523 vdd vdd) p12 w=2.4u l=0.13u
MP4546 (n4541 n4529 vdd vdd) p12 w=2.4u l=0.13u
MN4549 (n4547 n4535 n4548 vss) n12 w=1.6u l=0.13u
MN4550 (n4548 n4541 vss vss) n12 w=1.6u l=0.13u
MP4551 (n4547 n4535 vdd vdd) p12 w=2.4u l=0.13u
MP4552 (n4547 n4541 vdd vdd) p12 w=2.4u l=0.13u
MN4555 (n4553 lead_sync2_2 n4554 vss) n12 w=1.6u l=0.13u
MN4556 (n4554 n4547 vss vss) n12 w=1.6u l=0.13u
MP4557 (n4553 lead_sync2_2 vdd vdd) p12 w=2.4u l=0.13u
MP4558 (n4553 n4547 vdd vdd) p12 w=2.4u l=0.13u
MN4561 (n4559 lead_sync2_2 n4560 vss) n12 w=1.6u l=0.13u
MN4562 (n4560 n4553 vss vss) n12 w=1.6u l=0.13u
MP4563 (n4559 lead_sync2_2 vdd vdd) p12 w=2.4u l=0.13u
MP4564 (n4559 n4553 vdd vdd) p12 w=2.4u l=0.13u
MN4567 (n4565 n4547 n4566 vss) n12 w=1.6u l=0.13u
MN4568 (n4566 n4553 vss vss) n12 w=1.6u l=0.13u
MP4569 (n4565 n4547 vdd vdd) p12 w=2.4u l=0.13u
MP4570 (n4565 n4553 vdd vdd) p12 w=2.4u l=0.13u
MN4573 (n4571 n4559 n4572 vss) n12 w=1.6u l=0.13u
MN4574 (n4572 n4565 vss vss) n12 w=1.6u l=0.13u
MP4575 (n4571 n4559 vdd vdd) p12 w=2.4u l=0.13u
MP4576 (n4571 n4565 vdd vdd) p12 w=2.4u l=0.13u
MN4579 (n4577 lead_sync2_1 n4578 vss) n12 w=1.6u l=0.13u
MN4580 (n4578 n4571 vss vss) n12 w=1.6u l=0.13u
MP4581 (n4577 lead_sync2_1 vdd vdd) p12 w=2.4u l=0.13u
MP4582 (n4577 n4571 vdd vdd) p12 w=2.4u l=0.13u
MN4585 (n4583 lead_sync2_1 n4584 vss) n12 w=1.6u l=0.13u
MN4586 (n4584 n4577 vss vss) n12 w=1.6u l=0.13u
MP4587 (n4583 lead_sync2_1 vdd vdd) p12 w=2.4u l=0.13u
MP4588 (n4583 n4577 vdd vdd) p12 w=2.4u l=0.13u
MN4591 (n4589 n4571 n4590 vss) n12 w=1.6u l=0.13u
MN4592 (n4590 n4577 vss vss) n12 w=1.6u l=0.13u
MP4593 (n4589 n4571 vdd vdd) p12 w=2.4u l=0.13u
MP4594 (n4589 n4577 vdd vdd) p12 w=2.4u l=0.13u
MN4597 (n4595 n4583 n4596 vss) n12 w=1.6u l=0.13u
MN4598 (n4596 n4589 vss vss) n12 w=1.6u l=0.13u
MP4599 (n4595 n4583 vdd vdd) p12 w=2.4u l=0.13u
MP4600 (n4595 n4589 vdd vdd) p12 w=2.4u l=0.13u
MN4603 (n4601 lead_sync2_0 n4602 vss) n12 w=1.6u l=0.13u
MN4604 (n4602 n4595 vss vss) n12 w=1.6u l=0.13u
MP4605 (n4601 lead_sync2_0 vdd vdd) p12 w=2.4u l=0.13u
MP4606 (n4601 n4595 vdd vdd) p12 w=2.4u l=0.13u
MN4609 (n4607 lead_sync2_0 n4608 vss) n12 w=1.6u l=0.13u
MN4610 (n4608 n4601 vss vss) n12 w=1.6u l=0.13u
MP4611 (n4607 lead_sync2_0 vdd vdd) p12 w=2.4u l=0.13u
MP4612 (n4607 n4601 vdd vdd) p12 w=2.4u l=0.13u
MN4615 (n4613 n4595 n4614 vss) n12 w=1.6u l=0.13u
MN4616 (n4614 n4601 vss vss) n12 w=1.6u l=0.13u
MP4617 (n4613 n4595 vdd vdd) p12 w=2.4u l=0.13u
MP4618 (n4613 n4601 vdd vdd) p12 w=2.4u l=0.13u
MN4621 (n4619 n4607 n4620 vss) n12 w=1.6u l=0.13u
MN4622 (n4620 n4613 vss vss) n12 w=1.6u l=0.13u
MP4623 (n4619 n4607 vdd vdd) p12 w=2.4u l=0.13u
MP4624 (n4619 n4613 vdd vdd) p12 w=2.4u l=0.13u
MN4626 (n4625 n4619 vss vss) n12 w=0.8u l=0.13u
MP4627 (n4625 n4619 vdd vdd) p12 w=2.4u l=0.13u
MN4629 (n4628 n4625 vss vss) n12 w=0.8u l=0.13u
MP4630 (n4628 n4625 vdd vdd) p12 w=2.4u l=0.13u
MN4632 (n4631 n4628 vss vss) n12 w=0.8u l=0.13u
MP4633 (n4631 n4628 vdd vdd) p12 w=2.4u l=0.13u
MN4634 (cl0 n4631 vss vss) n12 w=0.8u l=0.13u
MP4635 (cl0 n4631 vdd vdd) p12 w=2.4u l=0.13u
MN4637 (n4636 n4595 vss vss) n12 w=0.8u l=0.13u
MP4638 (n4636 n4595 vdd vdd) p12 w=2.4u l=0.13u
MN4640 (n4639 n4636 vss vss) n12 w=0.8u l=0.13u
MP4641 (n4639 n4636 vdd vdd) p12 w=2.4u l=0.13u
MN4643 (n4642 n4639 vss vss) n12 w=0.8u l=0.13u
MP4644 (n4642 n4639 vdd vdd) p12 w=2.4u l=0.13u
MN4645 (cl1 n4642 vss vss) n12 w=0.8u l=0.13u
MP4646 (cl1 n4642 vdd vdd) p12 w=2.4u l=0.13u
MN4648 (n4647 n4571 vss vss) n12 w=0.8u l=0.13u
MP4649 (n4647 n4571 vdd vdd) p12 w=2.4u l=0.13u
MN4651 (n4650 n4647 vss vss) n12 w=0.8u l=0.13u
MP4652 (n4650 n4647 vdd vdd) p12 w=2.4u l=0.13u
MN4654 (n4653 n4650 vss vss) n12 w=0.8u l=0.13u
MP4655 (n4653 n4650 vdd vdd) p12 w=2.4u l=0.13u
MN4656 (cl2 n4653 vss vss) n12 w=0.8u l=0.13u
MP4657 (cl2 n4653 vdd vdd) p12 w=2.4u l=0.13u
MN4659 (n4658 n4547 vss vss) n12 w=0.8u l=0.13u
MP4660 (n4658 n4547 vdd vdd) p12 w=2.4u l=0.13u
MN4662 (n4661 n4658 vss vss) n12 w=0.8u l=0.13u
MP4663 (n4661 n4658 vdd vdd) p12 w=2.4u l=0.13u
MN4665 (n4664 n4661 vss vss) n12 w=0.8u l=0.13u
MP4666 (n4664 n4661 vdd vdd) p12 w=2.4u l=0.13u
MN4667 (cl3 n4664 vss vss) n12 w=0.8u l=0.13u
MP4668 (cl3 n4664 vdd vdd) p12 w=2.4u l=0.13u
MN4670 (n4669 n4523 vss vss) n12 w=0.8u l=0.13u
MP4671 (n4669 n4523 vdd vdd) p12 w=2.4u l=0.13u
MN4673 (n4672 n4669 vss vss) n12 w=0.8u l=0.13u
MP4674 (n4672 n4669 vdd vdd) p12 w=2.4u l=0.13u
MN4676 (n4675 n4672 vss vss) n12 w=0.8u l=0.13u
MP4677 (n4675 n4672 vdd vdd) p12 w=2.4u l=0.13u
MN4678 (cl4 n4675 vss vss) n12 w=0.8u l=0.13u
MP4679 (cl4 n4675 vdd vdd) p12 w=2.4u l=0.13u
MN4681 (n4680 n4499 vss vss) n12 w=0.8u l=0.13u
MP4682 (n4680 n4499 vdd vdd) p12 w=2.4u l=0.13u
MN4684 (n4683 n4680 vss vss) n12 w=0.8u l=0.13u
MP4685 (n4683 n4680 vdd vdd) p12 w=2.4u l=0.13u
MN4687 (n4686 n4683 vss vss) n12 w=0.8u l=0.13u
MP4688 (n4686 n4683 vdd vdd) p12 w=2.4u l=0.13u
MN4689 (cl5 n4686 vss vss) n12 w=0.8u l=0.13u
MP4690 (cl5 n4686 vdd vdd) p12 w=2.4u l=0.13u
MN4692 (n4691 n4475 vss vss) n12 w=0.8u l=0.13u
MP4693 (n4691 n4475 vdd vdd) p12 w=2.4u l=0.13u
MN4695 (n4694 n4691 vss vss) n12 w=0.8u l=0.13u
MP4696 (n4694 n4691 vdd vdd) p12 w=2.4u l=0.13u
MN4698 (n4697 n4694 vss vss) n12 w=0.8u l=0.13u
MP4699 (n4697 n4694 vdd vdd) p12 w=2.4u l=0.13u
MN4700 (cl6 n4697 vss vss) n12 w=0.8u l=0.13u
MP4701 (cl6 n4697 vdd vdd) p12 w=2.4u l=0.13u
MN4703 (n4702 n4451 vss vss) n12 w=0.8u l=0.13u
MP4704 (n4702 n4451 vdd vdd) p12 w=2.4u l=0.13u
MN4706 (n4705 n4702 vss vss) n12 w=0.8u l=0.13u
MP4707 (n4705 n4702 vdd vdd) p12 w=2.4u l=0.13u
MN4709 (n4708 n4705 vss vss) n12 w=0.8u l=0.13u
MP4710 (n4708 n4705 vdd vdd) p12 w=2.4u l=0.13u
MN4711 (cl7 n4708 vss vss) n12 w=0.8u l=0.13u
MP4712 (cl7 n4708 vdd vdd) p12 w=2.4u l=0.13u
MN4714 (n4713 lead_sync2_8 vss vss) n12 w=0.8u l=0.13u
MP4715 (n4713 lead_sync2_8 vdd vdd) p12 w=2.4u l=0.13u
MN4717 (n4716 n4713 vss vss) n12 w=0.8u l=0.13u
MP4718 (n4716 n4713 vdd vdd) p12 w=2.4u l=0.13u
MN4720 (n4719 n4716 vss vss) n12 w=0.8u l=0.13u
MP4721 (n4719 n4716 vdd vdd) p12 w=2.4u l=0.13u
MN4722 (cl8 n4719 vss vss) n12 w=0.8u l=0.13u
MP4723 (cl8 n4719 vdd vdd) p12 w=2.4u l=0.13u
MN4726 (n4724 lag_sync2_7 n4725 vss) n12 w=1.6u l=0.13u
MN4727 (n4725 lag_sync2_8 vss vss) n12 w=1.6u l=0.13u
MP4728 (n4724 lag_sync2_7 vdd vdd) p12 w=2.4u l=0.13u
MP4729 (n4724 lag_sync2_8 vdd vdd) p12 w=2.4u l=0.13u
MN4732 (n4730 lag_sync2_7 n4731 vss) n12 w=1.6u l=0.13u
MN4733 (n4731 n4724 vss vss) n12 w=1.6u l=0.13u
MP4734 (n4730 lag_sync2_7 vdd vdd) p12 w=2.4u l=0.13u
MP4735 (n4730 n4724 vdd vdd) p12 w=2.4u l=0.13u
MN4738 (n4736 lag_sync2_8 n4737 vss) n12 w=1.6u l=0.13u
MN4739 (n4737 n4724 vss vss) n12 w=1.6u l=0.13u
MP4740 (n4736 lag_sync2_8 vdd vdd) p12 w=2.4u l=0.13u
MP4741 (n4736 n4724 vdd vdd) p12 w=2.4u l=0.13u
MN4744 (n4742 n4730 n4743 vss) n12 w=1.6u l=0.13u
MN4745 (n4743 n4736 vss vss) n12 w=1.6u l=0.13u
MP4746 (n4742 n4730 vdd vdd) p12 w=2.4u l=0.13u
MP4747 (n4742 n4736 vdd vdd) p12 w=2.4u l=0.13u
MN4750 (n4748 lag_sync2_6 n4749 vss) n12 w=1.6u l=0.13u
MN4751 (n4749 n4742 vss vss) n12 w=1.6u l=0.13u
MP4752 (n4748 lag_sync2_6 vdd vdd) p12 w=2.4u l=0.13u
MP4753 (n4748 n4742 vdd vdd) p12 w=2.4u l=0.13u
MN4756 (n4754 lag_sync2_6 n4755 vss) n12 w=1.6u l=0.13u
MN4757 (n4755 n4748 vss vss) n12 w=1.6u l=0.13u
MP4758 (n4754 lag_sync2_6 vdd vdd) p12 w=2.4u l=0.13u
MP4759 (n4754 n4748 vdd vdd) p12 w=2.4u l=0.13u
MN4762 (n4760 n4742 n4761 vss) n12 w=1.6u l=0.13u
MN4763 (n4761 n4748 vss vss) n12 w=1.6u l=0.13u
MP4764 (n4760 n4742 vdd vdd) p12 w=2.4u l=0.13u
MP4765 (n4760 n4748 vdd vdd) p12 w=2.4u l=0.13u
MN4768 (n4766 n4754 n4767 vss) n12 w=1.6u l=0.13u
MN4769 (n4767 n4760 vss vss) n12 w=1.6u l=0.13u
MP4770 (n4766 n4754 vdd vdd) p12 w=2.4u l=0.13u
MP4771 (n4766 n4760 vdd vdd) p12 w=2.4u l=0.13u
MN4774 (n4772 lag_sync2_5 n4773 vss) n12 w=1.6u l=0.13u
MN4775 (n4773 n4766 vss vss) n12 w=1.6u l=0.13u
MP4776 (n4772 lag_sync2_5 vdd vdd) p12 w=2.4u l=0.13u
MP4777 (n4772 n4766 vdd vdd) p12 w=2.4u l=0.13u
MN4780 (n4778 lag_sync2_5 n4779 vss) n12 w=1.6u l=0.13u
MN4781 (n4779 n4772 vss vss) n12 w=1.6u l=0.13u
MP4782 (n4778 lag_sync2_5 vdd vdd) p12 w=2.4u l=0.13u
MP4783 (n4778 n4772 vdd vdd) p12 w=2.4u l=0.13u
MN4786 (n4784 n4766 n4785 vss) n12 w=1.6u l=0.13u
MN4787 (n4785 n4772 vss vss) n12 w=1.6u l=0.13u
MP4788 (n4784 n4766 vdd vdd) p12 w=2.4u l=0.13u
MP4789 (n4784 n4772 vdd vdd) p12 w=2.4u l=0.13u
MN4792 (n4790 n4778 n4791 vss) n12 w=1.6u l=0.13u
MN4793 (n4791 n4784 vss vss) n12 w=1.6u l=0.13u
MP4794 (n4790 n4778 vdd vdd) p12 w=2.4u l=0.13u
MP4795 (n4790 n4784 vdd vdd) p12 w=2.4u l=0.13u
MN4798 (n4796 lag_sync2_4 n4797 vss) n12 w=1.6u l=0.13u
MN4799 (n4797 n4790 vss vss) n12 w=1.6u l=0.13u
MP4800 (n4796 lag_sync2_4 vdd vdd) p12 w=2.4u l=0.13u
MP4801 (n4796 n4790 vdd vdd) p12 w=2.4u l=0.13u
MN4804 (n4802 lag_sync2_4 n4803 vss) n12 w=1.6u l=0.13u
MN4805 (n4803 n4796 vss vss) n12 w=1.6u l=0.13u
MP4806 (n4802 lag_sync2_4 vdd vdd) p12 w=2.4u l=0.13u
MP4807 (n4802 n4796 vdd vdd) p12 w=2.4u l=0.13u
MN4810 (n4808 n4790 n4809 vss) n12 w=1.6u l=0.13u
MN4811 (n4809 n4796 vss vss) n12 w=1.6u l=0.13u
MP4812 (n4808 n4790 vdd vdd) p12 w=2.4u l=0.13u
MP4813 (n4808 n4796 vdd vdd) p12 w=2.4u l=0.13u
MN4816 (n4814 n4802 n4815 vss) n12 w=1.6u l=0.13u
MN4817 (n4815 n4808 vss vss) n12 w=1.6u l=0.13u
MP4818 (n4814 n4802 vdd vdd) p12 w=2.4u l=0.13u
MP4819 (n4814 n4808 vdd vdd) p12 w=2.4u l=0.13u
MN4822 (n4820 lag_sync2_3 n4821 vss) n12 w=1.6u l=0.13u
MN4823 (n4821 n4814 vss vss) n12 w=1.6u l=0.13u
MP4824 (n4820 lag_sync2_3 vdd vdd) p12 w=2.4u l=0.13u
MP4825 (n4820 n4814 vdd vdd) p12 w=2.4u l=0.13u
MN4828 (n4826 lag_sync2_3 n4827 vss) n12 w=1.6u l=0.13u
MN4829 (n4827 n4820 vss vss) n12 w=1.6u l=0.13u
MP4830 (n4826 lag_sync2_3 vdd vdd) p12 w=2.4u l=0.13u
MP4831 (n4826 n4820 vdd vdd) p12 w=2.4u l=0.13u
MN4834 (n4832 n4814 n4833 vss) n12 w=1.6u l=0.13u
MN4835 (n4833 n4820 vss vss) n12 w=1.6u l=0.13u
MP4836 (n4832 n4814 vdd vdd) p12 w=2.4u l=0.13u
MP4837 (n4832 n4820 vdd vdd) p12 w=2.4u l=0.13u
MN4840 (n4838 n4826 n4839 vss) n12 w=1.6u l=0.13u
MN4841 (n4839 n4832 vss vss) n12 w=1.6u l=0.13u
MP4842 (n4838 n4826 vdd vdd) p12 w=2.4u l=0.13u
MP4843 (n4838 n4832 vdd vdd) p12 w=2.4u l=0.13u
MN4846 (n4844 lag_sync2_2 n4845 vss) n12 w=1.6u l=0.13u
MN4847 (n4845 n4838 vss vss) n12 w=1.6u l=0.13u
MP4848 (n4844 lag_sync2_2 vdd vdd) p12 w=2.4u l=0.13u
MP4849 (n4844 n4838 vdd vdd) p12 w=2.4u l=0.13u
MN4852 (n4850 lag_sync2_2 n4851 vss) n12 w=1.6u l=0.13u
MN4853 (n4851 n4844 vss vss) n12 w=1.6u l=0.13u
MP4854 (n4850 lag_sync2_2 vdd vdd) p12 w=2.4u l=0.13u
MP4855 (n4850 n4844 vdd vdd) p12 w=2.4u l=0.13u
MN4858 (n4856 n4838 n4857 vss) n12 w=1.6u l=0.13u
MN4859 (n4857 n4844 vss vss) n12 w=1.6u l=0.13u
MP4860 (n4856 n4838 vdd vdd) p12 w=2.4u l=0.13u
MP4861 (n4856 n4844 vdd vdd) p12 w=2.4u l=0.13u
MN4864 (n4862 n4850 n4863 vss) n12 w=1.6u l=0.13u
MN4865 (n4863 n4856 vss vss) n12 w=1.6u l=0.13u
MP4866 (n4862 n4850 vdd vdd) p12 w=2.4u l=0.13u
MP4867 (n4862 n4856 vdd vdd) p12 w=2.4u l=0.13u
MN4870 (n4868 lag_sync2_1 n4869 vss) n12 w=1.6u l=0.13u
MN4871 (n4869 n4862 vss vss) n12 w=1.6u l=0.13u
MP4872 (n4868 lag_sync2_1 vdd vdd) p12 w=2.4u l=0.13u
MP4873 (n4868 n4862 vdd vdd) p12 w=2.4u l=0.13u
MN4876 (n4874 lag_sync2_1 n4875 vss) n12 w=1.6u l=0.13u
MN4877 (n4875 n4868 vss vss) n12 w=1.6u l=0.13u
MP4878 (n4874 lag_sync2_1 vdd vdd) p12 w=2.4u l=0.13u
MP4879 (n4874 n4868 vdd vdd) p12 w=2.4u l=0.13u
MN4882 (n4880 n4862 n4881 vss) n12 w=1.6u l=0.13u
MN4883 (n4881 n4868 vss vss) n12 w=1.6u l=0.13u
MP4884 (n4880 n4862 vdd vdd) p12 w=2.4u l=0.13u
MP4885 (n4880 n4868 vdd vdd) p12 w=2.4u l=0.13u
MN4888 (n4886 n4874 n4887 vss) n12 w=1.6u l=0.13u
MN4889 (n4887 n4880 vss vss) n12 w=1.6u l=0.13u
MP4890 (n4886 n4874 vdd vdd) p12 w=2.4u l=0.13u
MP4891 (n4886 n4880 vdd vdd) p12 w=2.4u l=0.13u
MN4894 (n4892 lag_sync2_0 n4893 vss) n12 w=1.6u l=0.13u
MN4895 (n4893 n4886 vss vss) n12 w=1.6u l=0.13u
MP4896 (n4892 lag_sync2_0 vdd vdd) p12 w=2.4u l=0.13u
MP4897 (n4892 n4886 vdd vdd) p12 w=2.4u l=0.13u
MN4900 (n4898 lag_sync2_0 n4899 vss) n12 w=1.6u l=0.13u
MN4901 (n4899 n4892 vss vss) n12 w=1.6u l=0.13u
MP4902 (n4898 lag_sync2_0 vdd vdd) p12 w=2.4u l=0.13u
MP4903 (n4898 n4892 vdd vdd) p12 w=2.4u l=0.13u
MN4906 (n4904 n4886 n4905 vss) n12 w=1.6u l=0.13u
MN4907 (n4905 n4892 vss vss) n12 w=1.6u l=0.13u
MP4908 (n4904 n4886 vdd vdd) p12 w=2.4u l=0.13u
MP4909 (n4904 n4892 vdd vdd) p12 w=2.4u l=0.13u
MN4912 (n4910 n4898 n4911 vss) n12 w=1.6u l=0.13u
MN4913 (n4911 n4904 vss vss) n12 w=1.6u l=0.13u
MP4914 (n4910 n4898 vdd vdd) p12 w=2.4u l=0.13u
MP4915 (n4910 n4904 vdd vdd) p12 w=2.4u l=0.13u
MN4917 (n4916 n4910 vss vss) n12 w=0.8u l=0.13u
MP4918 (n4916 n4910 vdd vdd) p12 w=2.4u l=0.13u
MN4920 (n4919 n4916 vss vss) n12 w=0.8u l=0.13u
MP4921 (n4919 n4916 vdd vdd) p12 w=2.4u l=0.13u
MN4923 (n4922 n4919 vss vss) n12 w=0.8u l=0.13u
MP4924 (n4922 n4919 vdd vdd) p12 w=2.4u l=0.13u
MN4925 (cg0 n4922 vss vss) n12 w=0.8u l=0.13u
MP4926 (cg0 n4922 vdd vdd) p12 w=2.4u l=0.13u
MN4928 (n4927 n4886 vss vss) n12 w=0.8u l=0.13u
MP4929 (n4927 n4886 vdd vdd) p12 w=2.4u l=0.13u
MN4931 (n4930 n4927 vss vss) n12 w=0.8u l=0.13u
MP4932 (n4930 n4927 vdd vdd) p12 w=2.4u l=0.13u
MN4934 (n4933 n4930 vss vss) n12 w=0.8u l=0.13u
MP4935 (n4933 n4930 vdd vdd) p12 w=2.4u l=0.13u
MN4936 (cg1 n4933 vss vss) n12 w=0.8u l=0.13u
MP4937 (cg1 n4933 vdd vdd) p12 w=2.4u l=0.13u
MN4939 (n4938 n4862 vss vss) n12 w=0.8u l=0.13u
MP4940 (n4938 n4862 vdd vdd) p12 w=2.4u l=0.13u
MN4942 (n4941 n4938 vss vss) n12 w=0.8u l=0.13u
MP4943 (n4941 n4938 vdd vdd) p12 w=2.4u l=0.13u
MN4945 (n4944 n4941 vss vss) n12 w=0.8u l=0.13u
MP4946 (n4944 n4941 vdd vdd) p12 w=2.4u l=0.13u
MN4947 (cg2 n4944 vss vss) n12 w=0.8u l=0.13u
MP4948 (cg2 n4944 vdd vdd) p12 w=2.4u l=0.13u
MN4950 (n4949 n4838 vss vss) n12 w=0.8u l=0.13u
MP4951 (n4949 n4838 vdd vdd) p12 w=2.4u l=0.13u
MN4953 (n4952 n4949 vss vss) n12 w=0.8u l=0.13u
MP4954 (n4952 n4949 vdd vdd) p12 w=2.4u l=0.13u
MN4956 (n4955 n4952 vss vss) n12 w=0.8u l=0.13u
MP4957 (n4955 n4952 vdd vdd) p12 w=2.4u l=0.13u
MN4958 (cg3 n4955 vss vss) n12 w=0.8u l=0.13u
MP4959 (cg3 n4955 vdd vdd) p12 w=2.4u l=0.13u
MN4961 (n4960 n4814 vss vss) n12 w=0.8u l=0.13u
MP4962 (n4960 n4814 vdd vdd) p12 w=2.4u l=0.13u
MN4964 (n4963 n4960 vss vss) n12 w=0.8u l=0.13u
MP4965 (n4963 n4960 vdd vdd) p12 w=2.4u l=0.13u
MN4967 (n4966 n4963 vss vss) n12 w=0.8u l=0.13u
MP4968 (n4966 n4963 vdd vdd) p12 w=2.4u l=0.13u
MN4969 (cg4 n4966 vss vss) n12 w=0.8u l=0.13u
MP4970 (cg4 n4966 vdd vdd) p12 w=2.4u l=0.13u
MN4972 (n4971 n4790 vss vss) n12 w=0.8u l=0.13u
MP4973 (n4971 n4790 vdd vdd) p12 w=2.4u l=0.13u
MN4975 (n4974 n4971 vss vss) n12 w=0.8u l=0.13u
MP4976 (n4974 n4971 vdd vdd) p12 w=2.4u l=0.13u
MN4978 (n4977 n4974 vss vss) n12 w=0.8u l=0.13u
MP4979 (n4977 n4974 vdd vdd) p12 w=2.4u l=0.13u
MN4980 (cg5 n4977 vss vss) n12 w=0.8u l=0.13u
MP4981 (cg5 n4977 vdd vdd) p12 w=2.4u l=0.13u
MN4983 (n4982 n4766 vss vss) n12 w=0.8u l=0.13u
MP4984 (n4982 n4766 vdd vdd) p12 w=2.4u l=0.13u
MN4986 (n4985 n4982 vss vss) n12 w=0.8u l=0.13u
MP4987 (n4985 n4982 vdd vdd) p12 w=2.4u l=0.13u
MN4989 (n4988 n4985 vss vss) n12 w=0.8u l=0.13u
MP4990 (n4988 n4985 vdd vdd) p12 w=2.4u l=0.13u
MN4991 (cg6 n4988 vss vss) n12 w=0.8u l=0.13u
MP4992 (cg6 n4988 vdd vdd) p12 w=2.4u l=0.13u
MN4994 (n4993 n4742 vss vss) n12 w=0.8u l=0.13u
MP4995 (n4993 n4742 vdd vdd) p12 w=2.4u l=0.13u
MN4997 (n4996 n4993 vss vss) n12 w=0.8u l=0.13u
MP4998 (n4996 n4993 vdd vdd) p12 w=2.4u l=0.13u
MN5000 (n4999 n4996 vss vss) n12 w=0.8u l=0.13u
MP5001 (n4999 n4996 vdd vdd) p12 w=2.4u l=0.13u
MN5002 (cg7 n4999 vss vss) n12 w=0.8u l=0.13u
MP5003 (cg7 n4999 vdd vdd) p12 w=2.4u l=0.13u
MN5005 (n5004 lag_sync2_8 vss vss) n12 w=0.8u l=0.13u
MP5006 (n5004 lag_sync2_8 vdd vdd) p12 w=2.4u l=0.13u
MN5008 (n5007 n5004 vss vss) n12 w=0.8u l=0.13u
MP5009 (n5007 n5004 vdd vdd) p12 w=2.4u l=0.13u
MN5011 (n5010 n5007 vss vss) n12 w=0.8u l=0.13u
MP5012 (n5010 n5007 vdd vdd) p12 w=2.4u l=0.13u
MN5013 (cg8 n5010 vss vss) n12 w=0.8u l=0.13u
MP5014 (cg8 n5010 vdd vdd) p12 w=2.4u l=0.13u
MN5017 (n5015 div_sync2_7 n5016 vss) n12 w=1.6u l=0.13u
MN5018 (n5016 div_sync2_8 vss vss) n12 w=1.6u l=0.13u
MP5019 (n5015 div_sync2_7 vdd vdd) p12 w=2.4u l=0.13u
MP5020 (n5015 div_sync2_8 vdd vdd) p12 w=2.4u l=0.13u
MN5023 (n5021 div_sync2_7 n5022 vss) n12 w=1.6u l=0.13u
MN5024 (n5022 n5015 vss vss) n12 w=1.6u l=0.13u
MP5025 (n5021 div_sync2_7 vdd vdd) p12 w=2.4u l=0.13u
MP5026 (n5021 n5015 vdd vdd) p12 w=2.4u l=0.13u
MN5029 (n5027 div_sync2_8 n5028 vss) n12 w=1.6u l=0.13u
MN5030 (n5028 n5015 vss vss) n12 w=1.6u l=0.13u
MP5031 (n5027 div_sync2_8 vdd vdd) p12 w=2.4u l=0.13u
MP5032 (n5027 n5015 vdd vdd) p12 w=2.4u l=0.13u
MN5035 (n5033 n5021 n5034 vss) n12 w=1.6u l=0.13u
MN5036 (n5034 n5027 vss vss) n12 w=1.6u l=0.13u
MP5037 (n5033 n5021 vdd vdd) p12 w=2.4u l=0.13u
MP5038 (n5033 n5027 vdd vdd) p12 w=2.4u l=0.13u
MN5041 (n5039 div_sync2_6 n5040 vss) n12 w=1.6u l=0.13u
MN5042 (n5040 n5033 vss vss) n12 w=1.6u l=0.13u
MP5043 (n5039 div_sync2_6 vdd vdd) p12 w=2.4u l=0.13u
MP5044 (n5039 n5033 vdd vdd) p12 w=2.4u l=0.13u
MN5047 (n5045 div_sync2_6 n5046 vss) n12 w=1.6u l=0.13u
MN5048 (n5046 n5039 vss vss) n12 w=1.6u l=0.13u
MP5049 (n5045 div_sync2_6 vdd vdd) p12 w=2.4u l=0.13u
MP5050 (n5045 n5039 vdd vdd) p12 w=2.4u l=0.13u
MN5053 (n5051 n5033 n5052 vss) n12 w=1.6u l=0.13u
MN5054 (n5052 n5039 vss vss) n12 w=1.6u l=0.13u
MP5055 (n5051 n5033 vdd vdd) p12 w=2.4u l=0.13u
MP5056 (n5051 n5039 vdd vdd) p12 w=2.4u l=0.13u
MN5059 (n5057 n5045 n5058 vss) n12 w=1.6u l=0.13u
MN5060 (n5058 n5051 vss vss) n12 w=1.6u l=0.13u
MP5061 (n5057 n5045 vdd vdd) p12 w=2.4u l=0.13u
MP5062 (n5057 n5051 vdd vdd) p12 w=2.4u l=0.13u
MN5065 (n5063 div_sync2_5 n5064 vss) n12 w=1.6u l=0.13u
MN5066 (n5064 n5057 vss vss) n12 w=1.6u l=0.13u
MP5067 (n5063 div_sync2_5 vdd vdd) p12 w=2.4u l=0.13u
MP5068 (n5063 n5057 vdd vdd) p12 w=2.4u l=0.13u
MN5071 (n5069 div_sync2_5 n5070 vss) n12 w=1.6u l=0.13u
MN5072 (n5070 n5063 vss vss) n12 w=1.6u l=0.13u
MP5073 (n5069 div_sync2_5 vdd vdd) p12 w=2.4u l=0.13u
MP5074 (n5069 n5063 vdd vdd) p12 w=2.4u l=0.13u
MN5077 (n5075 n5057 n5076 vss) n12 w=1.6u l=0.13u
MN5078 (n5076 n5063 vss vss) n12 w=1.6u l=0.13u
MP5079 (n5075 n5057 vdd vdd) p12 w=2.4u l=0.13u
MP5080 (n5075 n5063 vdd vdd) p12 w=2.4u l=0.13u
MN5083 (n5081 n5069 n5082 vss) n12 w=1.6u l=0.13u
MN5084 (n5082 n5075 vss vss) n12 w=1.6u l=0.13u
MP5085 (n5081 n5069 vdd vdd) p12 w=2.4u l=0.13u
MP5086 (n5081 n5075 vdd vdd) p12 w=2.4u l=0.13u
MN5089 (n5087 div_sync2_4 n5088 vss) n12 w=1.6u l=0.13u
MN5090 (n5088 n5081 vss vss) n12 w=1.6u l=0.13u
MP5091 (n5087 div_sync2_4 vdd vdd) p12 w=2.4u l=0.13u
MP5092 (n5087 n5081 vdd vdd) p12 w=2.4u l=0.13u
MN5095 (n5093 div_sync2_4 n5094 vss) n12 w=1.6u l=0.13u
MN5096 (n5094 n5087 vss vss) n12 w=1.6u l=0.13u
MP5097 (n5093 div_sync2_4 vdd vdd) p12 w=2.4u l=0.13u
MP5098 (n5093 n5087 vdd vdd) p12 w=2.4u l=0.13u
MN5101 (n5099 n5081 n5100 vss) n12 w=1.6u l=0.13u
MN5102 (n5100 n5087 vss vss) n12 w=1.6u l=0.13u
MP5103 (n5099 n5081 vdd vdd) p12 w=2.4u l=0.13u
MP5104 (n5099 n5087 vdd vdd) p12 w=2.4u l=0.13u
MN5107 (n5105 n5093 n5106 vss) n12 w=1.6u l=0.13u
MN5108 (n5106 n5099 vss vss) n12 w=1.6u l=0.13u
MP5109 (n5105 n5093 vdd vdd) p12 w=2.4u l=0.13u
MP5110 (n5105 n5099 vdd vdd) p12 w=2.4u l=0.13u
MN5113 (n5111 div_sync2_3 n5112 vss) n12 w=1.6u l=0.13u
MN5114 (n5112 n5105 vss vss) n12 w=1.6u l=0.13u
MP5115 (n5111 div_sync2_3 vdd vdd) p12 w=2.4u l=0.13u
MP5116 (n5111 n5105 vdd vdd) p12 w=2.4u l=0.13u
MN5119 (n5117 div_sync2_3 n5118 vss) n12 w=1.6u l=0.13u
MN5120 (n5118 n5111 vss vss) n12 w=1.6u l=0.13u
MP5121 (n5117 div_sync2_3 vdd vdd) p12 w=2.4u l=0.13u
MP5122 (n5117 n5111 vdd vdd) p12 w=2.4u l=0.13u
MN5125 (n5123 n5105 n5124 vss) n12 w=1.6u l=0.13u
MN5126 (n5124 n5111 vss vss) n12 w=1.6u l=0.13u
MP5127 (n5123 n5105 vdd vdd) p12 w=2.4u l=0.13u
MP5128 (n5123 n5111 vdd vdd) p12 w=2.4u l=0.13u
MN5131 (n5129 n5117 n5130 vss) n12 w=1.6u l=0.13u
MN5132 (n5130 n5123 vss vss) n12 w=1.6u l=0.13u
MP5133 (n5129 n5117 vdd vdd) p12 w=2.4u l=0.13u
MP5134 (n5129 n5123 vdd vdd) p12 w=2.4u l=0.13u
MN5137 (n5135 div_sync2_2 n5136 vss) n12 w=1.6u l=0.13u
MN5138 (n5136 n5129 vss vss) n12 w=1.6u l=0.13u
MP5139 (n5135 div_sync2_2 vdd vdd) p12 w=2.4u l=0.13u
MP5140 (n5135 n5129 vdd vdd) p12 w=2.4u l=0.13u
MN5143 (n5141 div_sync2_2 n5142 vss) n12 w=1.6u l=0.13u
MN5144 (n5142 n5135 vss vss) n12 w=1.6u l=0.13u
MP5145 (n5141 div_sync2_2 vdd vdd) p12 w=2.4u l=0.13u
MP5146 (n5141 n5135 vdd vdd) p12 w=2.4u l=0.13u
MN5149 (n5147 n5129 n5148 vss) n12 w=1.6u l=0.13u
MN5150 (n5148 n5135 vss vss) n12 w=1.6u l=0.13u
MP5151 (n5147 n5129 vdd vdd) p12 w=2.4u l=0.13u
MP5152 (n5147 n5135 vdd vdd) p12 w=2.4u l=0.13u
MN5155 (n5153 n5141 n5154 vss) n12 w=1.6u l=0.13u
MN5156 (n5154 n5147 vss vss) n12 w=1.6u l=0.13u
MP5157 (n5153 n5141 vdd vdd) p12 w=2.4u l=0.13u
MP5158 (n5153 n5147 vdd vdd) p12 w=2.4u l=0.13u
MN5161 (n5159 div_sync2_1 n5160 vss) n12 w=1.6u l=0.13u
MN5162 (n5160 n5153 vss vss) n12 w=1.6u l=0.13u
MP5163 (n5159 div_sync2_1 vdd vdd) p12 w=2.4u l=0.13u
MP5164 (n5159 n5153 vdd vdd) p12 w=2.4u l=0.13u
MN5167 (n5165 div_sync2_1 n5166 vss) n12 w=1.6u l=0.13u
MN5168 (n5166 n5159 vss vss) n12 w=1.6u l=0.13u
MP5169 (n5165 div_sync2_1 vdd vdd) p12 w=2.4u l=0.13u
MP5170 (n5165 n5159 vdd vdd) p12 w=2.4u l=0.13u
MN5173 (n5171 n5153 n5172 vss) n12 w=1.6u l=0.13u
MN5174 (n5172 n5159 vss vss) n12 w=1.6u l=0.13u
MP5175 (n5171 n5153 vdd vdd) p12 w=2.4u l=0.13u
MP5176 (n5171 n5159 vdd vdd) p12 w=2.4u l=0.13u
MN5179 (n5177 n5165 n5178 vss) n12 w=1.6u l=0.13u
MN5180 (n5178 n5171 vss vss) n12 w=1.6u l=0.13u
MP5181 (n5177 n5165 vdd vdd) p12 w=2.4u l=0.13u
MP5182 (n5177 n5171 vdd vdd) p12 w=2.4u l=0.13u
MN5185 (n5183 div_sync2_0 n5184 vss) n12 w=1.6u l=0.13u
MN5186 (n5184 n5177 vss vss) n12 w=1.6u l=0.13u
MP5187 (n5183 div_sync2_0 vdd vdd) p12 w=2.4u l=0.13u
MP5188 (n5183 n5177 vdd vdd) p12 w=2.4u l=0.13u
MN5191 (n5189 div_sync2_0 n5190 vss) n12 w=1.6u l=0.13u
MN5192 (n5190 n5183 vss vss) n12 w=1.6u l=0.13u
MP5193 (n5189 div_sync2_0 vdd vdd) p12 w=2.4u l=0.13u
MP5194 (n5189 n5183 vdd vdd) p12 w=2.4u l=0.13u
MN5197 (n5195 n5177 n5196 vss) n12 w=1.6u l=0.13u
MN5198 (n5196 n5183 vss vss) n12 w=1.6u l=0.13u
MP5199 (n5195 n5177 vdd vdd) p12 w=2.4u l=0.13u
MP5200 (n5195 n5183 vdd vdd) p12 w=2.4u l=0.13u
MN5203 (n5201 n5189 n5202 vss) n12 w=1.6u l=0.13u
MN5204 (n5202 n5195 vss vss) n12 w=1.6u l=0.13u
MP5205 (n5201 n5189 vdd vdd) p12 w=2.4u l=0.13u
MP5206 (n5201 n5195 vdd vdd) p12 w=2.4u l=0.13u
MN5208 (n5207 n5201 vss vss) n12 w=0.8u l=0.13u
MP5209 (n5207 n5201 vdd vdd) p12 w=2.4u l=0.13u
MN5211 (n5210 n5207 vss vss) n12 w=0.8u l=0.13u
MP5212 (n5210 n5207 vdd vdd) p12 w=2.4u l=0.13u
MN5214 (n5213 n5210 vss vss) n12 w=0.8u l=0.13u
MP5215 (n5213 n5210 vdd vdd) p12 w=2.4u l=0.13u
MN5216 (cd0 n5213 vss vss) n12 w=0.8u l=0.13u
MP5217 (cd0 n5213 vdd vdd) p12 w=2.4u l=0.13u
MN5219 (n5218 n5177 vss vss) n12 w=0.8u l=0.13u
MP5220 (n5218 n5177 vdd vdd) p12 w=2.4u l=0.13u
MN5222 (n5221 n5218 vss vss) n12 w=0.8u l=0.13u
MP5223 (n5221 n5218 vdd vdd) p12 w=2.4u l=0.13u
MN5225 (n5224 n5221 vss vss) n12 w=0.8u l=0.13u
MP5226 (n5224 n5221 vdd vdd) p12 w=2.4u l=0.13u
MN5227 (cd1 n5224 vss vss) n12 w=0.8u l=0.13u
MP5228 (cd1 n5224 vdd vdd) p12 w=2.4u l=0.13u
MN5230 (n5229 n5153 vss vss) n12 w=0.8u l=0.13u
MP5231 (n5229 n5153 vdd vdd) p12 w=2.4u l=0.13u
MN5233 (n5232 n5229 vss vss) n12 w=0.8u l=0.13u
MP5234 (n5232 n5229 vdd vdd) p12 w=2.4u l=0.13u
MN5236 (n5235 n5232 vss vss) n12 w=0.8u l=0.13u
MP5237 (n5235 n5232 vdd vdd) p12 w=2.4u l=0.13u
MN5238 (cd2 n5235 vss vss) n12 w=0.8u l=0.13u
MP5239 (cd2 n5235 vdd vdd) p12 w=2.4u l=0.13u
MN5241 (n5240 n5129 vss vss) n12 w=0.8u l=0.13u
MP5242 (n5240 n5129 vdd vdd) p12 w=2.4u l=0.13u
MN5244 (n5243 n5240 vss vss) n12 w=0.8u l=0.13u
MP5245 (n5243 n5240 vdd vdd) p12 w=2.4u l=0.13u
MN5247 (n5246 n5243 vss vss) n12 w=0.8u l=0.13u
MP5248 (n5246 n5243 vdd vdd) p12 w=2.4u l=0.13u
MN5249 (cd3 n5246 vss vss) n12 w=0.8u l=0.13u
MP5250 (cd3 n5246 vdd vdd) p12 w=2.4u l=0.13u
MN5252 (n5251 n5105 vss vss) n12 w=0.8u l=0.13u
MP5253 (n5251 n5105 vdd vdd) p12 w=2.4u l=0.13u
MN5255 (n5254 n5251 vss vss) n12 w=0.8u l=0.13u
MP5256 (n5254 n5251 vdd vdd) p12 w=2.4u l=0.13u
MN5258 (n5257 n5254 vss vss) n12 w=0.8u l=0.13u
MP5259 (n5257 n5254 vdd vdd) p12 w=2.4u l=0.13u
MN5260 (cd4 n5257 vss vss) n12 w=0.8u l=0.13u
MP5261 (cd4 n5257 vdd vdd) p12 w=2.4u l=0.13u
MN5263 (n5262 n5081 vss vss) n12 w=0.8u l=0.13u
MP5264 (n5262 n5081 vdd vdd) p12 w=2.4u l=0.13u
MN5266 (n5265 n5262 vss vss) n12 w=0.8u l=0.13u
MP5267 (n5265 n5262 vdd vdd) p12 w=2.4u l=0.13u
MN5269 (n5268 n5265 vss vss) n12 w=0.8u l=0.13u
MP5270 (n5268 n5265 vdd vdd) p12 w=2.4u l=0.13u
MN5271 (cd5 n5268 vss vss) n12 w=0.8u l=0.13u
MP5272 (cd5 n5268 vdd vdd) p12 w=2.4u l=0.13u
MN5274 (n5273 n5057 vss vss) n12 w=0.8u l=0.13u
MP5275 (n5273 n5057 vdd vdd) p12 w=2.4u l=0.13u
MN5277 (n5276 n5273 vss vss) n12 w=0.8u l=0.13u
MP5278 (n5276 n5273 vdd vdd) p12 w=2.4u l=0.13u
MN5280 (n5279 n5276 vss vss) n12 w=0.8u l=0.13u
MP5281 (n5279 n5276 vdd vdd) p12 w=2.4u l=0.13u
MN5282 (cd6 n5279 vss vss) n12 w=0.8u l=0.13u
MP5283 (cd6 n5279 vdd vdd) p12 w=2.4u l=0.13u
MN5285 (n5284 n5033 vss vss) n12 w=0.8u l=0.13u
MP5286 (n5284 n5033 vdd vdd) p12 w=2.4u l=0.13u
MN5288 (n5287 n5284 vss vss) n12 w=0.8u l=0.13u
MP5289 (n5287 n5284 vdd vdd) p12 w=2.4u l=0.13u
MN5291 (n5290 n5287 vss vss) n12 w=0.8u l=0.13u
MP5292 (n5290 n5287 vdd vdd) p12 w=2.4u l=0.13u
MN5293 (cd7 n5290 vss vss) n12 w=0.8u l=0.13u
MP5294 (cd7 n5290 vdd vdd) p12 w=2.4u l=0.13u
MN5296 (n5295 div_sync2_8 vss vss) n12 w=0.8u l=0.13u
MP5297 (n5295 div_sync2_8 vdd vdd) p12 w=2.4u l=0.13u
MN5299 (n5298 n5295 vss vss) n12 w=0.8u l=0.13u
MP5300 (n5298 n5295 vdd vdd) p12 w=2.4u l=0.13u
MN5302 (n5301 n5298 vss vss) n12 w=0.8u l=0.13u
MP5303 (n5301 n5298 vdd vdd) p12 w=2.4u l=0.13u
MN5304 (cd8 n5301 vss vss) n12 w=0.8u l=0.13u
MP5305 (cd8 n5301 vdd vdd) p12 w=2.4u l=0.13u
MN5310 (seen clk_low3155 storage5309 vss) n12 w=1.2u l=0.13u
MP5311 (seen clk_lowb3156 storage5309 vdd) p12 w=3.6u l=0.13u
MN5312 (qm5306 clk_high3157 storage5309 vss) n12 w=1.2u l=0.13u
MP5313 (qm5306 clk_highb3158 storage5309 vdd) p12 w=3.6u l=0.13u
MN5314 (qmb5307 storage5309 vss vss) n12 w=0.5u l=0.13u
MP5315 (qmb5307 storage5309 vdd vdd) p12 w=1.5u l=0.13u
MN5316 (qm5306 qmb5307 vss vss) n12 w=0.5u l=0.13u
MP5317 (qm5306 qmb5307 vdd vdd) p12 w=1.5u l=0.13u
MN5318 (storage5309 count_rst vss vss) n12 w=2u l=0.13u
MN5320 (qm5306 clk_high3157 storage5319 vss) n12 w=1.2u l=0.13u
MP5321 (qm5306 clk_highb3158 storage5319 vdd) p12 w=3.6u l=0.13u
MN5322 (seen_sync1 clk_low3155 storage5319 vss) n12 w=1.2u l=0.13u
MP5323 (seen_sync1 clk_lowb3156 storage5319 vdd) p12 w=3.6u l=0.13u
MN5324 (qb5308 storage5319 vss vss) n12 w=0.5u l=0.13u
MP5325 (qb5308 storage5319 vdd vdd) p12 w=1.5u l=0.13u
MN5326 (seen_sync1 qb5308 vss vss) n12 w=0.5u l=0.13u
MP5327 (seen_sync1 qb5308 vdd vdd) p12 w=1.5u l=0.13u
MN5328 (storage5319 count_rst vss vss) n12 w=2u l=0.13u
MN5333 (seen_sync1 clk_low3155 storage5332 vss) n12 w=1.2u l=0.13u
MP5334 (seen_sync1 clk_lowb3156 storage5332 vdd) p12 w=3.6u l=0.13u
MN5335 (qm5329 clk_high3157 storage5332 vss) n12 w=1.2u l=0.13u
MP5336 (qm5329 clk_highb3158 storage5332 vdd) p12 w=3.6u l=0.13u
MN5337 (qmb5330 storage5332 vss vss) n12 w=0.5u l=0.13u
MP5338 (qmb5330 storage5332 vdd vdd) p12 w=1.5u l=0.13u
MN5339 (qm5329 qmb5330 vss vss) n12 w=0.5u l=0.13u
MP5340 (qm5329 qmb5330 vdd vdd) p12 w=1.5u l=0.13u
MN5341 (storage5332 count_rst vss vss) n12 w=2u l=0.13u
MN5343 (qm5329 clk_high3157 storage5342 vss) n12 w=1.2u l=0.13u
MP5344 (qm5329 clk_highb3158 storage5342 vdd) p12 w=3.6u l=0.13u
MN5345 (seen_sync2 clk_low3155 storage5342 vss) n12 w=1.2u l=0.13u
MP5346 (seen_sync2 clk_lowb3156 storage5342 vdd) p12 w=3.6u l=0.13u
MN5347 (qb5331 storage5342 vss vss) n12 w=0.5u l=0.13u
MP5348 (qb5331 storage5342 vdd vdd) p12 w=1.5u l=0.13u
MN5349 (seen_sync2 qb5331 vss vss) n12 w=0.5u l=0.13u
MP5350 (seen_sync2 qb5331 vdd vdd) p12 w=1.5u l=0.13u
MN5351 (storage5342 count_rst vss vss) n12 w=2u l=0.13u
MN5356 (seen_sync2 clk_low3155 storage5355 vss) n12 w=1.2u l=0.13u
MP5357 (seen_sync2 clk_lowb3156 storage5355 vdd) p12 w=3.6u l=0.13u
MN5358 (qm5352 clk_high3157 storage5355 vss) n12 w=1.2u l=0.13u
MP5359 (qm5352 clk_highb3158 storage5355 vdd) p12 w=3.6u l=0.13u
MN5360 (qmb5353 storage5355 vss vss) n12 w=0.5u l=0.13u
MP5361 (qmb5353 storage5355 vdd vdd) p12 w=1.5u l=0.13u
MN5362 (qm5352 qmb5353 vss vss) n12 w=0.5u l=0.13u
MP5363 (qm5352 qmb5353 vdd vdd) p12 w=1.5u l=0.13u
MN5364 (storage5355 count_rst vss vss) n12 w=2u l=0.13u
MN5366 (qm5352 clk_high3157 storage5365 vss) n12 w=1.2u l=0.13u
MP5367 (qm5352 clk_highb3158 storage5365 vdd) p12 w=3.6u l=0.13u
MN5368 (epoch_valid1 clk_low3155 storage5365 vss) n12 w=1.2u l=0.13u
MP5369 (epoch_valid1 clk_lowb3156 storage5365 vdd) p12 w=3.6u l=0.13u
MN5370 (qb5354 storage5365 vss vss) n12 w=0.5u l=0.13u
MP5371 (qb5354 storage5365 vdd vdd) p12 w=1.5u l=0.13u
MN5372 (epoch_valid1 qb5354 vss vss) n12 w=0.5u l=0.13u
MP5373 (epoch_valid1 qb5354 vdd vdd) p12 w=1.5u l=0.13u
MN5374 (storage5365 count_rst vss vss) n12 w=2u l=0.13u
MN5379 (epoch_valid1 clk_low3155 storage5378 vss) n12 w=1.2u l=0.13u
MP5380 (epoch_valid1 clk_lowb3156 storage5378 vdd) p12 w=3.6u l=0.13u
MN5381 (qm5375 clk_high3157 storage5378 vss) n12 w=1.2u l=0.13u
MP5382 (qm5375 clk_highb3158 storage5378 vdd) p12 w=3.6u l=0.13u
MN5383 (qmb5376 storage5378 vss vss) n12 w=0.5u l=0.13u
MP5384 (qmb5376 storage5378 vdd vdd) p12 w=1.5u l=0.13u
MN5385 (qm5375 qmb5376 vss vss) n12 w=0.5u l=0.13u
MP5386 (qm5375 qmb5376 vdd vdd) p12 w=1.5u l=0.13u
MN5387 (storage5378 count_rst vss vss) n12 w=2u l=0.13u
MN5389 (qm5375 clk_high3157 storage5388 vss) n12 w=1.2u l=0.13u
MP5390 (qm5375 clk_highb3158 storage5388 vdd) p12 w=3.6u l=0.13u
MN5391 (epoch_valid clk_low3155 storage5388 vss) n12 w=1.2u l=0.13u
MP5392 (epoch_valid clk_lowb3156 storage5388 vdd) p12 w=3.6u l=0.13u
MN5393 (qb5377 storage5388 vss vss) n12 w=0.5u l=0.13u
MP5394 (qb5377 storage5388 vdd vdd) p12 w=1.5u l=0.13u
MN5395 (epoch_valid qb5377 vss vss) n12 w=0.5u l=0.13u
MP5396 (epoch_valid qb5377 vdd vdd) p12 w=1.5u l=0.13u
MN5397 (storage5388 count_rst vss vss) n12 w=2u l=0.13u
MN5399 (n5398 cd0 vss vss) n12 w=0.8u l=0.13u
MP5400 (n5398 cd0 vdd vdd) p12 w=2.4u l=0.13u
MN5403 (n5401 cg0 n5402 vss) n12 w=1.6u l=0.13u
MN5404 (n5402 n5398 vss vss) n12 w=1.6u l=0.13u
MP5405 (n5401 cg0 vdd vdd) p12 w=2.4u l=0.13u
MP5406 (n5401 n5398 vdd vdd) p12 w=2.4u l=0.13u
MN5409 (n5407 cg0 n5408 vss) n12 w=1.6u l=0.13u
MN5410 (n5408 n5401 vss vss) n12 w=1.6u l=0.13u
MP5411 (n5407 cg0 vdd vdd) p12 w=2.4u l=0.13u
MP5412 (n5407 n5401 vdd vdd) p12 w=2.4u l=0.13u
MN5415 (n5413 n5398 n5414 vss) n12 w=1.6u l=0.13u
MN5416 (n5414 n5401 vss vss) n12 w=1.6u l=0.13u
MP5417 (n5413 n5398 vdd vdd) p12 w=2.4u l=0.13u
MP5418 (n5413 n5401 vdd vdd) p12 w=2.4u l=0.13u
MN5421 (n5419 n5407 n5420 vss) n12 w=1.6u l=0.13u
MN5422 (n5420 n5413 vss vss) n12 w=1.6u l=0.13u
MP5423 (n5419 n5407 vdd vdd) p12 w=2.4u l=0.13u
MP5424 (n5419 n5413 vdd vdd) p12 w=2.4u l=0.13u
MN5426 (n5425 n5419 vss vss) n12 w=0.8u l=0.13u
MP5427 (n5425 n5419 vdd vdd) p12 w=2.4u l=0.13u
MN5429 (n5428 n5401 vss vss) n12 w=0.8u l=0.13u
MP5430 (n5428 n5401 vdd vdd) p12 w=2.4u l=0.13u
MN5433 (n5431 n5419 vss vss) n12 w=0.8u l=0.13u
MN5434 (n5431 n5428 vss vss) n12 w=0.8u l=0.13u
MP5435 (n5431 n5419 n5432 vdd) p12 w=4.8u l=0.13u
MP5436 (n5432 n5428 vdd vdd) p12 w=4.8u l=0.13u
MN5438 (n5437 n5431 vss vss) n12 w=0.8u l=0.13u
MP5439 (n5437 n5431 vdd vdd) p12 w=2.4u l=0.13u
MN5441 (n5440 cd1 vss vss) n12 w=0.8u l=0.13u
MP5442 (n5440 cd1 vdd vdd) p12 w=2.4u l=0.13u
MN5445 (n5443 cg1 n5444 vss) n12 w=1.6u l=0.13u
MN5446 (n5444 n5440 vss vss) n12 w=1.6u l=0.13u
MP5447 (n5443 cg1 vdd vdd) p12 w=2.4u l=0.13u
MP5448 (n5443 n5440 vdd vdd) p12 w=2.4u l=0.13u
MN5451 (n5449 cg1 n5450 vss) n12 w=1.6u l=0.13u
MN5452 (n5450 n5443 vss vss) n12 w=1.6u l=0.13u
MP5453 (n5449 cg1 vdd vdd) p12 w=2.4u l=0.13u
MP5454 (n5449 n5443 vdd vdd) p12 w=2.4u l=0.13u
MN5457 (n5455 n5440 n5456 vss) n12 w=1.6u l=0.13u
MN5458 (n5456 n5443 vss vss) n12 w=1.6u l=0.13u
MP5459 (n5455 n5440 vdd vdd) p12 w=2.4u l=0.13u
MP5460 (n5455 n5443 vdd vdd) p12 w=2.4u l=0.13u
MN5463 (n5461 n5449 n5462 vss) n12 w=1.6u l=0.13u
MN5464 (n5462 n5455 vss vss) n12 w=1.6u l=0.13u
MP5465 (n5461 n5449 vdd vdd) p12 w=2.4u l=0.13u
MP5466 (n5461 n5455 vdd vdd) p12 w=2.4u l=0.13u
MN5469 (n5467 n5437 n5468 vss) n12 w=1.6u l=0.13u
MN5470 (n5468 n5461 vss vss) n12 w=1.6u l=0.13u
MP5471 (n5467 n5437 vdd vdd) p12 w=2.4u l=0.13u
MP5472 (n5467 n5461 vdd vdd) p12 w=2.4u l=0.13u
MN5475 (n5473 n5437 n5474 vss) n12 w=1.6u l=0.13u
MN5476 (n5474 n5467 vss vss) n12 w=1.6u l=0.13u
MP5477 (n5473 n5437 vdd vdd) p12 w=2.4u l=0.13u
MP5478 (n5473 n5467 vdd vdd) p12 w=2.4u l=0.13u
MN5481 (n5479 n5461 n5480 vss) n12 w=1.6u l=0.13u
MN5482 (n5480 n5467 vss vss) n12 w=1.6u l=0.13u
MP5483 (n5479 n5461 vdd vdd) p12 w=2.4u l=0.13u
MP5484 (n5479 n5467 vdd vdd) p12 w=2.4u l=0.13u
MN5487 (n5485 n5473 n5486 vss) n12 w=1.6u l=0.13u
MN5488 (n5486 n5479 vss vss) n12 w=1.6u l=0.13u
MP5489 (n5485 n5473 vdd vdd) p12 w=2.4u l=0.13u
MP5490 (n5485 n5479 vdd vdd) p12 w=2.4u l=0.13u
MN5492 (n5491 n5443 vss vss) n12 w=0.8u l=0.13u
MP5493 (n5491 n5443 vdd vdd) p12 w=2.4u l=0.13u
MN5495 (n5494 n5467 vss vss) n12 w=0.8u l=0.13u
MP5496 (n5494 n5467 vdd vdd) p12 w=2.4u l=0.13u
MN5499 (n5497 n5491 vss vss) n12 w=0.8u l=0.13u
MN5500 (n5497 n5494 vss vss) n12 w=0.8u l=0.13u
MP5501 (n5497 n5491 n5498 vdd) p12 w=4.8u l=0.13u
MP5502 (n5498 n5494 vdd vdd) p12 w=4.8u l=0.13u
MN5504 (n5503 n5497 vss vss) n12 w=0.8u l=0.13u
MP5505 (n5503 n5497 vdd vdd) p12 w=2.4u l=0.13u
MN5507 (n5506 cd2 vss vss) n12 w=0.8u l=0.13u
MP5508 (n5506 cd2 vdd vdd) p12 w=2.4u l=0.13u
MN5511 (n5509 cg2 n5510 vss) n12 w=1.6u l=0.13u
MN5512 (n5510 n5506 vss vss) n12 w=1.6u l=0.13u
MP5513 (n5509 cg2 vdd vdd) p12 w=2.4u l=0.13u
MP5514 (n5509 n5506 vdd vdd) p12 w=2.4u l=0.13u
MN5517 (n5515 cg2 n5516 vss) n12 w=1.6u l=0.13u
MN5518 (n5516 n5509 vss vss) n12 w=1.6u l=0.13u
MP5519 (n5515 cg2 vdd vdd) p12 w=2.4u l=0.13u
MP5520 (n5515 n5509 vdd vdd) p12 w=2.4u l=0.13u
MN5523 (n5521 n5506 n5522 vss) n12 w=1.6u l=0.13u
MN5524 (n5522 n5509 vss vss) n12 w=1.6u l=0.13u
MP5525 (n5521 n5506 vdd vdd) p12 w=2.4u l=0.13u
MP5526 (n5521 n5509 vdd vdd) p12 w=2.4u l=0.13u
MN5529 (n5527 n5515 n5528 vss) n12 w=1.6u l=0.13u
MN5530 (n5528 n5521 vss vss) n12 w=1.6u l=0.13u
MP5531 (n5527 n5515 vdd vdd) p12 w=2.4u l=0.13u
MP5532 (n5527 n5521 vdd vdd) p12 w=2.4u l=0.13u
MN5535 (n5533 n5503 n5534 vss) n12 w=1.6u l=0.13u
MN5536 (n5534 n5527 vss vss) n12 w=1.6u l=0.13u
MP5537 (n5533 n5503 vdd vdd) p12 w=2.4u l=0.13u
MP5538 (n5533 n5527 vdd vdd) p12 w=2.4u l=0.13u
MN5541 (n5539 n5503 n5540 vss) n12 w=1.6u l=0.13u
MN5542 (n5540 n5533 vss vss) n12 w=1.6u l=0.13u
MP5543 (n5539 n5503 vdd vdd) p12 w=2.4u l=0.13u
MP5544 (n5539 n5533 vdd vdd) p12 w=2.4u l=0.13u
MN5547 (n5545 n5527 n5546 vss) n12 w=1.6u l=0.13u
MN5548 (n5546 n5533 vss vss) n12 w=1.6u l=0.13u
MP5549 (n5545 n5527 vdd vdd) p12 w=2.4u l=0.13u
MP5550 (n5545 n5533 vdd vdd) p12 w=2.4u l=0.13u
MN5553 (n5551 n5539 n5552 vss) n12 w=1.6u l=0.13u
MN5554 (n5552 n5545 vss vss) n12 w=1.6u l=0.13u
MP5555 (n5551 n5539 vdd vdd) p12 w=2.4u l=0.13u
MP5556 (n5551 n5545 vdd vdd) p12 w=2.4u l=0.13u
MN5558 (n5557 n5509 vss vss) n12 w=0.8u l=0.13u
MP5559 (n5557 n5509 vdd vdd) p12 w=2.4u l=0.13u
MN5561 (n5560 n5533 vss vss) n12 w=0.8u l=0.13u
MP5562 (n5560 n5533 vdd vdd) p12 w=2.4u l=0.13u
MN5565 (n5563 n5557 vss vss) n12 w=0.8u l=0.13u
MN5566 (n5563 n5560 vss vss) n12 w=0.8u l=0.13u
MP5567 (n5563 n5557 n5564 vdd) p12 w=4.8u l=0.13u
MP5568 (n5564 n5560 vdd vdd) p12 w=4.8u l=0.13u
MN5570 (n5569 n5563 vss vss) n12 w=0.8u l=0.13u
MP5571 (n5569 n5563 vdd vdd) p12 w=2.4u l=0.13u
MN5573 (n5572 cd3 vss vss) n12 w=0.8u l=0.13u
MP5574 (n5572 cd3 vdd vdd) p12 w=2.4u l=0.13u
MN5577 (n5575 cg3 n5576 vss) n12 w=1.6u l=0.13u
MN5578 (n5576 n5572 vss vss) n12 w=1.6u l=0.13u
MP5579 (n5575 cg3 vdd vdd) p12 w=2.4u l=0.13u
MP5580 (n5575 n5572 vdd vdd) p12 w=2.4u l=0.13u
MN5583 (n5581 cg3 n5582 vss) n12 w=1.6u l=0.13u
MN5584 (n5582 n5575 vss vss) n12 w=1.6u l=0.13u
MP5585 (n5581 cg3 vdd vdd) p12 w=2.4u l=0.13u
MP5586 (n5581 n5575 vdd vdd) p12 w=2.4u l=0.13u
MN5589 (n5587 n5572 n5588 vss) n12 w=1.6u l=0.13u
MN5590 (n5588 n5575 vss vss) n12 w=1.6u l=0.13u
MP5591 (n5587 n5572 vdd vdd) p12 w=2.4u l=0.13u
MP5592 (n5587 n5575 vdd vdd) p12 w=2.4u l=0.13u
MN5595 (n5593 n5581 n5594 vss) n12 w=1.6u l=0.13u
MN5596 (n5594 n5587 vss vss) n12 w=1.6u l=0.13u
MP5597 (n5593 n5581 vdd vdd) p12 w=2.4u l=0.13u
MP5598 (n5593 n5587 vdd vdd) p12 w=2.4u l=0.13u
MN5601 (n5599 n5569 n5600 vss) n12 w=1.6u l=0.13u
MN5602 (n5600 n5593 vss vss) n12 w=1.6u l=0.13u
MP5603 (n5599 n5569 vdd vdd) p12 w=2.4u l=0.13u
MP5604 (n5599 n5593 vdd vdd) p12 w=2.4u l=0.13u
MN5607 (n5605 n5569 n5606 vss) n12 w=1.6u l=0.13u
MN5608 (n5606 n5599 vss vss) n12 w=1.6u l=0.13u
MP5609 (n5605 n5569 vdd vdd) p12 w=2.4u l=0.13u
MP5610 (n5605 n5599 vdd vdd) p12 w=2.4u l=0.13u
MN5613 (n5611 n5593 n5612 vss) n12 w=1.6u l=0.13u
MN5614 (n5612 n5599 vss vss) n12 w=1.6u l=0.13u
MP5615 (n5611 n5593 vdd vdd) p12 w=2.4u l=0.13u
MP5616 (n5611 n5599 vdd vdd) p12 w=2.4u l=0.13u
MN5619 (n5617 n5605 n5618 vss) n12 w=1.6u l=0.13u
MN5620 (n5618 n5611 vss vss) n12 w=1.6u l=0.13u
MP5621 (n5617 n5605 vdd vdd) p12 w=2.4u l=0.13u
MP5622 (n5617 n5611 vdd vdd) p12 w=2.4u l=0.13u
MN5624 (n5623 n5575 vss vss) n12 w=0.8u l=0.13u
MP5625 (n5623 n5575 vdd vdd) p12 w=2.4u l=0.13u
MN5627 (n5626 n5599 vss vss) n12 w=0.8u l=0.13u
MP5628 (n5626 n5599 vdd vdd) p12 w=2.4u l=0.13u
MN5631 (n5629 n5623 vss vss) n12 w=0.8u l=0.13u
MN5632 (n5629 n5626 vss vss) n12 w=0.8u l=0.13u
MP5633 (n5629 n5623 n5630 vdd) p12 w=4.8u l=0.13u
MP5634 (n5630 n5626 vdd vdd) p12 w=4.8u l=0.13u
MN5636 (n5635 n5629 vss vss) n12 w=0.8u l=0.13u
MP5637 (n5635 n5629 vdd vdd) p12 w=2.4u l=0.13u
MN5639 (n5638 cd4 vss vss) n12 w=0.8u l=0.13u
MP5640 (n5638 cd4 vdd vdd) p12 w=2.4u l=0.13u
MN5643 (n5641 cg4 n5642 vss) n12 w=1.6u l=0.13u
MN5644 (n5642 n5638 vss vss) n12 w=1.6u l=0.13u
MP5645 (n5641 cg4 vdd vdd) p12 w=2.4u l=0.13u
MP5646 (n5641 n5638 vdd vdd) p12 w=2.4u l=0.13u
MN5649 (n5647 cg4 n5648 vss) n12 w=1.6u l=0.13u
MN5650 (n5648 n5641 vss vss) n12 w=1.6u l=0.13u
MP5651 (n5647 cg4 vdd vdd) p12 w=2.4u l=0.13u
MP5652 (n5647 n5641 vdd vdd) p12 w=2.4u l=0.13u
MN5655 (n5653 n5638 n5654 vss) n12 w=1.6u l=0.13u
MN5656 (n5654 n5641 vss vss) n12 w=1.6u l=0.13u
MP5657 (n5653 n5638 vdd vdd) p12 w=2.4u l=0.13u
MP5658 (n5653 n5641 vdd vdd) p12 w=2.4u l=0.13u
MN5661 (n5659 n5647 n5660 vss) n12 w=1.6u l=0.13u
MN5662 (n5660 n5653 vss vss) n12 w=1.6u l=0.13u
MP5663 (n5659 n5647 vdd vdd) p12 w=2.4u l=0.13u
MP5664 (n5659 n5653 vdd vdd) p12 w=2.4u l=0.13u
MN5667 (n5665 n5635 n5666 vss) n12 w=1.6u l=0.13u
MN5668 (n5666 n5659 vss vss) n12 w=1.6u l=0.13u
MP5669 (n5665 n5635 vdd vdd) p12 w=2.4u l=0.13u
MP5670 (n5665 n5659 vdd vdd) p12 w=2.4u l=0.13u
MN5673 (n5671 n5635 n5672 vss) n12 w=1.6u l=0.13u
MN5674 (n5672 n5665 vss vss) n12 w=1.6u l=0.13u
MP5675 (n5671 n5635 vdd vdd) p12 w=2.4u l=0.13u
MP5676 (n5671 n5665 vdd vdd) p12 w=2.4u l=0.13u
MN5679 (n5677 n5659 n5678 vss) n12 w=1.6u l=0.13u
MN5680 (n5678 n5665 vss vss) n12 w=1.6u l=0.13u
MP5681 (n5677 n5659 vdd vdd) p12 w=2.4u l=0.13u
MP5682 (n5677 n5665 vdd vdd) p12 w=2.4u l=0.13u
MN5685 (n5683 n5671 n5684 vss) n12 w=1.6u l=0.13u
MN5686 (n5684 n5677 vss vss) n12 w=1.6u l=0.13u
MP5687 (n5683 n5671 vdd vdd) p12 w=2.4u l=0.13u
MP5688 (n5683 n5677 vdd vdd) p12 w=2.4u l=0.13u
MN5690 (n5689 n5641 vss vss) n12 w=0.8u l=0.13u
MP5691 (n5689 n5641 vdd vdd) p12 w=2.4u l=0.13u
MN5693 (n5692 n5665 vss vss) n12 w=0.8u l=0.13u
MP5694 (n5692 n5665 vdd vdd) p12 w=2.4u l=0.13u
MN5697 (n5695 n5689 vss vss) n12 w=0.8u l=0.13u
MN5698 (n5695 n5692 vss vss) n12 w=0.8u l=0.13u
MP5699 (n5695 n5689 n5696 vdd) p12 w=4.8u l=0.13u
MP5700 (n5696 n5692 vdd vdd) p12 w=4.8u l=0.13u
MN5702 (n5701 n5695 vss vss) n12 w=0.8u l=0.13u
MP5703 (n5701 n5695 vdd vdd) p12 w=2.4u l=0.13u
MN5705 (n5704 cd5 vss vss) n12 w=0.8u l=0.13u
MP5706 (n5704 cd5 vdd vdd) p12 w=2.4u l=0.13u
MN5709 (n5707 cg5 n5708 vss) n12 w=1.6u l=0.13u
MN5710 (n5708 n5704 vss vss) n12 w=1.6u l=0.13u
MP5711 (n5707 cg5 vdd vdd) p12 w=2.4u l=0.13u
MP5712 (n5707 n5704 vdd vdd) p12 w=2.4u l=0.13u
MN5715 (n5713 cg5 n5714 vss) n12 w=1.6u l=0.13u
MN5716 (n5714 n5707 vss vss) n12 w=1.6u l=0.13u
MP5717 (n5713 cg5 vdd vdd) p12 w=2.4u l=0.13u
MP5718 (n5713 n5707 vdd vdd) p12 w=2.4u l=0.13u
MN5721 (n5719 n5704 n5720 vss) n12 w=1.6u l=0.13u
MN5722 (n5720 n5707 vss vss) n12 w=1.6u l=0.13u
MP5723 (n5719 n5704 vdd vdd) p12 w=2.4u l=0.13u
MP5724 (n5719 n5707 vdd vdd) p12 w=2.4u l=0.13u
MN5727 (n5725 n5713 n5726 vss) n12 w=1.6u l=0.13u
MN5728 (n5726 n5719 vss vss) n12 w=1.6u l=0.13u
MP5729 (n5725 n5713 vdd vdd) p12 w=2.4u l=0.13u
MP5730 (n5725 n5719 vdd vdd) p12 w=2.4u l=0.13u
MN5733 (n5731 n5701 n5732 vss) n12 w=1.6u l=0.13u
MN5734 (n5732 n5725 vss vss) n12 w=1.6u l=0.13u
MP5735 (n5731 n5701 vdd vdd) p12 w=2.4u l=0.13u
MP5736 (n5731 n5725 vdd vdd) p12 w=2.4u l=0.13u
MN5739 (n5737 n5701 n5738 vss) n12 w=1.6u l=0.13u
MN5740 (n5738 n5731 vss vss) n12 w=1.6u l=0.13u
MP5741 (n5737 n5701 vdd vdd) p12 w=2.4u l=0.13u
MP5742 (n5737 n5731 vdd vdd) p12 w=2.4u l=0.13u
MN5745 (n5743 n5725 n5744 vss) n12 w=1.6u l=0.13u
MN5746 (n5744 n5731 vss vss) n12 w=1.6u l=0.13u
MP5747 (n5743 n5725 vdd vdd) p12 w=2.4u l=0.13u
MP5748 (n5743 n5731 vdd vdd) p12 w=2.4u l=0.13u
MN5751 (n5749 n5737 n5750 vss) n12 w=1.6u l=0.13u
MN5752 (n5750 n5743 vss vss) n12 w=1.6u l=0.13u
MP5753 (n5749 n5737 vdd vdd) p12 w=2.4u l=0.13u
MP5754 (n5749 n5743 vdd vdd) p12 w=2.4u l=0.13u
MN5756 (n5755 n5707 vss vss) n12 w=0.8u l=0.13u
MP5757 (n5755 n5707 vdd vdd) p12 w=2.4u l=0.13u
MN5759 (n5758 n5731 vss vss) n12 w=0.8u l=0.13u
MP5760 (n5758 n5731 vdd vdd) p12 w=2.4u l=0.13u
MN5763 (n5761 n5755 vss vss) n12 w=0.8u l=0.13u
MN5764 (n5761 n5758 vss vss) n12 w=0.8u l=0.13u
MP5765 (n5761 n5755 n5762 vdd) p12 w=4.8u l=0.13u
MP5766 (n5762 n5758 vdd vdd) p12 w=4.8u l=0.13u
MN5768 (n5767 n5761 vss vss) n12 w=0.8u l=0.13u
MP5769 (n5767 n5761 vdd vdd) p12 w=2.4u l=0.13u
MN5771 (n5770 cd6 vss vss) n12 w=0.8u l=0.13u
MP5772 (n5770 cd6 vdd vdd) p12 w=2.4u l=0.13u
MN5775 (n5773 cg6 n5774 vss) n12 w=1.6u l=0.13u
MN5776 (n5774 n5770 vss vss) n12 w=1.6u l=0.13u
MP5777 (n5773 cg6 vdd vdd) p12 w=2.4u l=0.13u
MP5778 (n5773 n5770 vdd vdd) p12 w=2.4u l=0.13u
MN5781 (n5779 cg6 n5780 vss) n12 w=1.6u l=0.13u
MN5782 (n5780 n5773 vss vss) n12 w=1.6u l=0.13u
MP5783 (n5779 cg6 vdd vdd) p12 w=2.4u l=0.13u
MP5784 (n5779 n5773 vdd vdd) p12 w=2.4u l=0.13u
MN5787 (n5785 n5770 n5786 vss) n12 w=1.6u l=0.13u
MN5788 (n5786 n5773 vss vss) n12 w=1.6u l=0.13u
MP5789 (n5785 n5770 vdd vdd) p12 w=2.4u l=0.13u
MP5790 (n5785 n5773 vdd vdd) p12 w=2.4u l=0.13u
MN5793 (n5791 n5779 n5792 vss) n12 w=1.6u l=0.13u
MN5794 (n5792 n5785 vss vss) n12 w=1.6u l=0.13u
MP5795 (n5791 n5779 vdd vdd) p12 w=2.4u l=0.13u
MP5796 (n5791 n5785 vdd vdd) p12 w=2.4u l=0.13u
MN5799 (n5797 n5767 n5798 vss) n12 w=1.6u l=0.13u
MN5800 (n5798 n5791 vss vss) n12 w=1.6u l=0.13u
MP5801 (n5797 n5767 vdd vdd) p12 w=2.4u l=0.13u
MP5802 (n5797 n5791 vdd vdd) p12 w=2.4u l=0.13u
MN5805 (n5803 n5767 n5804 vss) n12 w=1.6u l=0.13u
MN5806 (n5804 n5797 vss vss) n12 w=1.6u l=0.13u
MP5807 (n5803 n5767 vdd vdd) p12 w=2.4u l=0.13u
MP5808 (n5803 n5797 vdd vdd) p12 w=2.4u l=0.13u
MN5811 (n5809 n5791 n5810 vss) n12 w=1.6u l=0.13u
MN5812 (n5810 n5797 vss vss) n12 w=1.6u l=0.13u
MP5813 (n5809 n5791 vdd vdd) p12 w=2.4u l=0.13u
MP5814 (n5809 n5797 vdd vdd) p12 w=2.4u l=0.13u
MN5817 (n5815 n5803 n5816 vss) n12 w=1.6u l=0.13u
MN5818 (n5816 n5809 vss vss) n12 w=1.6u l=0.13u
MP5819 (n5815 n5803 vdd vdd) p12 w=2.4u l=0.13u
MP5820 (n5815 n5809 vdd vdd) p12 w=2.4u l=0.13u
MN5822 (n5821 n5773 vss vss) n12 w=0.8u l=0.13u
MP5823 (n5821 n5773 vdd vdd) p12 w=2.4u l=0.13u
MN5825 (n5824 n5797 vss vss) n12 w=0.8u l=0.13u
MP5826 (n5824 n5797 vdd vdd) p12 w=2.4u l=0.13u
MN5829 (n5827 n5821 vss vss) n12 w=0.8u l=0.13u
MN5830 (n5827 n5824 vss vss) n12 w=0.8u l=0.13u
MP5831 (n5827 n5821 n5828 vdd) p12 w=4.8u l=0.13u
MP5832 (n5828 n5824 vdd vdd) p12 w=4.8u l=0.13u
MN5834 (n5833 n5827 vss vss) n12 w=0.8u l=0.13u
MP5835 (n5833 n5827 vdd vdd) p12 w=2.4u l=0.13u
MN5837 (n5836 cd7 vss vss) n12 w=0.8u l=0.13u
MP5838 (n5836 cd7 vdd vdd) p12 w=2.4u l=0.13u
MN5841 (n5839 cg7 n5840 vss) n12 w=1.6u l=0.13u
MN5842 (n5840 n5836 vss vss) n12 w=1.6u l=0.13u
MP5843 (n5839 cg7 vdd vdd) p12 w=2.4u l=0.13u
MP5844 (n5839 n5836 vdd vdd) p12 w=2.4u l=0.13u
MN5847 (n5845 cg7 n5846 vss) n12 w=1.6u l=0.13u
MN5848 (n5846 n5839 vss vss) n12 w=1.6u l=0.13u
MP5849 (n5845 cg7 vdd vdd) p12 w=2.4u l=0.13u
MP5850 (n5845 n5839 vdd vdd) p12 w=2.4u l=0.13u
MN5853 (n5851 n5836 n5852 vss) n12 w=1.6u l=0.13u
MN5854 (n5852 n5839 vss vss) n12 w=1.6u l=0.13u
MP5855 (n5851 n5836 vdd vdd) p12 w=2.4u l=0.13u
MP5856 (n5851 n5839 vdd vdd) p12 w=2.4u l=0.13u
MN5859 (n5857 n5845 n5858 vss) n12 w=1.6u l=0.13u
MN5860 (n5858 n5851 vss vss) n12 w=1.6u l=0.13u
MP5861 (n5857 n5845 vdd vdd) p12 w=2.4u l=0.13u
MP5862 (n5857 n5851 vdd vdd) p12 w=2.4u l=0.13u
MN5865 (n5863 n5833 n5864 vss) n12 w=1.6u l=0.13u
MN5866 (n5864 n5857 vss vss) n12 w=1.6u l=0.13u
MP5867 (n5863 n5833 vdd vdd) p12 w=2.4u l=0.13u
MP5868 (n5863 n5857 vdd vdd) p12 w=2.4u l=0.13u
MN5871 (n5869 n5833 n5870 vss) n12 w=1.6u l=0.13u
MN5872 (n5870 n5863 vss vss) n12 w=1.6u l=0.13u
MP5873 (n5869 n5833 vdd vdd) p12 w=2.4u l=0.13u
MP5874 (n5869 n5863 vdd vdd) p12 w=2.4u l=0.13u
MN5877 (n5875 n5857 n5876 vss) n12 w=1.6u l=0.13u
MN5878 (n5876 n5863 vss vss) n12 w=1.6u l=0.13u
MP5879 (n5875 n5857 vdd vdd) p12 w=2.4u l=0.13u
MP5880 (n5875 n5863 vdd vdd) p12 w=2.4u l=0.13u
MN5883 (n5881 n5869 n5882 vss) n12 w=1.6u l=0.13u
MN5884 (n5882 n5875 vss vss) n12 w=1.6u l=0.13u
MP5885 (n5881 n5869 vdd vdd) p12 w=2.4u l=0.13u
MP5886 (n5881 n5875 vdd vdd) p12 w=2.4u l=0.13u
MN5888 (n5887 n5839 vss vss) n12 w=0.8u l=0.13u
MP5889 (n5887 n5839 vdd vdd) p12 w=2.4u l=0.13u
MN5891 (n5890 n5863 vss vss) n12 w=0.8u l=0.13u
MP5892 (n5890 n5863 vdd vdd) p12 w=2.4u l=0.13u
MN5895 (n5893 n5887 vss vss) n12 w=0.8u l=0.13u
MN5896 (n5893 n5890 vss vss) n12 w=0.8u l=0.13u
MP5897 (n5893 n5887 n5894 vdd) p12 w=4.8u l=0.13u
MP5898 (n5894 n5890 vdd vdd) p12 w=4.8u l=0.13u
MN5900 (n5899 n5893 vss vss) n12 w=0.8u l=0.13u
MP5901 (n5899 n5893 vdd vdd) p12 w=2.4u l=0.13u
MN5903 (n5902 cd8 vss vss) n12 w=0.8u l=0.13u
MP5904 (n5902 cd8 vdd vdd) p12 w=2.4u l=0.13u
MN5907 (n5905 cg8 n5906 vss) n12 w=1.6u l=0.13u
MN5908 (n5906 n5902 vss vss) n12 w=1.6u l=0.13u
MP5909 (n5905 cg8 vdd vdd) p12 w=2.4u l=0.13u
MP5910 (n5905 n5902 vdd vdd) p12 w=2.4u l=0.13u
MN5913 (n5911 cg8 n5912 vss) n12 w=1.6u l=0.13u
MN5914 (n5912 n5905 vss vss) n12 w=1.6u l=0.13u
MP5915 (n5911 cg8 vdd vdd) p12 w=2.4u l=0.13u
MP5916 (n5911 n5905 vdd vdd) p12 w=2.4u l=0.13u
MN5919 (n5917 n5902 n5918 vss) n12 w=1.6u l=0.13u
MN5920 (n5918 n5905 vss vss) n12 w=1.6u l=0.13u
MP5921 (n5917 n5902 vdd vdd) p12 w=2.4u l=0.13u
MP5922 (n5917 n5905 vdd vdd) p12 w=2.4u l=0.13u
MN5925 (n5923 n5911 n5924 vss) n12 w=1.6u l=0.13u
MN5926 (n5924 n5917 vss vss) n12 w=1.6u l=0.13u
MP5927 (n5923 n5911 vdd vdd) p12 w=2.4u l=0.13u
MP5928 (n5923 n5917 vdd vdd) p12 w=2.4u l=0.13u
MN5931 (n5929 n5899 n5930 vss) n12 w=1.6u l=0.13u
MN5932 (n5930 n5923 vss vss) n12 w=1.6u l=0.13u
MP5933 (n5929 n5899 vdd vdd) p12 w=2.4u l=0.13u
MP5934 (n5929 n5923 vdd vdd) p12 w=2.4u l=0.13u
MN5937 (n5935 n5899 n5936 vss) n12 w=1.6u l=0.13u
MN5938 (n5936 n5929 vss vss) n12 w=1.6u l=0.13u
MP5939 (n5935 n5899 vdd vdd) p12 w=2.4u l=0.13u
MP5940 (n5935 n5929 vdd vdd) p12 w=2.4u l=0.13u
MN5943 (n5941 n5923 n5942 vss) n12 w=1.6u l=0.13u
MN5944 (n5942 n5929 vss vss) n12 w=1.6u l=0.13u
MP5945 (n5941 n5923 vdd vdd) p12 w=2.4u l=0.13u
MP5946 (n5941 n5929 vdd vdd) p12 w=2.4u l=0.13u
MN5949 (n5947 n5935 n5948 vss) n12 w=1.6u l=0.13u
MN5950 (n5948 n5941 vss vss) n12 w=1.6u l=0.13u
MP5951 (n5947 n5935 vdd vdd) p12 w=2.4u l=0.13u
MP5952 (n5947 n5941 vdd vdd) p12 w=2.4u l=0.13u
MN5954 (n5953 n5905 vss vss) n12 w=0.8u l=0.13u
MP5955 (n5953 n5905 vdd vdd) p12 w=2.4u l=0.13u
MN5957 (n5956 n5929 vss vss) n12 w=0.8u l=0.13u
MP5958 (n5956 n5929 vdd vdd) p12 w=2.4u l=0.13u
MN5961 (n5959 n5953 vss vss) n12 w=0.8u l=0.13u
MN5962 (n5959 n5956 vss vss) n12 w=0.8u l=0.13u
MP5963 (n5959 n5953 n5960 vdd) p12 w=4.8u l=0.13u
MP5964 (n5960 n5956 vdd vdd) p12 w=4.8u l=0.13u
MN5966 (n5965 n5959 vss vss) n12 w=0.8u l=0.13u
MP5967 (n5965 n5959 vdd vdd) p12 w=2.4u l=0.13u
MN5970 (n5968 n5485 vss vss) n12 w=0.8u l=0.13u
MN5971 (n5968 n5551 vss vss) n12 w=0.8u l=0.13u
MP5972 (n5968 n5485 n5969 vdd) p12 w=4.8u l=0.13u
MP5973 (n5969 n5551 vdd vdd) p12 w=4.8u l=0.13u
MN5975 (n5974 n5968 vss vss) n12 w=0.8u l=0.13u
MP5976 (n5974 n5968 vdd vdd) p12 w=2.4u l=0.13u
MN5979 (n5977 n5617 vss vss) n12 w=0.8u l=0.13u
MN5980 (n5977 n5683 vss vss) n12 w=0.8u l=0.13u
MP5981 (n5977 n5617 n5978 vdd) p12 w=4.8u l=0.13u
MP5982 (n5978 n5683 vdd vdd) p12 w=4.8u l=0.13u
MN5984 (n5983 n5977 vss vss) n12 w=0.8u l=0.13u
MP5985 (n5983 n5977 vdd vdd) p12 w=2.4u l=0.13u
MN5988 (n5986 n5749 vss vss) n12 w=0.8u l=0.13u
MN5989 (n5986 n5815 vss vss) n12 w=0.8u l=0.13u
MP5990 (n5986 n5749 n5987 vdd) p12 w=4.8u l=0.13u
MP5991 (n5987 n5815 vdd vdd) p12 w=4.8u l=0.13u
MN5993 (n5992 n5986 vss vss) n12 w=0.8u l=0.13u
MP5994 (n5992 n5986 vdd vdd) p12 w=2.4u l=0.13u
MN5997 (n5995 n5881 vss vss) n12 w=0.8u l=0.13u
MN5998 (n5995 n5947 vss vss) n12 w=0.8u l=0.13u
MP5999 (n5995 n5881 n5996 vdd) p12 w=4.8u l=0.13u
MP6000 (n5996 n5947 vdd vdd) p12 w=4.8u l=0.13u
MN6002 (n6001 n5995 vss vss) n12 w=0.8u l=0.13u
MP6003 (n6001 n5995 vdd vdd) p12 w=2.4u l=0.13u
MN6006 (n6004 n5974 vss vss) n12 w=0.8u l=0.13u
MN6007 (n6004 n5983 vss vss) n12 w=0.8u l=0.13u
MP6008 (n6004 n5974 n6005 vdd) p12 w=4.8u l=0.13u
MP6009 (n6005 n5983 vdd vdd) p12 w=4.8u l=0.13u
MN6011 (n6010 n6004 vss vss) n12 w=0.8u l=0.13u
MP6012 (n6010 n6004 vdd vdd) p12 w=2.4u l=0.13u
MN6015 (n6013 n5992 vss vss) n12 w=0.8u l=0.13u
MN6016 (n6013 n6001 vss vss) n12 w=0.8u l=0.13u
MP6017 (n6013 n5992 n6014 vdd) p12 w=4.8u l=0.13u
MP6018 (n6014 n6001 vdd vdd) p12 w=4.8u l=0.13u
MN6020 (n6019 n6013 vss vss) n12 w=0.8u l=0.13u
MP6021 (n6019 n6013 vdd vdd) p12 w=2.4u l=0.13u
MN6024 (n6022 n6010 vss vss) n12 w=0.8u l=0.13u
MN6025 (n6022 n6019 vss vss) n12 w=0.8u l=0.13u
MP6026 (n6022 n6010 n6023 vdd) p12 w=4.8u l=0.13u
MP6027 (n6023 n6019 vdd vdd) p12 w=4.8u l=0.13u
MN6029 (n6028 n6022 vss vss) n12 w=0.8u l=0.13u
MP6030 (n6028 n6022 vdd vdd) p12 w=2.4u l=0.13u
MN6033 (n6031 n5965 n6032 vss) n12 w=1.6u l=0.13u
MN6034 (n6032 n6028 vss vss) n12 w=1.6u l=0.13u
MP6035 (n6031 n5965 vdd vdd) p12 w=2.4u l=0.13u
MP6036 (n6031 n6028 vdd vdd) p12 w=2.4u l=0.13u
MN6038 (n6037 n6031 vss vss) n12 w=0.8u l=0.13u
MP6039 (n6037 n6031 vdd vdd) p12 w=2.4u l=0.13u
MN6041 (n6040 cl0 vss vss) n12 w=0.8u l=0.13u
MP6042 (n6040 cl0 vdd vdd) p12 w=2.4u l=0.13u
MN6045 (n6043 cd0 n6044 vss) n12 w=1.6u l=0.13u
MN6046 (n6044 n6040 vss vss) n12 w=1.6u l=0.13u
MP6047 (n6043 cd0 vdd vdd) p12 w=2.4u l=0.13u
MP6048 (n6043 n6040 vdd vdd) p12 w=2.4u l=0.13u
MN6051 (n6049 cd0 n6050 vss) n12 w=1.6u l=0.13u
MN6052 (n6050 n6043 vss vss) n12 w=1.6u l=0.13u
MP6053 (n6049 cd0 vdd vdd) p12 w=2.4u l=0.13u
MP6054 (n6049 n6043 vdd vdd) p12 w=2.4u l=0.13u
MN6057 (n6055 n6040 n6056 vss) n12 w=1.6u l=0.13u
MN6058 (n6056 n6043 vss vss) n12 w=1.6u l=0.13u
MP6059 (n6055 n6040 vdd vdd) p12 w=2.4u l=0.13u
MP6060 (n6055 n6043 vdd vdd) p12 w=2.4u l=0.13u
MN6063 (n6061 n6049 n6062 vss) n12 w=1.6u l=0.13u
MN6064 (n6062 n6055 vss vss) n12 w=1.6u l=0.13u
MP6065 (n6061 n6049 vdd vdd) p12 w=2.4u l=0.13u
MP6066 (n6061 n6055 vdd vdd) p12 w=2.4u l=0.13u
MN6068 (n6067 n6061 vss vss) n12 w=0.8u l=0.13u
MP6069 (n6067 n6061 vdd vdd) p12 w=2.4u l=0.13u
MN6071 (n6070 n6043 vss vss) n12 w=0.8u l=0.13u
MP6072 (n6070 n6043 vdd vdd) p12 w=2.4u l=0.13u
MN6075 (n6073 n6061 vss vss) n12 w=0.8u l=0.13u
MN6076 (n6073 n6070 vss vss) n12 w=0.8u l=0.13u
MP6077 (n6073 n6061 n6074 vdd) p12 w=4.8u l=0.13u
MP6078 (n6074 n6070 vdd vdd) p12 w=4.8u l=0.13u
MN6080 (n6079 n6073 vss vss) n12 w=0.8u l=0.13u
MP6081 (n6079 n6073 vdd vdd) p12 w=2.4u l=0.13u
MN6083 (n6082 cl1 vss vss) n12 w=0.8u l=0.13u
MP6084 (n6082 cl1 vdd vdd) p12 w=2.4u l=0.13u
MN6087 (n6085 cd1 n6086 vss) n12 w=1.6u l=0.13u
MN6088 (n6086 n6082 vss vss) n12 w=1.6u l=0.13u
MP6089 (n6085 cd1 vdd vdd) p12 w=2.4u l=0.13u
MP6090 (n6085 n6082 vdd vdd) p12 w=2.4u l=0.13u
MN6093 (n6091 cd1 n6092 vss) n12 w=1.6u l=0.13u
MN6094 (n6092 n6085 vss vss) n12 w=1.6u l=0.13u
MP6095 (n6091 cd1 vdd vdd) p12 w=2.4u l=0.13u
MP6096 (n6091 n6085 vdd vdd) p12 w=2.4u l=0.13u
MN6099 (n6097 n6082 n6098 vss) n12 w=1.6u l=0.13u
MN6100 (n6098 n6085 vss vss) n12 w=1.6u l=0.13u
MP6101 (n6097 n6082 vdd vdd) p12 w=2.4u l=0.13u
MP6102 (n6097 n6085 vdd vdd) p12 w=2.4u l=0.13u
MN6105 (n6103 n6091 n6104 vss) n12 w=1.6u l=0.13u
MN6106 (n6104 n6097 vss vss) n12 w=1.6u l=0.13u
MP6107 (n6103 n6091 vdd vdd) p12 w=2.4u l=0.13u
MP6108 (n6103 n6097 vdd vdd) p12 w=2.4u l=0.13u
MN6111 (n6109 n6079 n6110 vss) n12 w=1.6u l=0.13u
MN6112 (n6110 n6103 vss vss) n12 w=1.6u l=0.13u
MP6113 (n6109 n6079 vdd vdd) p12 w=2.4u l=0.13u
MP6114 (n6109 n6103 vdd vdd) p12 w=2.4u l=0.13u
MN6117 (n6115 n6079 n6116 vss) n12 w=1.6u l=0.13u
MN6118 (n6116 n6109 vss vss) n12 w=1.6u l=0.13u
MP6119 (n6115 n6079 vdd vdd) p12 w=2.4u l=0.13u
MP6120 (n6115 n6109 vdd vdd) p12 w=2.4u l=0.13u
MN6123 (n6121 n6103 n6122 vss) n12 w=1.6u l=0.13u
MN6124 (n6122 n6109 vss vss) n12 w=1.6u l=0.13u
MP6125 (n6121 n6103 vdd vdd) p12 w=2.4u l=0.13u
MP6126 (n6121 n6109 vdd vdd) p12 w=2.4u l=0.13u
MN6129 (n6127 n6115 n6128 vss) n12 w=1.6u l=0.13u
MN6130 (n6128 n6121 vss vss) n12 w=1.6u l=0.13u
MP6131 (n6127 n6115 vdd vdd) p12 w=2.4u l=0.13u
MP6132 (n6127 n6121 vdd vdd) p12 w=2.4u l=0.13u
MN6134 (n6133 n6085 vss vss) n12 w=0.8u l=0.13u
MP6135 (n6133 n6085 vdd vdd) p12 w=2.4u l=0.13u
MN6137 (n6136 n6109 vss vss) n12 w=0.8u l=0.13u
MP6138 (n6136 n6109 vdd vdd) p12 w=2.4u l=0.13u
MN6141 (n6139 n6133 vss vss) n12 w=0.8u l=0.13u
MN6142 (n6139 n6136 vss vss) n12 w=0.8u l=0.13u
MP6143 (n6139 n6133 n6140 vdd) p12 w=4.8u l=0.13u
MP6144 (n6140 n6136 vdd vdd) p12 w=4.8u l=0.13u
MN6146 (n6145 n6139 vss vss) n12 w=0.8u l=0.13u
MP6147 (n6145 n6139 vdd vdd) p12 w=2.4u l=0.13u
MN6149 (n6148 cl2 vss vss) n12 w=0.8u l=0.13u
MP6150 (n6148 cl2 vdd vdd) p12 w=2.4u l=0.13u
MN6153 (n6151 cd2 n6152 vss) n12 w=1.6u l=0.13u
MN6154 (n6152 n6148 vss vss) n12 w=1.6u l=0.13u
MP6155 (n6151 cd2 vdd vdd) p12 w=2.4u l=0.13u
MP6156 (n6151 n6148 vdd vdd) p12 w=2.4u l=0.13u
MN6159 (n6157 cd2 n6158 vss) n12 w=1.6u l=0.13u
MN6160 (n6158 n6151 vss vss) n12 w=1.6u l=0.13u
MP6161 (n6157 cd2 vdd vdd) p12 w=2.4u l=0.13u
MP6162 (n6157 n6151 vdd vdd) p12 w=2.4u l=0.13u
MN6165 (n6163 n6148 n6164 vss) n12 w=1.6u l=0.13u
MN6166 (n6164 n6151 vss vss) n12 w=1.6u l=0.13u
MP6167 (n6163 n6148 vdd vdd) p12 w=2.4u l=0.13u
MP6168 (n6163 n6151 vdd vdd) p12 w=2.4u l=0.13u
MN6171 (n6169 n6157 n6170 vss) n12 w=1.6u l=0.13u
MN6172 (n6170 n6163 vss vss) n12 w=1.6u l=0.13u
MP6173 (n6169 n6157 vdd vdd) p12 w=2.4u l=0.13u
MP6174 (n6169 n6163 vdd vdd) p12 w=2.4u l=0.13u
MN6177 (n6175 n6145 n6176 vss) n12 w=1.6u l=0.13u
MN6178 (n6176 n6169 vss vss) n12 w=1.6u l=0.13u
MP6179 (n6175 n6145 vdd vdd) p12 w=2.4u l=0.13u
MP6180 (n6175 n6169 vdd vdd) p12 w=2.4u l=0.13u
MN6183 (n6181 n6145 n6182 vss) n12 w=1.6u l=0.13u
MN6184 (n6182 n6175 vss vss) n12 w=1.6u l=0.13u
MP6185 (n6181 n6145 vdd vdd) p12 w=2.4u l=0.13u
MP6186 (n6181 n6175 vdd vdd) p12 w=2.4u l=0.13u
MN6189 (n6187 n6169 n6188 vss) n12 w=1.6u l=0.13u
MN6190 (n6188 n6175 vss vss) n12 w=1.6u l=0.13u
MP6191 (n6187 n6169 vdd vdd) p12 w=2.4u l=0.13u
MP6192 (n6187 n6175 vdd vdd) p12 w=2.4u l=0.13u
MN6195 (n6193 n6181 n6194 vss) n12 w=1.6u l=0.13u
MN6196 (n6194 n6187 vss vss) n12 w=1.6u l=0.13u
MP6197 (n6193 n6181 vdd vdd) p12 w=2.4u l=0.13u
MP6198 (n6193 n6187 vdd vdd) p12 w=2.4u l=0.13u
MN6200 (n6199 n6151 vss vss) n12 w=0.8u l=0.13u
MP6201 (n6199 n6151 vdd vdd) p12 w=2.4u l=0.13u
MN6203 (n6202 n6175 vss vss) n12 w=0.8u l=0.13u
MP6204 (n6202 n6175 vdd vdd) p12 w=2.4u l=0.13u
MN6207 (n6205 n6199 vss vss) n12 w=0.8u l=0.13u
MN6208 (n6205 n6202 vss vss) n12 w=0.8u l=0.13u
MP6209 (n6205 n6199 n6206 vdd) p12 w=4.8u l=0.13u
MP6210 (n6206 n6202 vdd vdd) p12 w=4.8u l=0.13u
MN6212 (n6211 n6205 vss vss) n12 w=0.8u l=0.13u
MP6213 (n6211 n6205 vdd vdd) p12 w=2.4u l=0.13u
MN6215 (n6214 cl3 vss vss) n12 w=0.8u l=0.13u
MP6216 (n6214 cl3 vdd vdd) p12 w=2.4u l=0.13u
MN6219 (n6217 cd3 n6218 vss) n12 w=1.6u l=0.13u
MN6220 (n6218 n6214 vss vss) n12 w=1.6u l=0.13u
MP6221 (n6217 cd3 vdd vdd) p12 w=2.4u l=0.13u
MP6222 (n6217 n6214 vdd vdd) p12 w=2.4u l=0.13u
MN6225 (n6223 cd3 n6224 vss) n12 w=1.6u l=0.13u
MN6226 (n6224 n6217 vss vss) n12 w=1.6u l=0.13u
MP6227 (n6223 cd3 vdd vdd) p12 w=2.4u l=0.13u
MP6228 (n6223 n6217 vdd vdd) p12 w=2.4u l=0.13u
MN6231 (n6229 n6214 n6230 vss) n12 w=1.6u l=0.13u
MN6232 (n6230 n6217 vss vss) n12 w=1.6u l=0.13u
MP6233 (n6229 n6214 vdd vdd) p12 w=2.4u l=0.13u
MP6234 (n6229 n6217 vdd vdd) p12 w=2.4u l=0.13u
MN6237 (n6235 n6223 n6236 vss) n12 w=1.6u l=0.13u
MN6238 (n6236 n6229 vss vss) n12 w=1.6u l=0.13u
MP6239 (n6235 n6223 vdd vdd) p12 w=2.4u l=0.13u
MP6240 (n6235 n6229 vdd vdd) p12 w=2.4u l=0.13u
MN6243 (n6241 n6211 n6242 vss) n12 w=1.6u l=0.13u
MN6244 (n6242 n6235 vss vss) n12 w=1.6u l=0.13u
MP6245 (n6241 n6211 vdd vdd) p12 w=2.4u l=0.13u
MP6246 (n6241 n6235 vdd vdd) p12 w=2.4u l=0.13u
MN6249 (n6247 n6211 n6248 vss) n12 w=1.6u l=0.13u
MN6250 (n6248 n6241 vss vss) n12 w=1.6u l=0.13u
MP6251 (n6247 n6211 vdd vdd) p12 w=2.4u l=0.13u
MP6252 (n6247 n6241 vdd vdd) p12 w=2.4u l=0.13u
MN6255 (n6253 n6235 n6254 vss) n12 w=1.6u l=0.13u
MN6256 (n6254 n6241 vss vss) n12 w=1.6u l=0.13u
MP6257 (n6253 n6235 vdd vdd) p12 w=2.4u l=0.13u
MP6258 (n6253 n6241 vdd vdd) p12 w=2.4u l=0.13u
MN6261 (n6259 n6247 n6260 vss) n12 w=1.6u l=0.13u
MN6262 (n6260 n6253 vss vss) n12 w=1.6u l=0.13u
MP6263 (n6259 n6247 vdd vdd) p12 w=2.4u l=0.13u
MP6264 (n6259 n6253 vdd vdd) p12 w=2.4u l=0.13u
MN6266 (n6265 n6217 vss vss) n12 w=0.8u l=0.13u
MP6267 (n6265 n6217 vdd vdd) p12 w=2.4u l=0.13u
MN6269 (n6268 n6241 vss vss) n12 w=0.8u l=0.13u
MP6270 (n6268 n6241 vdd vdd) p12 w=2.4u l=0.13u
MN6273 (n6271 n6265 vss vss) n12 w=0.8u l=0.13u
MN6274 (n6271 n6268 vss vss) n12 w=0.8u l=0.13u
MP6275 (n6271 n6265 n6272 vdd) p12 w=4.8u l=0.13u
MP6276 (n6272 n6268 vdd vdd) p12 w=4.8u l=0.13u
MN6278 (n6277 n6271 vss vss) n12 w=0.8u l=0.13u
MP6279 (n6277 n6271 vdd vdd) p12 w=2.4u l=0.13u
MN6281 (n6280 cl4 vss vss) n12 w=0.8u l=0.13u
MP6282 (n6280 cl4 vdd vdd) p12 w=2.4u l=0.13u
MN6285 (n6283 cd4 n6284 vss) n12 w=1.6u l=0.13u
MN6286 (n6284 n6280 vss vss) n12 w=1.6u l=0.13u
MP6287 (n6283 cd4 vdd vdd) p12 w=2.4u l=0.13u
MP6288 (n6283 n6280 vdd vdd) p12 w=2.4u l=0.13u
MN6291 (n6289 cd4 n6290 vss) n12 w=1.6u l=0.13u
MN6292 (n6290 n6283 vss vss) n12 w=1.6u l=0.13u
MP6293 (n6289 cd4 vdd vdd) p12 w=2.4u l=0.13u
MP6294 (n6289 n6283 vdd vdd) p12 w=2.4u l=0.13u
MN6297 (n6295 n6280 n6296 vss) n12 w=1.6u l=0.13u
MN6298 (n6296 n6283 vss vss) n12 w=1.6u l=0.13u
MP6299 (n6295 n6280 vdd vdd) p12 w=2.4u l=0.13u
MP6300 (n6295 n6283 vdd vdd) p12 w=2.4u l=0.13u
MN6303 (n6301 n6289 n6302 vss) n12 w=1.6u l=0.13u
MN6304 (n6302 n6295 vss vss) n12 w=1.6u l=0.13u
MP6305 (n6301 n6289 vdd vdd) p12 w=2.4u l=0.13u
MP6306 (n6301 n6295 vdd vdd) p12 w=2.4u l=0.13u
MN6309 (n6307 n6277 n6308 vss) n12 w=1.6u l=0.13u
MN6310 (n6308 n6301 vss vss) n12 w=1.6u l=0.13u
MP6311 (n6307 n6277 vdd vdd) p12 w=2.4u l=0.13u
MP6312 (n6307 n6301 vdd vdd) p12 w=2.4u l=0.13u
MN6315 (n6313 n6277 n6314 vss) n12 w=1.6u l=0.13u
MN6316 (n6314 n6307 vss vss) n12 w=1.6u l=0.13u
MP6317 (n6313 n6277 vdd vdd) p12 w=2.4u l=0.13u
MP6318 (n6313 n6307 vdd vdd) p12 w=2.4u l=0.13u
MN6321 (n6319 n6301 n6320 vss) n12 w=1.6u l=0.13u
MN6322 (n6320 n6307 vss vss) n12 w=1.6u l=0.13u
MP6323 (n6319 n6301 vdd vdd) p12 w=2.4u l=0.13u
MP6324 (n6319 n6307 vdd vdd) p12 w=2.4u l=0.13u
MN6327 (n6325 n6313 n6326 vss) n12 w=1.6u l=0.13u
MN6328 (n6326 n6319 vss vss) n12 w=1.6u l=0.13u
MP6329 (n6325 n6313 vdd vdd) p12 w=2.4u l=0.13u
MP6330 (n6325 n6319 vdd vdd) p12 w=2.4u l=0.13u
MN6332 (n6331 n6283 vss vss) n12 w=0.8u l=0.13u
MP6333 (n6331 n6283 vdd vdd) p12 w=2.4u l=0.13u
MN6335 (n6334 n6307 vss vss) n12 w=0.8u l=0.13u
MP6336 (n6334 n6307 vdd vdd) p12 w=2.4u l=0.13u
MN6339 (n6337 n6331 vss vss) n12 w=0.8u l=0.13u
MN6340 (n6337 n6334 vss vss) n12 w=0.8u l=0.13u
MP6341 (n6337 n6331 n6338 vdd) p12 w=4.8u l=0.13u
MP6342 (n6338 n6334 vdd vdd) p12 w=4.8u l=0.13u
MN6344 (n6343 n6337 vss vss) n12 w=0.8u l=0.13u
MP6345 (n6343 n6337 vdd vdd) p12 w=2.4u l=0.13u
MN6347 (n6346 cl5 vss vss) n12 w=0.8u l=0.13u
MP6348 (n6346 cl5 vdd vdd) p12 w=2.4u l=0.13u
MN6351 (n6349 cd5 n6350 vss) n12 w=1.6u l=0.13u
MN6352 (n6350 n6346 vss vss) n12 w=1.6u l=0.13u
MP6353 (n6349 cd5 vdd vdd) p12 w=2.4u l=0.13u
MP6354 (n6349 n6346 vdd vdd) p12 w=2.4u l=0.13u
MN6357 (n6355 cd5 n6356 vss) n12 w=1.6u l=0.13u
MN6358 (n6356 n6349 vss vss) n12 w=1.6u l=0.13u
MP6359 (n6355 cd5 vdd vdd) p12 w=2.4u l=0.13u
MP6360 (n6355 n6349 vdd vdd) p12 w=2.4u l=0.13u
MN6363 (n6361 n6346 n6362 vss) n12 w=1.6u l=0.13u
MN6364 (n6362 n6349 vss vss) n12 w=1.6u l=0.13u
MP6365 (n6361 n6346 vdd vdd) p12 w=2.4u l=0.13u
MP6366 (n6361 n6349 vdd vdd) p12 w=2.4u l=0.13u
MN6369 (n6367 n6355 n6368 vss) n12 w=1.6u l=0.13u
MN6370 (n6368 n6361 vss vss) n12 w=1.6u l=0.13u
MP6371 (n6367 n6355 vdd vdd) p12 w=2.4u l=0.13u
MP6372 (n6367 n6361 vdd vdd) p12 w=2.4u l=0.13u
MN6375 (n6373 n6343 n6374 vss) n12 w=1.6u l=0.13u
MN6376 (n6374 n6367 vss vss) n12 w=1.6u l=0.13u
MP6377 (n6373 n6343 vdd vdd) p12 w=2.4u l=0.13u
MP6378 (n6373 n6367 vdd vdd) p12 w=2.4u l=0.13u
MN6381 (n6379 n6343 n6380 vss) n12 w=1.6u l=0.13u
MN6382 (n6380 n6373 vss vss) n12 w=1.6u l=0.13u
MP6383 (n6379 n6343 vdd vdd) p12 w=2.4u l=0.13u
MP6384 (n6379 n6373 vdd vdd) p12 w=2.4u l=0.13u
MN6387 (n6385 n6367 n6386 vss) n12 w=1.6u l=0.13u
MN6388 (n6386 n6373 vss vss) n12 w=1.6u l=0.13u
MP6389 (n6385 n6367 vdd vdd) p12 w=2.4u l=0.13u
MP6390 (n6385 n6373 vdd vdd) p12 w=2.4u l=0.13u
MN6393 (n6391 n6379 n6392 vss) n12 w=1.6u l=0.13u
MN6394 (n6392 n6385 vss vss) n12 w=1.6u l=0.13u
MP6395 (n6391 n6379 vdd vdd) p12 w=2.4u l=0.13u
MP6396 (n6391 n6385 vdd vdd) p12 w=2.4u l=0.13u
MN6398 (n6397 n6349 vss vss) n12 w=0.8u l=0.13u
MP6399 (n6397 n6349 vdd vdd) p12 w=2.4u l=0.13u
MN6401 (n6400 n6373 vss vss) n12 w=0.8u l=0.13u
MP6402 (n6400 n6373 vdd vdd) p12 w=2.4u l=0.13u
MN6405 (n6403 n6397 vss vss) n12 w=0.8u l=0.13u
MN6406 (n6403 n6400 vss vss) n12 w=0.8u l=0.13u
MP6407 (n6403 n6397 n6404 vdd) p12 w=4.8u l=0.13u
MP6408 (n6404 n6400 vdd vdd) p12 w=4.8u l=0.13u
MN6410 (n6409 n6403 vss vss) n12 w=0.8u l=0.13u
MP6411 (n6409 n6403 vdd vdd) p12 w=2.4u l=0.13u
MN6413 (n6412 cl6 vss vss) n12 w=0.8u l=0.13u
MP6414 (n6412 cl6 vdd vdd) p12 w=2.4u l=0.13u
MN6417 (n6415 cd6 n6416 vss) n12 w=1.6u l=0.13u
MN6418 (n6416 n6412 vss vss) n12 w=1.6u l=0.13u
MP6419 (n6415 cd6 vdd vdd) p12 w=2.4u l=0.13u
MP6420 (n6415 n6412 vdd vdd) p12 w=2.4u l=0.13u
MN6423 (n6421 cd6 n6422 vss) n12 w=1.6u l=0.13u
MN6424 (n6422 n6415 vss vss) n12 w=1.6u l=0.13u
MP6425 (n6421 cd6 vdd vdd) p12 w=2.4u l=0.13u
MP6426 (n6421 n6415 vdd vdd) p12 w=2.4u l=0.13u
MN6429 (n6427 n6412 n6428 vss) n12 w=1.6u l=0.13u
MN6430 (n6428 n6415 vss vss) n12 w=1.6u l=0.13u
MP6431 (n6427 n6412 vdd vdd) p12 w=2.4u l=0.13u
MP6432 (n6427 n6415 vdd vdd) p12 w=2.4u l=0.13u
MN6435 (n6433 n6421 n6434 vss) n12 w=1.6u l=0.13u
MN6436 (n6434 n6427 vss vss) n12 w=1.6u l=0.13u
MP6437 (n6433 n6421 vdd vdd) p12 w=2.4u l=0.13u
MP6438 (n6433 n6427 vdd vdd) p12 w=2.4u l=0.13u
MN6441 (n6439 n6409 n6440 vss) n12 w=1.6u l=0.13u
MN6442 (n6440 n6433 vss vss) n12 w=1.6u l=0.13u
MP6443 (n6439 n6409 vdd vdd) p12 w=2.4u l=0.13u
MP6444 (n6439 n6433 vdd vdd) p12 w=2.4u l=0.13u
MN6447 (n6445 n6409 n6446 vss) n12 w=1.6u l=0.13u
MN6448 (n6446 n6439 vss vss) n12 w=1.6u l=0.13u
MP6449 (n6445 n6409 vdd vdd) p12 w=2.4u l=0.13u
MP6450 (n6445 n6439 vdd vdd) p12 w=2.4u l=0.13u
MN6453 (n6451 n6433 n6452 vss) n12 w=1.6u l=0.13u
MN6454 (n6452 n6439 vss vss) n12 w=1.6u l=0.13u
MP6455 (n6451 n6433 vdd vdd) p12 w=2.4u l=0.13u
MP6456 (n6451 n6439 vdd vdd) p12 w=2.4u l=0.13u
MN6459 (n6457 n6445 n6458 vss) n12 w=1.6u l=0.13u
MN6460 (n6458 n6451 vss vss) n12 w=1.6u l=0.13u
MP6461 (n6457 n6445 vdd vdd) p12 w=2.4u l=0.13u
MP6462 (n6457 n6451 vdd vdd) p12 w=2.4u l=0.13u
MN6464 (n6463 n6415 vss vss) n12 w=0.8u l=0.13u
MP6465 (n6463 n6415 vdd vdd) p12 w=2.4u l=0.13u
MN6467 (n6466 n6439 vss vss) n12 w=0.8u l=0.13u
MP6468 (n6466 n6439 vdd vdd) p12 w=2.4u l=0.13u
MN6471 (n6469 n6463 vss vss) n12 w=0.8u l=0.13u
MN6472 (n6469 n6466 vss vss) n12 w=0.8u l=0.13u
MP6473 (n6469 n6463 n6470 vdd) p12 w=4.8u l=0.13u
MP6474 (n6470 n6466 vdd vdd) p12 w=4.8u l=0.13u
MN6476 (n6475 n6469 vss vss) n12 w=0.8u l=0.13u
MP6477 (n6475 n6469 vdd vdd) p12 w=2.4u l=0.13u
MN6479 (n6478 cl7 vss vss) n12 w=0.8u l=0.13u
MP6480 (n6478 cl7 vdd vdd) p12 w=2.4u l=0.13u
MN6483 (n6481 cd7 n6482 vss) n12 w=1.6u l=0.13u
MN6484 (n6482 n6478 vss vss) n12 w=1.6u l=0.13u
MP6485 (n6481 cd7 vdd vdd) p12 w=2.4u l=0.13u
MP6486 (n6481 n6478 vdd vdd) p12 w=2.4u l=0.13u
MN6489 (n6487 cd7 n6488 vss) n12 w=1.6u l=0.13u
MN6490 (n6488 n6481 vss vss) n12 w=1.6u l=0.13u
MP6491 (n6487 cd7 vdd vdd) p12 w=2.4u l=0.13u
MP6492 (n6487 n6481 vdd vdd) p12 w=2.4u l=0.13u
MN6495 (n6493 n6478 n6494 vss) n12 w=1.6u l=0.13u
MN6496 (n6494 n6481 vss vss) n12 w=1.6u l=0.13u
MP6497 (n6493 n6478 vdd vdd) p12 w=2.4u l=0.13u
MP6498 (n6493 n6481 vdd vdd) p12 w=2.4u l=0.13u
MN6501 (n6499 n6487 n6500 vss) n12 w=1.6u l=0.13u
MN6502 (n6500 n6493 vss vss) n12 w=1.6u l=0.13u
MP6503 (n6499 n6487 vdd vdd) p12 w=2.4u l=0.13u
MP6504 (n6499 n6493 vdd vdd) p12 w=2.4u l=0.13u
MN6507 (n6505 n6475 n6506 vss) n12 w=1.6u l=0.13u
MN6508 (n6506 n6499 vss vss) n12 w=1.6u l=0.13u
MP6509 (n6505 n6475 vdd vdd) p12 w=2.4u l=0.13u
MP6510 (n6505 n6499 vdd vdd) p12 w=2.4u l=0.13u
MN6513 (n6511 n6475 n6512 vss) n12 w=1.6u l=0.13u
MN6514 (n6512 n6505 vss vss) n12 w=1.6u l=0.13u
MP6515 (n6511 n6475 vdd vdd) p12 w=2.4u l=0.13u
MP6516 (n6511 n6505 vdd vdd) p12 w=2.4u l=0.13u
MN6519 (n6517 n6499 n6518 vss) n12 w=1.6u l=0.13u
MN6520 (n6518 n6505 vss vss) n12 w=1.6u l=0.13u
MP6521 (n6517 n6499 vdd vdd) p12 w=2.4u l=0.13u
MP6522 (n6517 n6505 vdd vdd) p12 w=2.4u l=0.13u
MN6525 (n6523 n6511 n6524 vss) n12 w=1.6u l=0.13u
MN6526 (n6524 n6517 vss vss) n12 w=1.6u l=0.13u
MP6527 (n6523 n6511 vdd vdd) p12 w=2.4u l=0.13u
MP6528 (n6523 n6517 vdd vdd) p12 w=2.4u l=0.13u
MN6530 (n6529 n6481 vss vss) n12 w=0.8u l=0.13u
MP6531 (n6529 n6481 vdd vdd) p12 w=2.4u l=0.13u
MN6533 (n6532 n6505 vss vss) n12 w=0.8u l=0.13u
MP6534 (n6532 n6505 vdd vdd) p12 w=2.4u l=0.13u
MN6537 (n6535 n6529 vss vss) n12 w=0.8u l=0.13u
MN6538 (n6535 n6532 vss vss) n12 w=0.8u l=0.13u
MP6539 (n6535 n6529 n6536 vdd) p12 w=4.8u l=0.13u
MP6540 (n6536 n6532 vdd vdd) p12 w=4.8u l=0.13u
MN6542 (n6541 n6535 vss vss) n12 w=0.8u l=0.13u
MP6543 (n6541 n6535 vdd vdd) p12 w=2.4u l=0.13u
MN6545 (n6544 cl8 vss vss) n12 w=0.8u l=0.13u
MP6546 (n6544 cl8 vdd vdd) p12 w=2.4u l=0.13u
MN6549 (n6547 cd8 n6548 vss) n12 w=1.6u l=0.13u
MN6550 (n6548 n6544 vss vss) n12 w=1.6u l=0.13u
MP6551 (n6547 cd8 vdd vdd) p12 w=2.4u l=0.13u
MP6552 (n6547 n6544 vdd vdd) p12 w=2.4u l=0.13u
MN6555 (n6553 cd8 n6554 vss) n12 w=1.6u l=0.13u
MN6556 (n6554 n6547 vss vss) n12 w=1.6u l=0.13u
MP6557 (n6553 cd8 vdd vdd) p12 w=2.4u l=0.13u
MP6558 (n6553 n6547 vdd vdd) p12 w=2.4u l=0.13u
MN6561 (n6559 n6544 n6560 vss) n12 w=1.6u l=0.13u
MN6562 (n6560 n6547 vss vss) n12 w=1.6u l=0.13u
MP6563 (n6559 n6544 vdd vdd) p12 w=2.4u l=0.13u
MP6564 (n6559 n6547 vdd vdd) p12 w=2.4u l=0.13u
MN6567 (n6565 n6553 n6566 vss) n12 w=1.6u l=0.13u
MN6568 (n6566 n6559 vss vss) n12 w=1.6u l=0.13u
MP6569 (n6565 n6553 vdd vdd) p12 w=2.4u l=0.13u
MP6570 (n6565 n6559 vdd vdd) p12 w=2.4u l=0.13u
MN6573 (n6571 n6541 n6572 vss) n12 w=1.6u l=0.13u
MN6574 (n6572 n6565 vss vss) n12 w=1.6u l=0.13u
MP6575 (n6571 n6541 vdd vdd) p12 w=2.4u l=0.13u
MP6576 (n6571 n6565 vdd vdd) p12 w=2.4u l=0.13u
MN6579 (n6577 n6541 n6578 vss) n12 w=1.6u l=0.13u
MN6580 (n6578 n6571 vss vss) n12 w=1.6u l=0.13u
MP6581 (n6577 n6541 vdd vdd) p12 w=2.4u l=0.13u
MP6582 (n6577 n6571 vdd vdd) p12 w=2.4u l=0.13u
MN6585 (n6583 n6565 n6584 vss) n12 w=1.6u l=0.13u
MN6586 (n6584 n6571 vss vss) n12 w=1.6u l=0.13u
MP6587 (n6583 n6565 vdd vdd) p12 w=2.4u l=0.13u
MP6588 (n6583 n6571 vdd vdd) p12 w=2.4u l=0.13u
MN6591 (n6589 n6577 n6590 vss) n12 w=1.6u l=0.13u
MN6592 (n6590 n6583 vss vss) n12 w=1.6u l=0.13u
MP6593 (n6589 n6577 vdd vdd) p12 w=2.4u l=0.13u
MP6594 (n6589 n6583 vdd vdd) p12 w=2.4u l=0.13u
MN6596 (n6595 n6547 vss vss) n12 w=0.8u l=0.13u
MP6597 (n6595 n6547 vdd vdd) p12 w=2.4u l=0.13u
MN6599 (n6598 n6571 vss vss) n12 w=0.8u l=0.13u
MP6600 (n6598 n6571 vdd vdd) p12 w=2.4u l=0.13u
MN6603 (n6601 n6595 vss vss) n12 w=0.8u l=0.13u
MN6604 (n6601 n6598 vss vss) n12 w=0.8u l=0.13u
MP6605 (n6601 n6595 n6602 vdd) p12 w=4.8u l=0.13u
MP6606 (n6602 n6598 vdd vdd) p12 w=4.8u l=0.13u
MN6608 (n6607 n6601 vss vss) n12 w=0.8u l=0.13u
MP6609 (n6607 n6601 vdd vdd) p12 w=2.4u l=0.13u
MN6612 (n6610 n6127 vss vss) n12 w=0.8u l=0.13u
MN6613 (n6610 n6193 vss vss) n12 w=0.8u l=0.13u
MP6614 (n6610 n6127 n6611 vdd) p12 w=4.8u l=0.13u
MP6615 (n6611 n6193 vdd vdd) p12 w=4.8u l=0.13u
MN6617 (n6616 n6610 vss vss) n12 w=0.8u l=0.13u
MP6618 (n6616 n6610 vdd vdd) p12 w=2.4u l=0.13u
MN6621 (n6619 n6259 vss vss) n12 w=0.8u l=0.13u
MN6622 (n6619 n6325 vss vss) n12 w=0.8u l=0.13u
MP6623 (n6619 n6259 n6620 vdd) p12 w=4.8u l=0.13u
MP6624 (n6620 n6325 vdd vdd) p12 w=4.8u l=0.13u
MN6626 (n6625 n6619 vss vss) n12 w=0.8u l=0.13u
MP6627 (n6625 n6619 vdd vdd) p12 w=2.4u l=0.13u
MN6630 (n6628 n6391 vss vss) n12 w=0.8u l=0.13u
MN6631 (n6628 n6457 vss vss) n12 w=0.8u l=0.13u
MP6632 (n6628 n6391 n6629 vdd) p12 w=4.8u l=0.13u
MP6633 (n6629 n6457 vdd vdd) p12 w=4.8u l=0.13u
MN6635 (n6634 n6628 vss vss) n12 w=0.8u l=0.13u
MP6636 (n6634 n6628 vdd vdd) p12 w=2.4u l=0.13u
MN6639 (n6637 n6523 vss vss) n12 w=0.8u l=0.13u
MN6640 (n6637 n6589 vss vss) n12 w=0.8u l=0.13u
MP6641 (n6637 n6523 n6638 vdd) p12 w=4.8u l=0.13u
MP6642 (n6638 n6589 vdd vdd) p12 w=4.8u l=0.13u
MN6644 (n6643 n6637 vss vss) n12 w=0.8u l=0.13u
MP6645 (n6643 n6637 vdd vdd) p12 w=2.4u l=0.13u
MN6648 (n6646 n6616 vss vss) n12 w=0.8u l=0.13u
MN6649 (n6646 n6625 vss vss) n12 w=0.8u l=0.13u
MP6650 (n6646 n6616 n6647 vdd) p12 w=4.8u l=0.13u
MP6651 (n6647 n6625 vdd vdd) p12 w=4.8u l=0.13u
MN6653 (n6652 n6646 vss vss) n12 w=0.8u l=0.13u
MP6654 (n6652 n6646 vdd vdd) p12 w=2.4u l=0.13u
MN6657 (n6655 n6634 vss vss) n12 w=0.8u l=0.13u
MN6658 (n6655 n6643 vss vss) n12 w=0.8u l=0.13u
MP6659 (n6655 n6634 n6656 vdd) p12 w=4.8u l=0.13u
MP6660 (n6656 n6643 vdd vdd) p12 w=4.8u l=0.13u
MN6662 (n6661 n6655 vss vss) n12 w=0.8u l=0.13u
MP6663 (n6661 n6655 vdd vdd) p12 w=2.4u l=0.13u
MN6666 (n6664 n6652 vss vss) n12 w=0.8u l=0.13u
MN6667 (n6664 n6661 vss vss) n12 w=0.8u l=0.13u
MP6668 (n6664 n6652 n6665 vdd) p12 w=4.8u l=0.13u
MP6669 (n6665 n6661 vdd vdd) p12 w=4.8u l=0.13u
MN6671 (n6670 n6664 vss vss) n12 w=0.8u l=0.13u
MP6672 (n6670 n6664 vdd vdd) p12 w=2.4u l=0.13u
MN6675 (n6673 n6607 n6674 vss) n12 w=1.6u l=0.13u
MN6676 (n6674 n6670 vss vss) n12 w=1.6u l=0.13u
MP6677 (n6673 n6607 vdd vdd) p12 w=2.4u l=0.13u
MP6678 (n6673 n6670 vdd vdd) p12 w=2.4u l=0.13u
MN6680 (n6679 n6673 vss vss) n12 w=0.8u l=0.13u
MP6681 (n6679 n6673 vdd vdd) p12 w=2.4u l=0.13u
MN6683 (n6682 n6037 vss vss) n12 w=0.8u l=0.13u
MP6684 (n6682 n6037 vdd vdd) p12 w=2.4u l=0.13u
MN6686 (n6685 n6682 vss vss) n12 w=0.8u l=0.13u
MP6687 (n6685 n6682 vdd vdd) p12 w=2.4u l=0.13u
MN6689 (n6688 n6685 vss vss) n12 w=0.8u l=0.13u
MP6690 (n6688 n6685 vdd vdd) p12 w=2.4u l=0.13u
MN6691 (slow_raw n6688 vss vss) n12 w=0.8u l=0.13u
MP6692 (slow_raw n6688 vdd vdd) p12 w=2.4u l=0.13u
MN6694 (n6693 n6679 vss vss) n12 w=0.8u l=0.13u
MP6695 (n6693 n6679 vdd vdd) p12 w=2.4u l=0.13u
MN6697 (n6696 n6693 vss vss) n12 w=0.8u l=0.13u
MP6698 (n6696 n6693 vdd vdd) p12 w=2.4u l=0.13u
MN6700 (n6699 n6696 vss vss) n12 w=0.8u l=0.13u
MP6701 (n6699 n6696 vdd vdd) p12 w=2.4u l=0.13u
MN6702 (fast_raw n6699 vss vss) n12 w=0.8u l=0.13u
MP6703 (fast_raw n6699 vdd vdd) p12 w=2.4u l=0.13u
MN6705 (n6704 measure vss vss) n12 w=0.8u l=0.13u
MP6706 (n6704 measure vdd vdd) p12 w=2.4u l=0.13u
MN6709 (n6707 n6704 vss vss) n12 w=0.8u l=0.13u
MN6710 (n6707 rst vss vss) n12 w=0.8u l=0.13u
MP6711 (n6707 n6704 n6708 vdd) p12 w=4.8u l=0.13u
MP6712 (n6708 rst vdd vdd) p12 w=4.8u l=0.13u
MN6714 (n6713 n6707 vss vss) n12 w=0.8u l=0.13u
MP6715 (n6713 n6707 vdd vdd) p12 w=2.4u l=0.13u
MN6717 (n6716 n6713 vss vss) n12 w=0.8u l=0.13u
MP6718 (n6716 n6713 vdd vdd) p12 w=2.4u l=0.13u
MN6727 (n6723 n22 n6724 vss) n12 w=3.2u l=0.13u
MP6728 (n6723 n22 vdd vdd) p12 w=2.4u l=0.13u
MN6729 (n6724 n102 n6725 vss) n12 w=3.2u l=0.13u
MP6730 (n6723 n102 vdd vdd) p12 w=2.4u l=0.13u
MN6731 (n6725 clk_highb6722 n6726 vss) n12 w=3.2u l=0.13u
MP6732 (n6723 clk_highb6722 vdd vdd) p12 w=2.4u l=0.13u
MN6733 (n6726 n6716 vss vss) n12 w=3.2u l=0.13u
MP6734 (n6723 n6716 vdd vdd) p12 w=2.4u l=0.13u
MN6739 (n6735 n19 n6736 vss) n12 w=3.2u l=0.13u
MP6740 (n6735 n19 vdd vdd) p12 w=2.4u l=0.13u
MN6741 (n6736 delay99 n6737 vss) n12 w=3.2u l=0.13u
MP6742 (n6735 delay99 vdd vdd) p12 w=2.4u l=0.13u
MN6743 (n6737 clk_lowb6720 n6738 vss) n12 w=3.2u l=0.13u
MP6744 (n6735 clk_lowb6720 vdd vdd) p12 w=2.4u l=0.13u
MN6745 (n6738 n6716 vss vss) n12 w=3.2u l=0.13u
MP6746 (n6735 n6716 vdd vdd) p12 w=2.4u l=0.13u
MN6747 (clk_low6719 n6723 vss vss) n12 w=8u l=0.13u
MP6748 (clk_low6719 n6723 vdd vdd) p12 w=24u l=0.13u
MN6749 (clk_lowb6720 clk_low6719 vss vss) n12 w=8u l=0.13u
MP6750 (clk_lowb6720 clk_low6719 vdd vdd) p12 w=24u l=0.13u
MN6751 (clk_high6721 n6735 vss vss) n12 w=8u l=0.13u
MP6752 (clk_high6721 n6735 vdd vdd) p12 w=24u l=0.13u
MN6753 (clk_highb6722 clk_high6721 vss vss) n12 w=8u l=0.13u
MP6754 (clk_highb6722 clk_high6721 vdd vdd) p12 w=24u l=0.13u
MN6759 (n6037 clk_low6719 storage6758 vss) n12 w=1.2u l=0.13u
MP6760 (n6037 clk_lowb6720 storage6758 vdd) p12 w=3.6u l=0.13u
MN6761 (qm6755 clk_high6721 storage6758 vss) n12 w=1.2u l=0.13u
MP6762 (qm6755 clk_highb6722 storage6758 vdd) p12 w=3.6u l=0.13u
MN6763 (qmb6756 storage6758 vss vss) n12 w=0.5u l=0.13u
MP6764 (qmb6756 storage6758 vdd vdd) p12 w=1.5u l=0.13u
MN6765 (qm6755 qmb6756 vss vss) n12 w=0.5u l=0.13u
MP6766 (qm6755 qmb6756 vdd vdd) p12 w=1.5u l=0.13u
MN6767 (storage6758 n6713 vss vss) n12 w=2u l=0.13u
MN6769 (qm6755 clk_high6721 storage6768 vss) n12 w=1.2u l=0.13u
MP6770 (qm6755 clk_highb6722 storage6768 vdd) p12 w=3.6u l=0.13u
MN6771 (slow_prev clk_low6719 storage6768 vss) n12 w=1.2u l=0.13u
MP6772 (slow_prev clk_lowb6720 storage6768 vdd) p12 w=3.6u l=0.13u
MN6773 (qb6757 storage6768 vss vss) n12 w=0.5u l=0.13u
MP6774 (qb6757 storage6768 vdd vdd) p12 w=1.5u l=0.13u
MN6775 (slow_prev qb6757 vss vss) n12 w=0.5u l=0.13u
MP6776 (slow_prev qb6757 vdd vdd) p12 w=1.5u l=0.13u
MN6777 (storage6768 n6713 vss vss) n12 w=2u l=0.13u
MN6782 (n6679 clk_low6719 storage6781 vss) n12 w=1.2u l=0.13u
MP6783 (n6679 clk_lowb6720 storage6781 vdd) p12 w=3.6u l=0.13u
MN6784 (qm6778 clk_high6721 storage6781 vss) n12 w=1.2u l=0.13u
MP6785 (qm6778 clk_highb6722 storage6781 vdd) p12 w=3.6u l=0.13u
MN6786 (qmb6779 storage6781 vss vss) n12 w=0.5u l=0.13u
MP6787 (qmb6779 storage6781 vdd vdd) p12 w=1.5u l=0.13u
MN6788 (qm6778 qmb6779 vss vss) n12 w=0.5u l=0.13u
MP6789 (qm6778 qmb6779 vdd vdd) p12 w=1.5u l=0.13u
MN6790 (storage6781 n6713 vss vss) n12 w=2u l=0.13u
MN6792 (qm6778 clk_high6721 storage6791 vss) n12 w=1.2u l=0.13u
MP6793 (qm6778 clk_highb6722 storage6791 vdd) p12 w=3.6u l=0.13u
MN6794 (fast_prev clk_low6719 storage6791 vss) n12 w=1.2u l=0.13u
MP6795 (fast_prev clk_lowb6720 storage6791 vdd) p12 w=3.6u l=0.13u
MN6796 (qb6780 storage6791 vss vss) n12 w=0.5u l=0.13u
MP6797 (qb6780 storage6791 vdd vdd) p12 w=1.5u l=0.13u
MN6798 (fast_prev qb6780 vss vss) n12 w=0.5u l=0.13u
MP6799 (fast_prev qb6780 vdd vdd) p12 w=1.5u l=0.13u
MN6800 (storage6791 n6713 vss vss) n12 w=2u l=0.13u
MN6803 (n6801 n6037 n6802 vss) n12 w=1.6u l=0.13u
MN6804 (n6802 slow_prev vss vss) n12 w=1.6u l=0.13u
MP6805 (n6801 n6037 vdd vdd) p12 w=2.4u l=0.13u
MP6806 (n6801 slow_prev vdd vdd) p12 w=2.4u l=0.13u
MN6808 (n6807 n6801 vss vss) n12 w=0.8u l=0.13u
MP6809 (n6807 n6801 vdd vdd) p12 w=2.4u l=0.13u
MN6812 (n6810 fast_prev n6811 vss) n12 w=1.6u l=0.13u
MN6813 (n6811 n6679 vss vss) n12 w=1.6u l=0.13u
MP6814 (n6810 fast_prev vdd vdd) p12 w=2.4u l=0.13u
MP6815 (n6810 n6679 vdd vdd) p12 w=2.4u l=0.13u
MN6817 (n6816 n6810 vss vss) n12 w=0.8u l=0.13u
MP6818 (n6816 n6810 vdd vdd) p12 w=2.4u l=0.13u
MN6820 (n6819 n6807 vss vss) n12 w=0.8u l=0.13u
MP6821 (n6819 n6807 vdd vdd) p12 w=2.4u l=0.13u
MN6823 (n6822 n6819 vss vss) n12 w=0.8u l=0.13u
MP6824 (n6822 n6819 vdd vdd) p12 w=2.4u l=0.13u
MN6826 (n6825 n6822 vss vss) n12 w=0.8u l=0.13u
MP6827 (n6825 n6822 vdd vdd) p12 w=2.4u l=0.13u
MN6828 (slow_qualified n6825 vss vss) n12 w=0.8u l=0.13u
MP6829 (slow_qualified n6825 vdd vdd) p12 w=2.4u l=0.13u
MN6831 (n6830 n6816 vss vss) n12 w=0.8u l=0.13u
MP6832 (n6830 n6816 vdd vdd) p12 w=2.4u l=0.13u
MN6834 (n6833 n6830 vss vss) n12 w=0.8u l=0.13u
MP6835 (n6833 n6830 vdd vdd) p12 w=2.4u l=0.13u
MN6837 (n6836 n6833 vss vss) n12 w=0.8u l=0.13u
MP6838 (n6836 n6833 vdd vdd) p12 w=2.4u l=0.13u
MN6839 (fast_qualified n6836 vss vss) n12 w=0.8u l=0.13u
MP6840 (fast_qualified n6836 vdd vdd) p12 w=2.4u l=0.13u
MN6843 (n6841 cg6 n6842 vss) n12 w=1.6u l=0.13u
MN6844 (n6842 cg7 vss vss) n12 w=1.6u l=0.13u
MP6845 (n6841 cg6 vdd vdd) p12 w=2.4u l=0.13u
MP6846 (n6841 cg7 vdd vdd) p12 w=2.4u l=0.13u
MN6848 (n6847 n6841 vss vss) n12 w=0.8u l=0.13u
MP6849 (n6847 n6841 vdd vdd) p12 w=2.4u l=0.13u
MN6852 (n6850 cg5 n6851 vss) n12 w=1.6u l=0.13u
MN6853 (n6851 n6847 vss vss) n12 w=1.6u l=0.13u
MP6854 (n6850 cg5 vdd vdd) p12 w=2.4u l=0.13u
MP6855 (n6850 n6847 vdd vdd) p12 w=2.4u l=0.13u
MN6857 (n6856 n6850 vss vss) n12 w=0.8u l=0.13u
MP6858 (n6856 n6850 vdd vdd) p12 w=2.4u l=0.13u
MN6861 (n6859 cg8 vss vss) n12 w=0.8u l=0.13u
MN6862 (n6859 n6856 vss vss) n12 w=0.8u l=0.13u
MP6863 (n6859 cg8 n6860 vdd) p12 w=4.8u l=0.13u
MP6864 (n6860 n6856 vdd vdd) p12 w=4.8u l=0.13u
MN6866 (n6865 n6859 vss vss) n12 w=0.8u l=0.13u
MP6867 (n6865 n6859 vdd vdd) p12 w=2.4u l=0.13u
MN6870 (n6868 n6807 n6869 vss) n12 w=1.6u l=0.13u
MN6871 (n6869 n6816 vss vss) n12 w=1.6u l=0.13u
MP6872 (n6868 n6807 vdd vdd) p12 w=2.4u l=0.13u
MP6873 (n6868 n6816 vdd vdd) p12 w=2.4u l=0.13u
MN6875 (n6874 n6868 vss vss) n12 w=0.8u l=0.13u
MP6876 (n6874 n6868 vdd vdd) p12 w=2.4u l=0.13u
MN6879 (n6877 n6807 vss vss) n12 w=0.8u l=0.13u
MN6880 (n6877 n6816 vss vss) n12 w=0.8u l=0.13u
MP6881 (n6877 n6807 n6878 vdd) p12 w=4.8u l=0.13u
MP6882 (n6878 n6816 vdd vdd) p12 w=4.8u l=0.13u
MN6884 (n6883 n6877 vss vss) n12 w=0.8u l=0.13u
MP6885 (n6883 n6877 vdd vdd) p12 w=2.4u l=0.13u
MN6888 (n6886 n6865 vss vss) n12 w=0.8u l=0.13u
MN6889 (n6886 n6883 vss vss) n12 w=0.8u l=0.13u
MP6890 (n6886 n6865 n6887 vdd) p12 w=4.8u l=0.13u
MP6891 (n6887 n6883 vdd vdd) p12 w=4.8u l=0.13u
MN6893 (n6892 n6886 vss vss) n12 w=0.8u l=0.13u
MP6894 (n6892 n6886 vdd vdd) p12 w=2.4u l=0.13u
MN6897 (n6895 measure n6896 vss) n12 w=1.6u l=0.13u
MN6898 (n6896 n6892 vss vss) n12 w=1.6u l=0.13u
MP6899 (n6895 measure vdd vdd) p12 w=2.4u l=0.13u
MP6900 (n6895 n6892 vdd vdd) p12 w=2.4u l=0.13u
MN6902 (n6901 n6895 vss vss) n12 w=0.8u l=0.13u
MP6903 (n6901 n6895 vdd vdd) p12 w=2.4u l=0.13u
MN6905 (n6904 n6901 vss vss) n12 w=0.8u l=0.13u
MP6906 (n6904 n6901 vdd vdd) p12 w=2.4u l=0.13u
MN6908 (n6907 n6904 vss vss) n12 w=0.8u l=0.13u
MP6909 (n6907 n6904 vdd vdd) p12 w=2.4u l=0.13u
MN6911 (n6910 n6907 vss vss) n12 w=0.8u l=0.13u
MP6912 (n6910 n6907 vdd vdd) p12 w=2.4u l=0.13u
MN6913 (decision n6910 vss vss) n12 w=0.8u l=0.13u
MP6914 (decision n6910 vdd vdd) p12 w=2.4u l=0.13u
MN6917 (n6915 n6816 n6916 vss) n12 w=1.6u l=0.13u
MN6918 (n6916 n6901 vss vss) n12 w=1.6u l=0.13u
MP6919 (n6915 n6816 vdd vdd) p12 w=2.4u l=0.13u
MP6920 (n6915 n6901 vdd vdd) p12 w=2.4u l=0.13u
MN6923 (n6921 n6904 n6922 vss) n12 w=1.6u l=0.13u
MN6924 (n6922 was_fast vss vss) n12 w=1.6u l=0.13u
MP6925 (n6921 n6904 vdd vdd) p12 w=2.4u l=0.13u
MP6926 (n6921 was_fast vdd vdd) p12 w=2.4u l=0.13u
MN6929 (n6927 n6915 n6928 vss) n12 w=1.6u l=0.13u
MN6930 (n6928 n6921 vss vss) n12 w=1.6u l=0.13u
MP6931 (n6927 n6915 vdd vdd) p12 w=2.4u l=0.13u
MP6932 (n6927 n6921 vdd vdd) p12 w=2.4u l=0.13u
MN6937 (n6927 clk_low108 storage6936 vss) n12 w=1.2u l=0.13u
MP6938 (n6927 clk_lowb109 storage6936 vdd) p12 w=3.6u l=0.13u
MN6939 (qm6933 clk_high110 storage6936 vss) n12 w=1.2u l=0.13u
MP6940 (qm6933 clk_highb111 storage6936 vdd) p12 w=3.6u l=0.13u
MN6941 (qmb6934 storage6936 vss vss) n12 w=0.5u l=0.13u
MP6942 (qmb6934 storage6936 vdd vdd) p12 w=1.5u l=0.13u
MN6943 (qm6933 qmb6934 vss vss) n12 w=0.5u l=0.13u
MP6944 (qm6933 qmb6934 vdd vdd) p12 w=1.5u l=0.13u
MN6945 (storage6936 rst vss vss) n12 w=2u l=0.13u
MN6947 (qm6933 clk_high110 storage6946 vss) n12 w=1.2u l=0.13u
MP6948 (qm6933 clk_highb111 storage6946 vdd) p12 w=3.6u l=0.13u
MN6949 (was_fast clk_low108 storage6946 vss) n12 w=1.2u l=0.13u
MP6950 (was_fast clk_lowb109 storage6946 vdd) p12 w=3.6u l=0.13u
MN6951 (qb6935 storage6946 vss vss) n12 w=0.5u l=0.13u
MP6952 (qb6935 storage6946 vdd vdd) p12 w=1.5u l=0.13u
MN6953 (was_fast qb6935 vss vss) n12 w=0.5u l=0.13u
MP6954 (was_fast qb6935 vdd vdd) p12 w=1.5u l=0.13u
MN6955 (storage6946 rst vss vss) n12 w=2u l=0.13u
MN6958 (n6956 n6807 n6957 vss) n12 w=1.6u l=0.13u
MN6959 (n6957 n6901 vss vss) n12 w=1.6u l=0.13u
MP6960 (n6956 n6807 vdd vdd) p12 w=2.4u l=0.13u
MP6961 (n6956 n6901 vdd vdd) p12 w=2.4u l=0.13u
MN6964 (n6962 n6904 n6963 vss) n12 w=1.6u l=0.13u
MN6965 (n6963 was_slow vss vss) n12 w=1.6u l=0.13u
MP6966 (n6962 n6904 vdd vdd) p12 w=2.4u l=0.13u
MP6967 (n6962 was_slow vdd vdd) p12 w=2.4u l=0.13u
MN6970 (n6968 n6956 n6969 vss) n12 w=1.6u l=0.13u
MN6971 (n6969 n6962 vss vss) n12 w=1.6u l=0.13u
MP6972 (n6968 n6956 vdd vdd) p12 w=2.4u l=0.13u
MP6973 (n6968 n6962 vdd vdd) p12 w=2.4u l=0.13u
MN6978 (n6968 clk_low108 storage6977 vss) n12 w=1.2u l=0.13u
MP6979 (n6968 clk_lowb109 storage6977 vdd) p12 w=3.6u l=0.13u
MN6980 (qm6974 clk_high110 storage6977 vss) n12 w=1.2u l=0.13u
MP6981 (qm6974 clk_highb111 storage6977 vdd) p12 w=3.6u l=0.13u
MN6982 (qmb6975 storage6977 vss vss) n12 w=0.5u l=0.13u
MP6983 (qmb6975 storage6977 vdd vdd) p12 w=1.5u l=0.13u
MN6984 (qm6974 qmb6975 vss vss) n12 w=0.5u l=0.13u
MP6985 (qm6974 qmb6975 vdd vdd) p12 w=1.5u l=0.13u
MN6986 (storage6977 rst vss vss) n12 w=2u l=0.13u
MN6988 (qm6974 clk_high110 storage6987 vss) n12 w=1.2u l=0.13u
MP6989 (qm6974 clk_highb111 storage6987 vdd) p12 w=3.6u l=0.13u
MN6990 (was_slow clk_low108 storage6987 vss) n12 w=1.2u l=0.13u
MP6991 (was_slow clk_lowb109 storage6987 vdd) p12 w=3.6u l=0.13u
MN6992 (qb6976 storage6987 vss vss) n12 w=0.5u l=0.13u
MP6993 (qb6976 storage6987 vdd vdd) p12 w=1.5u l=0.13u
MN6994 (was_slow qb6976 vss vss) n12 w=0.5u l=0.13u
MP6995 (was_slow qb6976 vdd vdd) p12 w=1.5u l=0.13u
MN6996 (storage6987 rst vss vss) n12 w=2u l=0.13u
MN6998 (n6997 n6883 vss vss) n12 w=0.8u l=0.13u
MP6999 (n6997 n6883 vdd vdd) p12 w=2.4u l=0.13u
MN7002 (n7000 n6865 n7001 vss) n12 w=1.6u l=0.13u
MN7003 (n7001 n6997 vss vss) n12 w=1.6u l=0.13u
MP7004 (n7000 n6865 vdd vdd) p12 w=2.4u l=0.13u
MP7005 (n7000 n6997 vdd vdd) p12 w=2.4u l=0.13u
MN7007 (n7006 n7000 vss vss) n12 w=0.8u l=0.13u
MP7008 (n7006 n7000 vdd vdd) p12 w=2.4u l=0.13u
MN7011 (n7009 n6901 n7010 vss) n12 w=1.6u l=0.13u
MN7012 (n7010 n7006 vss vss) n12 w=1.6u l=0.13u
MP7013 (n7009 n6901 vdd vdd) p12 w=2.4u l=0.13u
MP7014 (n7009 n7006 vdd vdd) p12 w=2.4u l=0.13u
MN7017 (n7015 n6904 n7016 vss) n12 w=1.6u l=0.13u
MN7018 (n7016 was_near vss vss) n12 w=1.6u l=0.13u
MP7019 (n7015 n6904 vdd vdd) p12 w=2.4u l=0.13u
MP7020 (n7015 was_near vdd vdd) p12 w=2.4u l=0.13u
MN7023 (n7021 n7009 n7022 vss) n12 w=1.6u l=0.13u
MN7024 (n7022 n7015 vss vss) n12 w=1.6u l=0.13u
MP7025 (n7021 n7009 vdd vdd) p12 w=2.4u l=0.13u
MP7026 (n7021 n7015 vdd vdd) p12 w=2.4u l=0.13u
MN7031 (n7021 clk_low108 storage7030 vss) n12 w=1.2u l=0.13u
MP7032 (n7021 clk_lowb109 storage7030 vdd) p12 w=3.6u l=0.13u
MN7033 (qm7027 clk_high110 storage7030 vss) n12 w=1.2u l=0.13u
MP7034 (qm7027 clk_highb111 storage7030 vdd) p12 w=3.6u l=0.13u
MN7035 (qmb7028 storage7030 vss vss) n12 w=0.5u l=0.13u
MP7036 (qmb7028 storage7030 vdd vdd) p12 w=1.5u l=0.13u
MN7037 (qm7027 qmb7028 vss vss) n12 w=0.5u l=0.13u
MP7038 (qm7027 qmb7028 vdd vdd) p12 w=1.5u l=0.13u
MN7039 (storage7030 rst vss vss) n12 w=2u l=0.13u
MN7041 (qm7027 clk_high110 storage7040 vss) n12 w=1.2u l=0.13u
MP7042 (qm7027 clk_highb111 storage7040 vdd) p12 w=3.6u l=0.13u
MN7043 (was_near clk_low108 storage7040 vss) n12 w=1.2u l=0.13u
MP7044 (was_near clk_lowb109 storage7040 vdd) p12 w=3.6u l=0.13u
MN7045 (qb7029 storage7040 vss vss) n12 w=0.5u l=0.13u
MP7046 (qb7029 storage7040 vdd vdd) p12 w=1.5u l=0.13u
MN7047 (was_near qb7029 vss vss) n12 w=0.5u l=0.13u
MP7048 (was_near qb7029 vdd vdd) p12 w=1.5u l=0.13u
MN7049 (storage7040 rst vss vss) n12 w=2u l=0.13u
MN7052 (n7050 cl0 n7051 vss) n12 w=1.6u l=0.13u
MN7053 (n7051 n6901 vss vss) n12 w=1.6u l=0.13u
MP7054 (n7050 cl0 vdd vdd) p12 w=2.4u l=0.13u
MP7055 (n7050 n6901 vdd vdd) p12 w=2.4u l=0.13u
MN7058 (n7056 dl0 n7057 vss) n12 w=1.6u l=0.13u
MN7059 (n7057 n6904 vss vss) n12 w=1.6u l=0.13u
MP7060 (n7056 dl0 vdd vdd) p12 w=2.4u l=0.13u
MP7061 (n7056 n6904 vdd vdd) p12 w=2.4u l=0.13u
MN7064 (n7062 n7050 n7063 vss) n12 w=1.6u l=0.13u
MN7065 (n7063 n7056 vss vss) n12 w=1.6u l=0.13u
MP7066 (n7062 n7050 vdd vdd) p12 w=2.4u l=0.13u
MP7067 (n7062 n7056 vdd vdd) p12 w=2.4u l=0.13u
MN7072 (n7062 clk_low108 storage7071 vss) n12 w=1.2u l=0.13u
MP7073 (n7062 clk_lowb109 storage7071 vdd) p12 w=3.6u l=0.13u
MN7074 (qm7068 clk_high110 storage7071 vss) n12 w=1.2u l=0.13u
MP7075 (qm7068 clk_highb111 storage7071 vdd) p12 w=3.6u l=0.13u
MN7076 (qmb7069 storage7071 vss vss) n12 w=0.5u l=0.13u
MP7077 (qmb7069 storage7071 vdd vdd) p12 w=1.5u l=0.13u
MN7078 (qm7068 qmb7069 vss vss) n12 w=0.5u l=0.13u
MP7079 (qm7068 qmb7069 vdd vdd) p12 w=1.5u l=0.13u
MN7080 (storage7071 rst vss vss) n12 w=2u l=0.13u
MN7082 (qm7068 clk_high110 storage7081 vss) n12 w=1.2u l=0.13u
MP7083 (qm7068 clk_highb111 storage7081 vdd) p12 w=3.6u l=0.13u
MN7084 (dl0 clk_low108 storage7081 vss) n12 w=1.2u l=0.13u
MP7085 (dl0 clk_lowb109 storage7081 vdd) p12 w=3.6u l=0.13u
MN7086 (qb7070 storage7081 vss vss) n12 w=0.5u l=0.13u
MP7087 (qb7070 storage7081 vdd vdd) p12 w=1.5u l=0.13u
MN7088 (dl0 qb7070 vss vss) n12 w=0.5u l=0.13u
MP7089 (dl0 qb7070 vdd vdd) p12 w=1.5u l=0.13u
MN7090 (storage7081 rst vss vss) n12 w=2u l=0.13u
MN7093 (n7091 cl1 n7092 vss) n12 w=1.6u l=0.13u
MN7094 (n7092 n6901 vss vss) n12 w=1.6u l=0.13u
MP7095 (n7091 cl1 vdd vdd) p12 w=2.4u l=0.13u
MP7096 (n7091 n6901 vdd vdd) p12 w=2.4u l=0.13u
MN7099 (n7097 dl1 n7098 vss) n12 w=1.6u l=0.13u
MN7100 (n7098 n6904 vss vss) n12 w=1.6u l=0.13u
MP7101 (n7097 dl1 vdd vdd) p12 w=2.4u l=0.13u
MP7102 (n7097 n6904 vdd vdd) p12 w=2.4u l=0.13u
MN7105 (n7103 n7091 n7104 vss) n12 w=1.6u l=0.13u
MN7106 (n7104 n7097 vss vss) n12 w=1.6u l=0.13u
MP7107 (n7103 n7091 vdd vdd) p12 w=2.4u l=0.13u
MP7108 (n7103 n7097 vdd vdd) p12 w=2.4u l=0.13u
MN7113 (n7103 clk_low108 storage7112 vss) n12 w=1.2u l=0.13u
MP7114 (n7103 clk_lowb109 storage7112 vdd) p12 w=3.6u l=0.13u
MN7115 (qm7109 clk_high110 storage7112 vss) n12 w=1.2u l=0.13u
MP7116 (qm7109 clk_highb111 storage7112 vdd) p12 w=3.6u l=0.13u
MN7117 (qmb7110 storage7112 vss vss) n12 w=0.5u l=0.13u
MP7118 (qmb7110 storage7112 vdd vdd) p12 w=1.5u l=0.13u
MN7119 (qm7109 qmb7110 vss vss) n12 w=0.5u l=0.13u
MP7120 (qm7109 qmb7110 vdd vdd) p12 w=1.5u l=0.13u
MN7121 (storage7112 rst vss vss) n12 w=2u l=0.13u
MN7123 (qm7109 clk_high110 storage7122 vss) n12 w=1.2u l=0.13u
MP7124 (qm7109 clk_highb111 storage7122 vdd) p12 w=3.6u l=0.13u
MN7125 (dl1 clk_low108 storage7122 vss) n12 w=1.2u l=0.13u
MP7126 (dl1 clk_lowb109 storage7122 vdd) p12 w=3.6u l=0.13u
MN7127 (qb7111 storage7122 vss vss) n12 w=0.5u l=0.13u
MP7128 (qb7111 storage7122 vdd vdd) p12 w=1.5u l=0.13u
MN7129 (dl1 qb7111 vss vss) n12 w=0.5u l=0.13u
MP7130 (dl1 qb7111 vdd vdd) p12 w=1.5u l=0.13u
MN7131 (storage7122 rst vss vss) n12 w=2u l=0.13u
MN7134 (n7132 cl2 n7133 vss) n12 w=1.6u l=0.13u
MN7135 (n7133 n6901 vss vss) n12 w=1.6u l=0.13u
MP7136 (n7132 cl2 vdd vdd) p12 w=2.4u l=0.13u
MP7137 (n7132 n6901 vdd vdd) p12 w=2.4u l=0.13u
MN7140 (n7138 dl2 n7139 vss) n12 w=1.6u l=0.13u
MN7141 (n7139 n6904 vss vss) n12 w=1.6u l=0.13u
MP7142 (n7138 dl2 vdd vdd) p12 w=2.4u l=0.13u
MP7143 (n7138 n6904 vdd vdd) p12 w=2.4u l=0.13u
MN7146 (n7144 n7132 n7145 vss) n12 w=1.6u l=0.13u
MN7147 (n7145 n7138 vss vss) n12 w=1.6u l=0.13u
MP7148 (n7144 n7132 vdd vdd) p12 w=2.4u l=0.13u
MP7149 (n7144 n7138 vdd vdd) p12 w=2.4u l=0.13u
MN7154 (n7144 clk_low108 storage7153 vss) n12 w=1.2u l=0.13u
MP7155 (n7144 clk_lowb109 storage7153 vdd) p12 w=3.6u l=0.13u
MN7156 (qm7150 clk_high110 storage7153 vss) n12 w=1.2u l=0.13u
MP7157 (qm7150 clk_highb111 storage7153 vdd) p12 w=3.6u l=0.13u
MN7158 (qmb7151 storage7153 vss vss) n12 w=0.5u l=0.13u
MP7159 (qmb7151 storage7153 vdd vdd) p12 w=1.5u l=0.13u
MN7160 (qm7150 qmb7151 vss vss) n12 w=0.5u l=0.13u
MP7161 (qm7150 qmb7151 vdd vdd) p12 w=1.5u l=0.13u
MN7162 (storage7153 rst vss vss) n12 w=2u l=0.13u
MN7164 (qm7150 clk_high110 storage7163 vss) n12 w=1.2u l=0.13u
MP7165 (qm7150 clk_highb111 storage7163 vdd) p12 w=3.6u l=0.13u
MN7166 (dl2 clk_low108 storage7163 vss) n12 w=1.2u l=0.13u
MP7167 (dl2 clk_lowb109 storage7163 vdd) p12 w=3.6u l=0.13u
MN7168 (qb7152 storage7163 vss vss) n12 w=0.5u l=0.13u
MP7169 (qb7152 storage7163 vdd vdd) p12 w=1.5u l=0.13u
MN7170 (dl2 qb7152 vss vss) n12 w=0.5u l=0.13u
MP7171 (dl2 qb7152 vdd vdd) p12 w=1.5u l=0.13u
MN7172 (storage7163 rst vss vss) n12 w=2u l=0.13u
MN7175 (n7173 cl3 n7174 vss) n12 w=1.6u l=0.13u
MN7176 (n7174 n6901 vss vss) n12 w=1.6u l=0.13u
MP7177 (n7173 cl3 vdd vdd) p12 w=2.4u l=0.13u
MP7178 (n7173 n6901 vdd vdd) p12 w=2.4u l=0.13u
MN7181 (n7179 dl3 n7180 vss) n12 w=1.6u l=0.13u
MN7182 (n7180 n6904 vss vss) n12 w=1.6u l=0.13u
MP7183 (n7179 dl3 vdd vdd) p12 w=2.4u l=0.13u
MP7184 (n7179 n6904 vdd vdd) p12 w=2.4u l=0.13u
MN7187 (n7185 n7173 n7186 vss) n12 w=1.6u l=0.13u
MN7188 (n7186 n7179 vss vss) n12 w=1.6u l=0.13u
MP7189 (n7185 n7173 vdd vdd) p12 w=2.4u l=0.13u
MP7190 (n7185 n7179 vdd vdd) p12 w=2.4u l=0.13u
MN7195 (n7185 clk_low108 storage7194 vss) n12 w=1.2u l=0.13u
MP7196 (n7185 clk_lowb109 storage7194 vdd) p12 w=3.6u l=0.13u
MN7197 (qm7191 clk_high110 storage7194 vss) n12 w=1.2u l=0.13u
MP7198 (qm7191 clk_highb111 storage7194 vdd) p12 w=3.6u l=0.13u
MN7199 (qmb7192 storage7194 vss vss) n12 w=0.5u l=0.13u
MP7200 (qmb7192 storage7194 vdd vdd) p12 w=1.5u l=0.13u
MN7201 (qm7191 qmb7192 vss vss) n12 w=0.5u l=0.13u
MP7202 (qm7191 qmb7192 vdd vdd) p12 w=1.5u l=0.13u
MN7203 (storage7194 rst vss vss) n12 w=2u l=0.13u
MN7205 (qm7191 clk_high110 storage7204 vss) n12 w=1.2u l=0.13u
MP7206 (qm7191 clk_highb111 storage7204 vdd) p12 w=3.6u l=0.13u
MN7207 (dl3 clk_low108 storage7204 vss) n12 w=1.2u l=0.13u
MP7208 (dl3 clk_lowb109 storage7204 vdd) p12 w=3.6u l=0.13u
MN7209 (qb7193 storage7204 vss vss) n12 w=0.5u l=0.13u
MP7210 (qb7193 storage7204 vdd vdd) p12 w=1.5u l=0.13u
MN7211 (dl3 qb7193 vss vss) n12 w=0.5u l=0.13u
MP7212 (dl3 qb7193 vdd vdd) p12 w=1.5u l=0.13u
MN7213 (storage7204 rst vss vss) n12 w=2u l=0.13u
MN7216 (n7214 cl4 n7215 vss) n12 w=1.6u l=0.13u
MN7217 (n7215 n6901 vss vss) n12 w=1.6u l=0.13u
MP7218 (n7214 cl4 vdd vdd) p12 w=2.4u l=0.13u
MP7219 (n7214 n6901 vdd vdd) p12 w=2.4u l=0.13u
MN7222 (n7220 dl4 n7221 vss) n12 w=1.6u l=0.13u
MN7223 (n7221 n6904 vss vss) n12 w=1.6u l=0.13u
MP7224 (n7220 dl4 vdd vdd) p12 w=2.4u l=0.13u
MP7225 (n7220 n6904 vdd vdd) p12 w=2.4u l=0.13u
MN7228 (n7226 n7214 n7227 vss) n12 w=1.6u l=0.13u
MN7229 (n7227 n7220 vss vss) n12 w=1.6u l=0.13u
MP7230 (n7226 n7214 vdd vdd) p12 w=2.4u l=0.13u
MP7231 (n7226 n7220 vdd vdd) p12 w=2.4u l=0.13u
MN7236 (n7226 clk_low108 storage7235 vss) n12 w=1.2u l=0.13u
MP7237 (n7226 clk_lowb109 storage7235 vdd) p12 w=3.6u l=0.13u
MN7238 (qm7232 clk_high110 storage7235 vss) n12 w=1.2u l=0.13u
MP7239 (qm7232 clk_highb111 storage7235 vdd) p12 w=3.6u l=0.13u
MN7240 (qmb7233 storage7235 vss vss) n12 w=0.5u l=0.13u
MP7241 (qmb7233 storage7235 vdd vdd) p12 w=1.5u l=0.13u
MN7242 (qm7232 qmb7233 vss vss) n12 w=0.5u l=0.13u
MP7243 (qm7232 qmb7233 vdd vdd) p12 w=1.5u l=0.13u
MN7244 (storage7235 rst vss vss) n12 w=2u l=0.13u
MN7246 (qm7232 clk_high110 storage7245 vss) n12 w=1.2u l=0.13u
MP7247 (qm7232 clk_highb111 storage7245 vdd) p12 w=3.6u l=0.13u
MN7248 (dl4 clk_low108 storage7245 vss) n12 w=1.2u l=0.13u
MP7249 (dl4 clk_lowb109 storage7245 vdd) p12 w=3.6u l=0.13u
MN7250 (qb7234 storage7245 vss vss) n12 w=0.5u l=0.13u
MP7251 (qb7234 storage7245 vdd vdd) p12 w=1.5u l=0.13u
MN7252 (dl4 qb7234 vss vss) n12 w=0.5u l=0.13u
MP7253 (dl4 qb7234 vdd vdd) p12 w=1.5u l=0.13u
MN7254 (storage7245 rst vss vss) n12 w=2u l=0.13u
MN7257 (n7255 cl5 n7256 vss) n12 w=1.6u l=0.13u
MN7258 (n7256 n6901 vss vss) n12 w=1.6u l=0.13u
MP7259 (n7255 cl5 vdd vdd) p12 w=2.4u l=0.13u
MP7260 (n7255 n6901 vdd vdd) p12 w=2.4u l=0.13u
MN7263 (n7261 dl5 n7262 vss) n12 w=1.6u l=0.13u
MN7264 (n7262 n6904 vss vss) n12 w=1.6u l=0.13u
MP7265 (n7261 dl5 vdd vdd) p12 w=2.4u l=0.13u
MP7266 (n7261 n6904 vdd vdd) p12 w=2.4u l=0.13u
MN7269 (n7267 n7255 n7268 vss) n12 w=1.6u l=0.13u
MN7270 (n7268 n7261 vss vss) n12 w=1.6u l=0.13u
MP7271 (n7267 n7255 vdd vdd) p12 w=2.4u l=0.13u
MP7272 (n7267 n7261 vdd vdd) p12 w=2.4u l=0.13u
MN7277 (n7267 clk_low108 storage7276 vss) n12 w=1.2u l=0.13u
MP7278 (n7267 clk_lowb109 storage7276 vdd) p12 w=3.6u l=0.13u
MN7279 (qm7273 clk_high110 storage7276 vss) n12 w=1.2u l=0.13u
MP7280 (qm7273 clk_highb111 storage7276 vdd) p12 w=3.6u l=0.13u
MN7281 (qmb7274 storage7276 vss vss) n12 w=0.5u l=0.13u
MP7282 (qmb7274 storage7276 vdd vdd) p12 w=1.5u l=0.13u
MN7283 (qm7273 qmb7274 vss vss) n12 w=0.5u l=0.13u
MP7284 (qm7273 qmb7274 vdd vdd) p12 w=1.5u l=0.13u
MN7285 (storage7276 rst vss vss) n12 w=2u l=0.13u
MN7287 (qm7273 clk_high110 storage7286 vss) n12 w=1.2u l=0.13u
MP7288 (qm7273 clk_highb111 storage7286 vdd) p12 w=3.6u l=0.13u
MN7289 (dl5 clk_low108 storage7286 vss) n12 w=1.2u l=0.13u
MP7290 (dl5 clk_lowb109 storage7286 vdd) p12 w=3.6u l=0.13u
MN7291 (qb7275 storage7286 vss vss) n12 w=0.5u l=0.13u
MP7292 (qb7275 storage7286 vdd vdd) p12 w=1.5u l=0.13u
MN7293 (dl5 qb7275 vss vss) n12 w=0.5u l=0.13u
MP7294 (dl5 qb7275 vdd vdd) p12 w=1.5u l=0.13u
MN7295 (storage7286 rst vss vss) n12 w=2u l=0.13u
MN7298 (n7296 cl6 n7297 vss) n12 w=1.6u l=0.13u
MN7299 (n7297 n6901 vss vss) n12 w=1.6u l=0.13u
MP7300 (n7296 cl6 vdd vdd) p12 w=2.4u l=0.13u
MP7301 (n7296 n6901 vdd vdd) p12 w=2.4u l=0.13u
MN7304 (n7302 dl6 n7303 vss) n12 w=1.6u l=0.13u
MN7305 (n7303 n6904 vss vss) n12 w=1.6u l=0.13u
MP7306 (n7302 dl6 vdd vdd) p12 w=2.4u l=0.13u
MP7307 (n7302 n6904 vdd vdd) p12 w=2.4u l=0.13u
MN7310 (n7308 n7296 n7309 vss) n12 w=1.6u l=0.13u
MN7311 (n7309 n7302 vss vss) n12 w=1.6u l=0.13u
MP7312 (n7308 n7296 vdd vdd) p12 w=2.4u l=0.13u
MP7313 (n7308 n7302 vdd vdd) p12 w=2.4u l=0.13u
MN7318 (n7308 clk_low108 storage7317 vss) n12 w=1.2u l=0.13u
MP7319 (n7308 clk_lowb109 storage7317 vdd) p12 w=3.6u l=0.13u
MN7320 (qm7314 clk_high110 storage7317 vss) n12 w=1.2u l=0.13u
MP7321 (qm7314 clk_highb111 storage7317 vdd) p12 w=3.6u l=0.13u
MN7322 (qmb7315 storage7317 vss vss) n12 w=0.5u l=0.13u
MP7323 (qmb7315 storage7317 vdd vdd) p12 w=1.5u l=0.13u
MN7324 (qm7314 qmb7315 vss vss) n12 w=0.5u l=0.13u
MP7325 (qm7314 qmb7315 vdd vdd) p12 w=1.5u l=0.13u
MN7326 (storage7317 rst vss vss) n12 w=2u l=0.13u
MN7328 (qm7314 clk_high110 storage7327 vss) n12 w=1.2u l=0.13u
MP7329 (qm7314 clk_highb111 storage7327 vdd) p12 w=3.6u l=0.13u
MN7330 (dl6 clk_low108 storage7327 vss) n12 w=1.2u l=0.13u
MP7331 (dl6 clk_lowb109 storage7327 vdd) p12 w=3.6u l=0.13u
MN7332 (qb7316 storage7327 vss vss) n12 w=0.5u l=0.13u
MP7333 (qb7316 storage7327 vdd vdd) p12 w=1.5u l=0.13u
MN7334 (dl6 qb7316 vss vss) n12 w=0.5u l=0.13u
MP7335 (dl6 qb7316 vdd vdd) p12 w=1.5u l=0.13u
MN7336 (storage7327 rst vss vss) n12 w=2u l=0.13u
MN7339 (n7337 cl7 n7338 vss) n12 w=1.6u l=0.13u
MN7340 (n7338 n6901 vss vss) n12 w=1.6u l=0.13u
MP7341 (n7337 cl7 vdd vdd) p12 w=2.4u l=0.13u
MP7342 (n7337 n6901 vdd vdd) p12 w=2.4u l=0.13u
MN7345 (n7343 dl7 n7344 vss) n12 w=1.6u l=0.13u
MN7346 (n7344 n6904 vss vss) n12 w=1.6u l=0.13u
MP7347 (n7343 dl7 vdd vdd) p12 w=2.4u l=0.13u
MP7348 (n7343 n6904 vdd vdd) p12 w=2.4u l=0.13u
MN7351 (n7349 n7337 n7350 vss) n12 w=1.6u l=0.13u
MN7352 (n7350 n7343 vss vss) n12 w=1.6u l=0.13u
MP7353 (n7349 n7337 vdd vdd) p12 w=2.4u l=0.13u
MP7354 (n7349 n7343 vdd vdd) p12 w=2.4u l=0.13u
MN7359 (n7349 clk_low108 storage7358 vss) n12 w=1.2u l=0.13u
MP7360 (n7349 clk_lowb109 storage7358 vdd) p12 w=3.6u l=0.13u
MN7361 (qm7355 clk_high110 storage7358 vss) n12 w=1.2u l=0.13u
MP7362 (qm7355 clk_highb111 storage7358 vdd) p12 w=3.6u l=0.13u
MN7363 (qmb7356 storage7358 vss vss) n12 w=0.5u l=0.13u
MP7364 (qmb7356 storage7358 vdd vdd) p12 w=1.5u l=0.13u
MN7365 (qm7355 qmb7356 vss vss) n12 w=0.5u l=0.13u
MP7366 (qm7355 qmb7356 vdd vdd) p12 w=1.5u l=0.13u
MN7367 (storage7358 rst vss vss) n12 w=2u l=0.13u
MN7369 (qm7355 clk_high110 storage7368 vss) n12 w=1.2u l=0.13u
MP7370 (qm7355 clk_highb111 storage7368 vdd) p12 w=3.6u l=0.13u
MN7371 (dl7 clk_low108 storage7368 vss) n12 w=1.2u l=0.13u
MP7372 (dl7 clk_lowb109 storage7368 vdd) p12 w=3.6u l=0.13u
MN7373 (qb7357 storage7368 vss vss) n12 w=0.5u l=0.13u
MP7374 (qb7357 storage7368 vdd vdd) p12 w=1.5u l=0.13u
MN7375 (dl7 qb7357 vss vss) n12 w=0.5u l=0.13u
MP7376 (dl7 qb7357 vdd vdd) p12 w=1.5u l=0.13u
MN7377 (storage7368 rst vss vss) n12 w=2u l=0.13u
MN7380 (n7378 cl8 n7379 vss) n12 w=1.6u l=0.13u
MN7381 (n7379 n6901 vss vss) n12 w=1.6u l=0.13u
MP7382 (n7378 cl8 vdd vdd) p12 w=2.4u l=0.13u
MP7383 (n7378 n6901 vdd vdd) p12 w=2.4u l=0.13u
MN7386 (n7384 dl8 n7385 vss) n12 w=1.6u l=0.13u
MN7387 (n7385 n6904 vss vss) n12 w=1.6u l=0.13u
MP7388 (n7384 dl8 vdd vdd) p12 w=2.4u l=0.13u
MP7389 (n7384 n6904 vdd vdd) p12 w=2.4u l=0.13u
MN7392 (n7390 n7378 n7391 vss) n12 w=1.6u l=0.13u
MN7393 (n7391 n7384 vss vss) n12 w=1.6u l=0.13u
MP7394 (n7390 n7378 vdd vdd) p12 w=2.4u l=0.13u
MP7395 (n7390 n7384 vdd vdd) p12 w=2.4u l=0.13u
MN7400 (n7390 clk_low108 storage7399 vss) n12 w=1.2u l=0.13u
MP7401 (n7390 clk_lowb109 storage7399 vdd) p12 w=3.6u l=0.13u
MN7402 (qm7396 clk_high110 storage7399 vss) n12 w=1.2u l=0.13u
MP7403 (qm7396 clk_highb111 storage7399 vdd) p12 w=3.6u l=0.13u
MN7404 (qmb7397 storage7399 vss vss) n12 w=0.5u l=0.13u
MP7405 (qmb7397 storage7399 vdd vdd) p12 w=1.5u l=0.13u
MN7406 (qm7396 qmb7397 vss vss) n12 w=0.5u l=0.13u
MP7407 (qm7396 qmb7397 vdd vdd) p12 w=1.5u l=0.13u
MN7408 (storage7399 rst vss vss) n12 w=2u l=0.13u
MN7410 (qm7396 clk_high110 storage7409 vss) n12 w=1.2u l=0.13u
MP7411 (qm7396 clk_highb111 storage7409 vdd) p12 w=3.6u l=0.13u
MN7412 (dl8 clk_low108 storage7409 vss) n12 w=1.2u l=0.13u
MP7413 (dl8 clk_lowb109 storage7409 vdd) p12 w=3.6u l=0.13u
MN7414 (qb7398 storage7409 vss vss) n12 w=0.5u l=0.13u
MP7415 (qb7398 storage7409 vdd vdd) p12 w=1.5u l=0.13u
MN7416 (dl8 qb7398 vss vss) n12 w=0.5u l=0.13u
MP7417 (dl8 qb7398 vdd vdd) p12 w=1.5u l=0.13u
MN7418 (storage7409 rst vss vss) n12 w=2u l=0.13u
MN7421 (n7419 cg0 n7420 vss) n12 w=1.6u l=0.13u
MN7422 (n7420 n6901 vss vss) n12 w=1.6u l=0.13u
MP7423 (n7419 cg0 vdd vdd) p12 w=2.4u l=0.13u
MP7424 (n7419 n6901 vdd vdd) p12 w=2.4u l=0.13u
MN7427 (n7425 dg0 n7426 vss) n12 w=1.6u l=0.13u
MN7428 (n7426 n6904 vss vss) n12 w=1.6u l=0.13u
MP7429 (n7425 dg0 vdd vdd) p12 w=2.4u l=0.13u
MP7430 (n7425 n6904 vdd vdd) p12 w=2.4u l=0.13u
MN7433 (n7431 n7419 n7432 vss) n12 w=1.6u l=0.13u
MN7434 (n7432 n7425 vss vss) n12 w=1.6u l=0.13u
MP7435 (n7431 n7419 vdd vdd) p12 w=2.4u l=0.13u
MP7436 (n7431 n7425 vdd vdd) p12 w=2.4u l=0.13u
MN7441 (n7431 clk_low108 storage7440 vss) n12 w=1.2u l=0.13u
MP7442 (n7431 clk_lowb109 storage7440 vdd) p12 w=3.6u l=0.13u
MN7443 (qm7437 clk_high110 storage7440 vss) n12 w=1.2u l=0.13u
MP7444 (qm7437 clk_highb111 storage7440 vdd) p12 w=3.6u l=0.13u
MN7445 (qmb7438 storage7440 vss vss) n12 w=0.5u l=0.13u
MP7446 (qmb7438 storage7440 vdd vdd) p12 w=1.5u l=0.13u
MN7447 (qm7437 qmb7438 vss vss) n12 w=0.5u l=0.13u
MP7448 (qm7437 qmb7438 vdd vdd) p12 w=1.5u l=0.13u
MN7449 (storage7440 rst vss vss) n12 w=2u l=0.13u
MN7451 (qm7437 clk_high110 storage7450 vss) n12 w=1.2u l=0.13u
MP7452 (qm7437 clk_highb111 storage7450 vdd) p12 w=3.6u l=0.13u
MN7453 (dg0 clk_low108 storage7450 vss) n12 w=1.2u l=0.13u
MP7454 (dg0 clk_lowb109 storage7450 vdd) p12 w=3.6u l=0.13u
MN7455 (qb7439 storage7450 vss vss) n12 w=0.5u l=0.13u
MP7456 (qb7439 storage7450 vdd vdd) p12 w=1.5u l=0.13u
MN7457 (dg0 qb7439 vss vss) n12 w=0.5u l=0.13u
MP7458 (dg0 qb7439 vdd vdd) p12 w=1.5u l=0.13u
MN7459 (storage7450 rst vss vss) n12 w=2u l=0.13u
MN7462 (n7460 cg1 n7461 vss) n12 w=1.6u l=0.13u
MN7463 (n7461 n6901 vss vss) n12 w=1.6u l=0.13u
MP7464 (n7460 cg1 vdd vdd) p12 w=2.4u l=0.13u
MP7465 (n7460 n6901 vdd vdd) p12 w=2.4u l=0.13u
MN7468 (n7466 dg1 n7467 vss) n12 w=1.6u l=0.13u
MN7469 (n7467 n6904 vss vss) n12 w=1.6u l=0.13u
MP7470 (n7466 dg1 vdd vdd) p12 w=2.4u l=0.13u
MP7471 (n7466 n6904 vdd vdd) p12 w=2.4u l=0.13u
MN7474 (n7472 n7460 n7473 vss) n12 w=1.6u l=0.13u
MN7475 (n7473 n7466 vss vss) n12 w=1.6u l=0.13u
MP7476 (n7472 n7460 vdd vdd) p12 w=2.4u l=0.13u
MP7477 (n7472 n7466 vdd vdd) p12 w=2.4u l=0.13u
MN7482 (n7472 clk_low108 storage7481 vss) n12 w=1.2u l=0.13u
MP7483 (n7472 clk_lowb109 storage7481 vdd) p12 w=3.6u l=0.13u
MN7484 (qm7478 clk_high110 storage7481 vss) n12 w=1.2u l=0.13u
MP7485 (qm7478 clk_highb111 storage7481 vdd) p12 w=3.6u l=0.13u
MN7486 (qmb7479 storage7481 vss vss) n12 w=0.5u l=0.13u
MP7487 (qmb7479 storage7481 vdd vdd) p12 w=1.5u l=0.13u
MN7488 (qm7478 qmb7479 vss vss) n12 w=0.5u l=0.13u
MP7489 (qm7478 qmb7479 vdd vdd) p12 w=1.5u l=0.13u
MN7490 (storage7481 rst vss vss) n12 w=2u l=0.13u
MN7492 (qm7478 clk_high110 storage7491 vss) n12 w=1.2u l=0.13u
MP7493 (qm7478 clk_highb111 storage7491 vdd) p12 w=3.6u l=0.13u
MN7494 (dg1 clk_low108 storage7491 vss) n12 w=1.2u l=0.13u
MP7495 (dg1 clk_lowb109 storage7491 vdd) p12 w=3.6u l=0.13u
MN7496 (qb7480 storage7491 vss vss) n12 w=0.5u l=0.13u
MP7497 (qb7480 storage7491 vdd vdd) p12 w=1.5u l=0.13u
MN7498 (dg1 qb7480 vss vss) n12 w=0.5u l=0.13u
MP7499 (dg1 qb7480 vdd vdd) p12 w=1.5u l=0.13u
MN7500 (storage7491 rst vss vss) n12 w=2u l=0.13u
MN7503 (n7501 cg2 n7502 vss) n12 w=1.6u l=0.13u
MN7504 (n7502 n6901 vss vss) n12 w=1.6u l=0.13u
MP7505 (n7501 cg2 vdd vdd) p12 w=2.4u l=0.13u
MP7506 (n7501 n6901 vdd vdd) p12 w=2.4u l=0.13u
MN7509 (n7507 dg2 n7508 vss) n12 w=1.6u l=0.13u
MN7510 (n7508 n6904 vss vss) n12 w=1.6u l=0.13u
MP7511 (n7507 dg2 vdd vdd) p12 w=2.4u l=0.13u
MP7512 (n7507 n6904 vdd vdd) p12 w=2.4u l=0.13u
MN7515 (n7513 n7501 n7514 vss) n12 w=1.6u l=0.13u
MN7516 (n7514 n7507 vss vss) n12 w=1.6u l=0.13u
MP7517 (n7513 n7501 vdd vdd) p12 w=2.4u l=0.13u
MP7518 (n7513 n7507 vdd vdd) p12 w=2.4u l=0.13u
MN7523 (n7513 clk_low108 storage7522 vss) n12 w=1.2u l=0.13u
MP7524 (n7513 clk_lowb109 storage7522 vdd) p12 w=3.6u l=0.13u
MN7525 (qm7519 clk_high110 storage7522 vss) n12 w=1.2u l=0.13u
MP7526 (qm7519 clk_highb111 storage7522 vdd) p12 w=3.6u l=0.13u
MN7527 (qmb7520 storage7522 vss vss) n12 w=0.5u l=0.13u
MP7528 (qmb7520 storage7522 vdd vdd) p12 w=1.5u l=0.13u
MN7529 (qm7519 qmb7520 vss vss) n12 w=0.5u l=0.13u
MP7530 (qm7519 qmb7520 vdd vdd) p12 w=1.5u l=0.13u
MN7531 (storage7522 rst vss vss) n12 w=2u l=0.13u
MN7533 (qm7519 clk_high110 storage7532 vss) n12 w=1.2u l=0.13u
MP7534 (qm7519 clk_highb111 storage7532 vdd) p12 w=3.6u l=0.13u
MN7535 (dg2 clk_low108 storage7532 vss) n12 w=1.2u l=0.13u
MP7536 (dg2 clk_lowb109 storage7532 vdd) p12 w=3.6u l=0.13u
MN7537 (qb7521 storage7532 vss vss) n12 w=0.5u l=0.13u
MP7538 (qb7521 storage7532 vdd vdd) p12 w=1.5u l=0.13u
MN7539 (dg2 qb7521 vss vss) n12 w=0.5u l=0.13u
MP7540 (dg2 qb7521 vdd vdd) p12 w=1.5u l=0.13u
MN7541 (storage7532 rst vss vss) n12 w=2u l=0.13u
MN7544 (n7542 cg3 n7543 vss) n12 w=1.6u l=0.13u
MN7545 (n7543 n6901 vss vss) n12 w=1.6u l=0.13u
MP7546 (n7542 cg3 vdd vdd) p12 w=2.4u l=0.13u
MP7547 (n7542 n6901 vdd vdd) p12 w=2.4u l=0.13u
MN7550 (n7548 dg3 n7549 vss) n12 w=1.6u l=0.13u
MN7551 (n7549 n6904 vss vss) n12 w=1.6u l=0.13u
MP7552 (n7548 dg3 vdd vdd) p12 w=2.4u l=0.13u
MP7553 (n7548 n6904 vdd vdd) p12 w=2.4u l=0.13u
MN7556 (n7554 n7542 n7555 vss) n12 w=1.6u l=0.13u
MN7557 (n7555 n7548 vss vss) n12 w=1.6u l=0.13u
MP7558 (n7554 n7542 vdd vdd) p12 w=2.4u l=0.13u
MP7559 (n7554 n7548 vdd vdd) p12 w=2.4u l=0.13u
MN7564 (n7554 clk_low108 storage7563 vss) n12 w=1.2u l=0.13u
MP7565 (n7554 clk_lowb109 storage7563 vdd) p12 w=3.6u l=0.13u
MN7566 (qm7560 clk_high110 storage7563 vss) n12 w=1.2u l=0.13u
MP7567 (qm7560 clk_highb111 storage7563 vdd) p12 w=3.6u l=0.13u
MN7568 (qmb7561 storage7563 vss vss) n12 w=0.5u l=0.13u
MP7569 (qmb7561 storage7563 vdd vdd) p12 w=1.5u l=0.13u
MN7570 (qm7560 qmb7561 vss vss) n12 w=0.5u l=0.13u
MP7571 (qm7560 qmb7561 vdd vdd) p12 w=1.5u l=0.13u
MN7572 (storage7563 rst vss vss) n12 w=2u l=0.13u
MN7574 (qm7560 clk_high110 storage7573 vss) n12 w=1.2u l=0.13u
MP7575 (qm7560 clk_highb111 storage7573 vdd) p12 w=3.6u l=0.13u
MN7576 (dg3 clk_low108 storage7573 vss) n12 w=1.2u l=0.13u
MP7577 (dg3 clk_lowb109 storage7573 vdd) p12 w=3.6u l=0.13u
MN7578 (qb7562 storage7573 vss vss) n12 w=0.5u l=0.13u
MP7579 (qb7562 storage7573 vdd vdd) p12 w=1.5u l=0.13u
MN7580 (dg3 qb7562 vss vss) n12 w=0.5u l=0.13u
MP7581 (dg3 qb7562 vdd vdd) p12 w=1.5u l=0.13u
MN7582 (storage7573 rst vss vss) n12 w=2u l=0.13u
MN7585 (n7583 cg4 n7584 vss) n12 w=1.6u l=0.13u
MN7586 (n7584 n6901 vss vss) n12 w=1.6u l=0.13u
MP7587 (n7583 cg4 vdd vdd) p12 w=2.4u l=0.13u
MP7588 (n7583 n6901 vdd vdd) p12 w=2.4u l=0.13u
MN7591 (n7589 dg4 n7590 vss) n12 w=1.6u l=0.13u
MN7592 (n7590 n6904 vss vss) n12 w=1.6u l=0.13u
MP7593 (n7589 dg4 vdd vdd) p12 w=2.4u l=0.13u
MP7594 (n7589 n6904 vdd vdd) p12 w=2.4u l=0.13u
MN7597 (n7595 n7583 n7596 vss) n12 w=1.6u l=0.13u
MN7598 (n7596 n7589 vss vss) n12 w=1.6u l=0.13u
MP7599 (n7595 n7583 vdd vdd) p12 w=2.4u l=0.13u
MP7600 (n7595 n7589 vdd vdd) p12 w=2.4u l=0.13u
MN7605 (n7595 clk_low108 storage7604 vss) n12 w=1.2u l=0.13u
MP7606 (n7595 clk_lowb109 storage7604 vdd) p12 w=3.6u l=0.13u
MN7607 (qm7601 clk_high110 storage7604 vss) n12 w=1.2u l=0.13u
MP7608 (qm7601 clk_highb111 storage7604 vdd) p12 w=3.6u l=0.13u
MN7609 (qmb7602 storage7604 vss vss) n12 w=0.5u l=0.13u
MP7610 (qmb7602 storage7604 vdd vdd) p12 w=1.5u l=0.13u
MN7611 (qm7601 qmb7602 vss vss) n12 w=0.5u l=0.13u
MP7612 (qm7601 qmb7602 vdd vdd) p12 w=1.5u l=0.13u
MN7613 (storage7604 rst vss vss) n12 w=2u l=0.13u
MN7615 (qm7601 clk_high110 storage7614 vss) n12 w=1.2u l=0.13u
MP7616 (qm7601 clk_highb111 storage7614 vdd) p12 w=3.6u l=0.13u
MN7617 (dg4 clk_low108 storage7614 vss) n12 w=1.2u l=0.13u
MP7618 (dg4 clk_lowb109 storage7614 vdd) p12 w=3.6u l=0.13u
MN7619 (qb7603 storage7614 vss vss) n12 w=0.5u l=0.13u
MP7620 (qb7603 storage7614 vdd vdd) p12 w=1.5u l=0.13u
MN7621 (dg4 qb7603 vss vss) n12 w=0.5u l=0.13u
MP7622 (dg4 qb7603 vdd vdd) p12 w=1.5u l=0.13u
MN7623 (storage7614 rst vss vss) n12 w=2u l=0.13u
MN7626 (n7624 cg5 n7625 vss) n12 w=1.6u l=0.13u
MN7627 (n7625 n6901 vss vss) n12 w=1.6u l=0.13u
MP7628 (n7624 cg5 vdd vdd) p12 w=2.4u l=0.13u
MP7629 (n7624 n6901 vdd vdd) p12 w=2.4u l=0.13u
MN7632 (n7630 dg5 n7631 vss) n12 w=1.6u l=0.13u
MN7633 (n7631 n6904 vss vss) n12 w=1.6u l=0.13u
MP7634 (n7630 dg5 vdd vdd) p12 w=2.4u l=0.13u
MP7635 (n7630 n6904 vdd vdd) p12 w=2.4u l=0.13u
MN7638 (n7636 n7624 n7637 vss) n12 w=1.6u l=0.13u
MN7639 (n7637 n7630 vss vss) n12 w=1.6u l=0.13u
MP7640 (n7636 n7624 vdd vdd) p12 w=2.4u l=0.13u
MP7641 (n7636 n7630 vdd vdd) p12 w=2.4u l=0.13u
MN7646 (n7636 clk_low108 storage7645 vss) n12 w=1.2u l=0.13u
MP7647 (n7636 clk_lowb109 storage7645 vdd) p12 w=3.6u l=0.13u
MN7648 (qm7642 clk_high110 storage7645 vss) n12 w=1.2u l=0.13u
MP7649 (qm7642 clk_highb111 storage7645 vdd) p12 w=3.6u l=0.13u
MN7650 (qmb7643 storage7645 vss vss) n12 w=0.5u l=0.13u
MP7651 (qmb7643 storage7645 vdd vdd) p12 w=1.5u l=0.13u
MN7652 (qm7642 qmb7643 vss vss) n12 w=0.5u l=0.13u
MP7653 (qm7642 qmb7643 vdd vdd) p12 w=1.5u l=0.13u
MN7654 (storage7645 rst vss vss) n12 w=2u l=0.13u
MN7656 (qm7642 clk_high110 storage7655 vss) n12 w=1.2u l=0.13u
MP7657 (qm7642 clk_highb111 storage7655 vdd) p12 w=3.6u l=0.13u
MN7658 (dg5 clk_low108 storage7655 vss) n12 w=1.2u l=0.13u
MP7659 (dg5 clk_lowb109 storage7655 vdd) p12 w=3.6u l=0.13u
MN7660 (qb7644 storage7655 vss vss) n12 w=0.5u l=0.13u
MP7661 (qb7644 storage7655 vdd vdd) p12 w=1.5u l=0.13u
MN7662 (dg5 qb7644 vss vss) n12 w=0.5u l=0.13u
MP7663 (dg5 qb7644 vdd vdd) p12 w=1.5u l=0.13u
MN7664 (storage7655 rst vss vss) n12 w=2u l=0.13u
MN7667 (n7665 cg6 n7666 vss) n12 w=1.6u l=0.13u
MN7668 (n7666 n6901 vss vss) n12 w=1.6u l=0.13u
MP7669 (n7665 cg6 vdd vdd) p12 w=2.4u l=0.13u
MP7670 (n7665 n6901 vdd vdd) p12 w=2.4u l=0.13u
MN7673 (n7671 dg6 n7672 vss) n12 w=1.6u l=0.13u
MN7674 (n7672 n6904 vss vss) n12 w=1.6u l=0.13u
MP7675 (n7671 dg6 vdd vdd) p12 w=2.4u l=0.13u
MP7676 (n7671 n6904 vdd vdd) p12 w=2.4u l=0.13u
MN7679 (n7677 n7665 n7678 vss) n12 w=1.6u l=0.13u
MN7680 (n7678 n7671 vss vss) n12 w=1.6u l=0.13u
MP7681 (n7677 n7665 vdd vdd) p12 w=2.4u l=0.13u
MP7682 (n7677 n7671 vdd vdd) p12 w=2.4u l=0.13u
MN7687 (n7677 clk_low108 storage7686 vss) n12 w=1.2u l=0.13u
MP7688 (n7677 clk_lowb109 storage7686 vdd) p12 w=3.6u l=0.13u
MN7689 (qm7683 clk_high110 storage7686 vss) n12 w=1.2u l=0.13u
MP7690 (qm7683 clk_highb111 storage7686 vdd) p12 w=3.6u l=0.13u
MN7691 (qmb7684 storage7686 vss vss) n12 w=0.5u l=0.13u
MP7692 (qmb7684 storage7686 vdd vdd) p12 w=1.5u l=0.13u
MN7693 (qm7683 qmb7684 vss vss) n12 w=0.5u l=0.13u
MP7694 (qm7683 qmb7684 vdd vdd) p12 w=1.5u l=0.13u
MN7695 (storage7686 rst vss vss) n12 w=2u l=0.13u
MN7697 (qm7683 clk_high110 storage7696 vss) n12 w=1.2u l=0.13u
MP7698 (qm7683 clk_highb111 storage7696 vdd) p12 w=3.6u l=0.13u
MN7699 (dg6 clk_low108 storage7696 vss) n12 w=1.2u l=0.13u
MP7700 (dg6 clk_lowb109 storage7696 vdd) p12 w=3.6u l=0.13u
MN7701 (qb7685 storage7696 vss vss) n12 w=0.5u l=0.13u
MP7702 (qb7685 storage7696 vdd vdd) p12 w=1.5u l=0.13u
MN7703 (dg6 qb7685 vss vss) n12 w=0.5u l=0.13u
MP7704 (dg6 qb7685 vdd vdd) p12 w=1.5u l=0.13u
MN7705 (storage7696 rst vss vss) n12 w=2u l=0.13u
MN7708 (n7706 cg7 n7707 vss) n12 w=1.6u l=0.13u
MN7709 (n7707 n6901 vss vss) n12 w=1.6u l=0.13u
MP7710 (n7706 cg7 vdd vdd) p12 w=2.4u l=0.13u
MP7711 (n7706 n6901 vdd vdd) p12 w=2.4u l=0.13u
MN7714 (n7712 dg7 n7713 vss) n12 w=1.6u l=0.13u
MN7715 (n7713 n6904 vss vss) n12 w=1.6u l=0.13u
MP7716 (n7712 dg7 vdd vdd) p12 w=2.4u l=0.13u
MP7717 (n7712 n6904 vdd vdd) p12 w=2.4u l=0.13u
MN7720 (n7718 n7706 n7719 vss) n12 w=1.6u l=0.13u
MN7721 (n7719 n7712 vss vss) n12 w=1.6u l=0.13u
MP7722 (n7718 n7706 vdd vdd) p12 w=2.4u l=0.13u
MP7723 (n7718 n7712 vdd vdd) p12 w=2.4u l=0.13u
MN7728 (n7718 clk_low108 storage7727 vss) n12 w=1.2u l=0.13u
MP7729 (n7718 clk_lowb109 storage7727 vdd) p12 w=3.6u l=0.13u
MN7730 (qm7724 clk_high110 storage7727 vss) n12 w=1.2u l=0.13u
MP7731 (qm7724 clk_highb111 storage7727 vdd) p12 w=3.6u l=0.13u
MN7732 (qmb7725 storage7727 vss vss) n12 w=0.5u l=0.13u
MP7733 (qmb7725 storage7727 vdd vdd) p12 w=1.5u l=0.13u
MN7734 (qm7724 qmb7725 vss vss) n12 w=0.5u l=0.13u
MP7735 (qm7724 qmb7725 vdd vdd) p12 w=1.5u l=0.13u
MN7736 (storage7727 rst vss vss) n12 w=2u l=0.13u
MN7738 (qm7724 clk_high110 storage7737 vss) n12 w=1.2u l=0.13u
MP7739 (qm7724 clk_highb111 storage7737 vdd) p12 w=3.6u l=0.13u
MN7740 (dg7 clk_low108 storage7737 vss) n12 w=1.2u l=0.13u
MP7741 (dg7 clk_lowb109 storage7737 vdd) p12 w=3.6u l=0.13u
MN7742 (qb7726 storage7737 vss vss) n12 w=0.5u l=0.13u
MP7743 (qb7726 storage7737 vdd vdd) p12 w=1.5u l=0.13u
MN7744 (dg7 qb7726 vss vss) n12 w=0.5u l=0.13u
MP7745 (dg7 qb7726 vdd vdd) p12 w=1.5u l=0.13u
MN7746 (storage7737 rst vss vss) n12 w=2u l=0.13u
MN7749 (n7747 cg8 n7748 vss) n12 w=1.6u l=0.13u
MN7750 (n7748 n6901 vss vss) n12 w=1.6u l=0.13u
MP7751 (n7747 cg8 vdd vdd) p12 w=2.4u l=0.13u
MP7752 (n7747 n6901 vdd vdd) p12 w=2.4u l=0.13u
MN7755 (n7753 dg8 n7754 vss) n12 w=1.6u l=0.13u
MN7756 (n7754 n6904 vss vss) n12 w=1.6u l=0.13u
MP7757 (n7753 dg8 vdd vdd) p12 w=2.4u l=0.13u
MP7758 (n7753 n6904 vdd vdd) p12 w=2.4u l=0.13u
MN7761 (n7759 n7747 n7760 vss) n12 w=1.6u l=0.13u
MN7762 (n7760 n7753 vss vss) n12 w=1.6u l=0.13u
MP7763 (n7759 n7747 vdd vdd) p12 w=2.4u l=0.13u
MP7764 (n7759 n7753 vdd vdd) p12 w=2.4u l=0.13u
MN7769 (n7759 clk_low108 storage7768 vss) n12 w=1.2u l=0.13u
MP7770 (n7759 clk_lowb109 storage7768 vdd) p12 w=3.6u l=0.13u
MN7771 (qm7765 clk_high110 storage7768 vss) n12 w=1.2u l=0.13u
MP7772 (qm7765 clk_highb111 storage7768 vdd) p12 w=3.6u l=0.13u
MN7773 (qmb7766 storage7768 vss vss) n12 w=0.5u l=0.13u
MP7774 (qmb7766 storage7768 vdd vdd) p12 w=1.5u l=0.13u
MN7775 (qm7765 qmb7766 vss vss) n12 w=0.5u l=0.13u
MP7776 (qm7765 qmb7766 vdd vdd) p12 w=1.5u l=0.13u
MN7777 (storage7768 rst vss vss) n12 w=2u l=0.13u
MN7779 (qm7765 clk_high110 storage7778 vss) n12 w=1.2u l=0.13u
MP7780 (qm7765 clk_highb111 storage7778 vdd) p12 w=3.6u l=0.13u
MN7781 (dg8 clk_low108 storage7778 vss) n12 w=1.2u l=0.13u
MP7782 (dg8 clk_lowb109 storage7778 vdd) p12 w=3.6u l=0.13u
MN7783 (qb7767 storage7778 vss vss) n12 w=0.5u l=0.13u
MP7784 (qb7767 storage7778 vdd vdd) p12 w=1.5u l=0.13u
MN7785 (dg8 qb7767 vss vss) n12 w=0.5u l=0.13u
MP7786 (dg8 qb7767 vdd vdd) p12 w=1.5u l=0.13u
MN7787 (storage7778 rst vss vss) n12 w=2u l=0.13u
MN7790 (n7788 cd0 n7789 vss) n12 w=1.6u l=0.13u
MN7791 (n7789 n6901 vss vss) n12 w=1.6u l=0.13u
MP7792 (n7788 cd0 vdd vdd) p12 w=2.4u l=0.13u
MP7793 (n7788 n6901 vdd vdd) p12 w=2.4u l=0.13u
MN7796 (n7794 dd0 n7795 vss) n12 w=1.6u l=0.13u
MN7797 (n7795 n6904 vss vss) n12 w=1.6u l=0.13u
MP7798 (n7794 dd0 vdd vdd) p12 w=2.4u l=0.13u
MP7799 (n7794 n6904 vdd vdd) p12 w=2.4u l=0.13u
MN7802 (n7800 n7788 n7801 vss) n12 w=1.6u l=0.13u
MN7803 (n7801 n7794 vss vss) n12 w=1.6u l=0.13u
MP7804 (n7800 n7788 vdd vdd) p12 w=2.4u l=0.13u
MP7805 (n7800 n7794 vdd vdd) p12 w=2.4u l=0.13u
MN7810 (n7800 clk_low108 storage7809 vss) n12 w=1.2u l=0.13u
MP7811 (n7800 clk_lowb109 storage7809 vdd) p12 w=3.6u l=0.13u
MN7812 (qm7806 clk_high110 storage7809 vss) n12 w=1.2u l=0.13u
MP7813 (qm7806 clk_highb111 storage7809 vdd) p12 w=3.6u l=0.13u
MN7814 (qmb7807 storage7809 vss vss) n12 w=0.5u l=0.13u
MP7815 (qmb7807 storage7809 vdd vdd) p12 w=1.5u l=0.13u
MN7816 (qm7806 qmb7807 vss vss) n12 w=0.5u l=0.13u
MP7817 (qm7806 qmb7807 vdd vdd) p12 w=1.5u l=0.13u
MN7818 (storage7809 rst vss vss) n12 w=2u l=0.13u
MN7820 (qm7806 clk_high110 storage7819 vss) n12 w=1.2u l=0.13u
MP7821 (qm7806 clk_highb111 storage7819 vdd) p12 w=3.6u l=0.13u
MN7822 (dd0 clk_low108 storage7819 vss) n12 w=1.2u l=0.13u
MP7823 (dd0 clk_lowb109 storage7819 vdd) p12 w=3.6u l=0.13u
MN7824 (qb7808 storage7819 vss vss) n12 w=0.5u l=0.13u
MP7825 (qb7808 storage7819 vdd vdd) p12 w=1.5u l=0.13u
MN7826 (dd0 qb7808 vss vss) n12 w=0.5u l=0.13u
MP7827 (dd0 qb7808 vdd vdd) p12 w=1.5u l=0.13u
MN7828 (storage7819 rst vss vss) n12 w=2u l=0.13u
MN7831 (n7829 cd1 n7830 vss) n12 w=1.6u l=0.13u
MN7832 (n7830 n6901 vss vss) n12 w=1.6u l=0.13u
MP7833 (n7829 cd1 vdd vdd) p12 w=2.4u l=0.13u
MP7834 (n7829 n6901 vdd vdd) p12 w=2.4u l=0.13u
MN7837 (n7835 dd1 n7836 vss) n12 w=1.6u l=0.13u
MN7838 (n7836 n6904 vss vss) n12 w=1.6u l=0.13u
MP7839 (n7835 dd1 vdd vdd) p12 w=2.4u l=0.13u
MP7840 (n7835 n6904 vdd vdd) p12 w=2.4u l=0.13u
MN7843 (n7841 n7829 n7842 vss) n12 w=1.6u l=0.13u
MN7844 (n7842 n7835 vss vss) n12 w=1.6u l=0.13u
MP7845 (n7841 n7829 vdd vdd) p12 w=2.4u l=0.13u
MP7846 (n7841 n7835 vdd vdd) p12 w=2.4u l=0.13u
MN7851 (n7841 clk_low108 storage7850 vss) n12 w=1.2u l=0.13u
MP7852 (n7841 clk_lowb109 storage7850 vdd) p12 w=3.6u l=0.13u
MN7853 (qm7847 clk_high110 storage7850 vss) n12 w=1.2u l=0.13u
MP7854 (qm7847 clk_highb111 storage7850 vdd) p12 w=3.6u l=0.13u
MN7855 (qmb7848 storage7850 vss vss) n12 w=0.5u l=0.13u
MP7856 (qmb7848 storage7850 vdd vdd) p12 w=1.5u l=0.13u
MN7857 (qm7847 qmb7848 vss vss) n12 w=0.5u l=0.13u
MP7858 (qm7847 qmb7848 vdd vdd) p12 w=1.5u l=0.13u
MN7859 (storage7850 rst vss vss) n12 w=2u l=0.13u
MN7861 (qm7847 clk_high110 storage7860 vss) n12 w=1.2u l=0.13u
MP7862 (qm7847 clk_highb111 storage7860 vdd) p12 w=3.6u l=0.13u
MN7863 (dd1 clk_low108 storage7860 vss) n12 w=1.2u l=0.13u
MP7864 (dd1 clk_lowb109 storage7860 vdd) p12 w=3.6u l=0.13u
MN7865 (qb7849 storage7860 vss vss) n12 w=0.5u l=0.13u
MP7866 (qb7849 storage7860 vdd vdd) p12 w=1.5u l=0.13u
MN7867 (dd1 qb7849 vss vss) n12 w=0.5u l=0.13u
MP7868 (dd1 qb7849 vdd vdd) p12 w=1.5u l=0.13u
MN7869 (storage7860 rst vss vss) n12 w=2u l=0.13u
MN7872 (n7870 cd2 n7871 vss) n12 w=1.6u l=0.13u
MN7873 (n7871 n6901 vss vss) n12 w=1.6u l=0.13u
MP7874 (n7870 cd2 vdd vdd) p12 w=2.4u l=0.13u
MP7875 (n7870 n6901 vdd vdd) p12 w=2.4u l=0.13u
MN7878 (n7876 dd2 n7877 vss) n12 w=1.6u l=0.13u
MN7879 (n7877 n6904 vss vss) n12 w=1.6u l=0.13u
MP7880 (n7876 dd2 vdd vdd) p12 w=2.4u l=0.13u
MP7881 (n7876 n6904 vdd vdd) p12 w=2.4u l=0.13u
MN7884 (n7882 n7870 n7883 vss) n12 w=1.6u l=0.13u
MN7885 (n7883 n7876 vss vss) n12 w=1.6u l=0.13u
MP7886 (n7882 n7870 vdd vdd) p12 w=2.4u l=0.13u
MP7887 (n7882 n7876 vdd vdd) p12 w=2.4u l=0.13u
MN7892 (n7882 clk_low108 storage7891 vss) n12 w=1.2u l=0.13u
MP7893 (n7882 clk_lowb109 storage7891 vdd) p12 w=3.6u l=0.13u
MN7894 (qm7888 clk_high110 storage7891 vss) n12 w=1.2u l=0.13u
MP7895 (qm7888 clk_highb111 storage7891 vdd) p12 w=3.6u l=0.13u
MN7896 (qmb7889 storage7891 vss vss) n12 w=0.5u l=0.13u
MP7897 (qmb7889 storage7891 vdd vdd) p12 w=1.5u l=0.13u
MN7898 (qm7888 qmb7889 vss vss) n12 w=0.5u l=0.13u
MP7899 (qm7888 qmb7889 vdd vdd) p12 w=1.5u l=0.13u
MN7900 (storage7891 rst vss vss) n12 w=2u l=0.13u
MN7902 (qm7888 clk_high110 storage7901 vss) n12 w=1.2u l=0.13u
MP7903 (qm7888 clk_highb111 storage7901 vdd) p12 w=3.6u l=0.13u
MN7904 (dd2 clk_low108 storage7901 vss) n12 w=1.2u l=0.13u
MP7905 (dd2 clk_lowb109 storage7901 vdd) p12 w=3.6u l=0.13u
MN7906 (qb7890 storage7901 vss vss) n12 w=0.5u l=0.13u
MP7907 (qb7890 storage7901 vdd vdd) p12 w=1.5u l=0.13u
MN7908 (dd2 qb7890 vss vss) n12 w=0.5u l=0.13u
MP7909 (dd2 qb7890 vdd vdd) p12 w=1.5u l=0.13u
MN7910 (storage7901 rst vss vss) n12 w=2u l=0.13u
MN7913 (n7911 cd3 n7912 vss) n12 w=1.6u l=0.13u
MN7914 (n7912 n6901 vss vss) n12 w=1.6u l=0.13u
MP7915 (n7911 cd3 vdd vdd) p12 w=2.4u l=0.13u
MP7916 (n7911 n6901 vdd vdd) p12 w=2.4u l=0.13u
MN7919 (n7917 dd3 n7918 vss) n12 w=1.6u l=0.13u
MN7920 (n7918 n6904 vss vss) n12 w=1.6u l=0.13u
MP7921 (n7917 dd3 vdd vdd) p12 w=2.4u l=0.13u
MP7922 (n7917 n6904 vdd vdd) p12 w=2.4u l=0.13u
MN7925 (n7923 n7911 n7924 vss) n12 w=1.6u l=0.13u
MN7926 (n7924 n7917 vss vss) n12 w=1.6u l=0.13u
MP7927 (n7923 n7911 vdd vdd) p12 w=2.4u l=0.13u
MP7928 (n7923 n7917 vdd vdd) p12 w=2.4u l=0.13u
MN7933 (n7923 clk_low108 storage7932 vss) n12 w=1.2u l=0.13u
MP7934 (n7923 clk_lowb109 storage7932 vdd) p12 w=3.6u l=0.13u
MN7935 (qm7929 clk_high110 storage7932 vss) n12 w=1.2u l=0.13u
MP7936 (qm7929 clk_highb111 storage7932 vdd) p12 w=3.6u l=0.13u
MN7937 (qmb7930 storage7932 vss vss) n12 w=0.5u l=0.13u
MP7938 (qmb7930 storage7932 vdd vdd) p12 w=1.5u l=0.13u
MN7939 (qm7929 qmb7930 vss vss) n12 w=0.5u l=0.13u
MP7940 (qm7929 qmb7930 vdd vdd) p12 w=1.5u l=0.13u
MN7941 (storage7932 rst vss vss) n12 w=2u l=0.13u
MN7943 (qm7929 clk_high110 storage7942 vss) n12 w=1.2u l=0.13u
MP7944 (qm7929 clk_highb111 storage7942 vdd) p12 w=3.6u l=0.13u
MN7945 (dd3 clk_low108 storage7942 vss) n12 w=1.2u l=0.13u
MP7946 (dd3 clk_lowb109 storage7942 vdd) p12 w=3.6u l=0.13u
MN7947 (qb7931 storage7942 vss vss) n12 w=0.5u l=0.13u
MP7948 (qb7931 storage7942 vdd vdd) p12 w=1.5u l=0.13u
MN7949 (dd3 qb7931 vss vss) n12 w=0.5u l=0.13u
MP7950 (dd3 qb7931 vdd vdd) p12 w=1.5u l=0.13u
MN7951 (storage7942 rst vss vss) n12 w=2u l=0.13u
MN7954 (n7952 cd4 n7953 vss) n12 w=1.6u l=0.13u
MN7955 (n7953 n6901 vss vss) n12 w=1.6u l=0.13u
MP7956 (n7952 cd4 vdd vdd) p12 w=2.4u l=0.13u
MP7957 (n7952 n6901 vdd vdd) p12 w=2.4u l=0.13u
MN7960 (n7958 dd4 n7959 vss) n12 w=1.6u l=0.13u
MN7961 (n7959 n6904 vss vss) n12 w=1.6u l=0.13u
MP7962 (n7958 dd4 vdd vdd) p12 w=2.4u l=0.13u
MP7963 (n7958 n6904 vdd vdd) p12 w=2.4u l=0.13u
MN7966 (n7964 n7952 n7965 vss) n12 w=1.6u l=0.13u
MN7967 (n7965 n7958 vss vss) n12 w=1.6u l=0.13u
MP7968 (n7964 n7952 vdd vdd) p12 w=2.4u l=0.13u
MP7969 (n7964 n7958 vdd vdd) p12 w=2.4u l=0.13u
MN7974 (n7964 clk_low108 storage7973 vss) n12 w=1.2u l=0.13u
MP7975 (n7964 clk_lowb109 storage7973 vdd) p12 w=3.6u l=0.13u
MN7976 (qm7970 clk_high110 storage7973 vss) n12 w=1.2u l=0.13u
MP7977 (qm7970 clk_highb111 storage7973 vdd) p12 w=3.6u l=0.13u
MN7978 (qmb7971 storage7973 vss vss) n12 w=0.5u l=0.13u
MP7979 (qmb7971 storage7973 vdd vdd) p12 w=1.5u l=0.13u
MN7980 (qm7970 qmb7971 vss vss) n12 w=0.5u l=0.13u
MP7981 (qm7970 qmb7971 vdd vdd) p12 w=1.5u l=0.13u
MN7982 (storage7973 rst vss vss) n12 w=2u l=0.13u
MN7984 (qm7970 clk_high110 storage7983 vss) n12 w=1.2u l=0.13u
MP7985 (qm7970 clk_highb111 storage7983 vdd) p12 w=3.6u l=0.13u
MN7986 (dd4 clk_low108 storage7983 vss) n12 w=1.2u l=0.13u
MP7987 (dd4 clk_lowb109 storage7983 vdd) p12 w=3.6u l=0.13u
MN7988 (qb7972 storage7983 vss vss) n12 w=0.5u l=0.13u
MP7989 (qb7972 storage7983 vdd vdd) p12 w=1.5u l=0.13u
MN7990 (dd4 qb7972 vss vss) n12 w=0.5u l=0.13u
MP7991 (dd4 qb7972 vdd vdd) p12 w=1.5u l=0.13u
MN7992 (storage7983 rst vss vss) n12 w=2u l=0.13u
MN7995 (n7993 cd5 n7994 vss) n12 w=1.6u l=0.13u
MN7996 (n7994 n6901 vss vss) n12 w=1.6u l=0.13u
MP7997 (n7993 cd5 vdd vdd) p12 w=2.4u l=0.13u
MP7998 (n7993 n6901 vdd vdd) p12 w=2.4u l=0.13u
MN8001 (n7999 dd5 n8000 vss) n12 w=1.6u l=0.13u
MN8002 (n8000 n6904 vss vss) n12 w=1.6u l=0.13u
MP8003 (n7999 dd5 vdd vdd) p12 w=2.4u l=0.13u
MP8004 (n7999 n6904 vdd vdd) p12 w=2.4u l=0.13u
MN8007 (n8005 n7993 n8006 vss) n12 w=1.6u l=0.13u
MN8008 (n8006 n7999 vss vss) n12 w=1.6u l=0.13u
MP8009 (n8005 n7993 vdd vdd) p12 w=2.4u l=0.13u
MP8010 (n8005 n7999 vdd vdd) p12 w=2.4u l=0.13u
MN8015 (n8005 clk_low108 storage8014 vss) n12 w=1.2u l=0.13u
MP8016 (n8005 clk_lowb109 storage8014 vdd) p12 w=3.6u l=0.13u
MN8017 (qm8011 clk_high110 storage8014 vss) n12 w=1.2u l=0.13u
MP8018 (qm8011 clk_highb111 storage8014 vdd) p12 w=3.6u l=0.13u
MN8019 (qmb8012 storage8014 vss vss) n12 w=0.5u l=0.13u
MP8020 (qmb8012 storage8014 vdd vdd) p12 w=1.5u l=0.13u
MN8021 (qm8011 qmb8012 vss vss) n12 w=0.5u l=0.13u
MP8022 (qm8011 qmb8012 vdd vdd) p12 w=1.5u l=0.13u
MN8023 (storage8014 rst vss vss) n12 w=2u l=0.13u
MN8025 (qm8011 clk_high110 storage8024 vss) n12 w=1.2u l=0.13u
MP8026 (qm8011 clk_highb111 storage8024 vdd) p12 w=3.6u l=0.13u
MN8027 (dd5 clk_low108 storage8024 vss) n12 w=1.2u l=0.13u
MP8028 (dd5 clk_lowb109 storage8024 vdd) p12 w=3.6u l=0.13u
MN8029 (qb8013 storage8024 vss vss) n12 w=0.5u l=0.13u
MP8030 (qb8013 storage8024 vdd vdd) p12 w=1.5u l=0.13u
MN8031 (dd5 qb8013 vss vss) n12 w=0.5u l=0.13u
MP8032 (dd5 qb8013 vdd vdd) p12 w=1.5u l=0.13u
MN8033 (storage8024 rst vss vss) n12 w=2u l=0.13u
MN8036 (n8034 cd6 n8035 vss) n12 w=1.6u l=0.13u
MN8037 (n8035 n6901 vss vss) n12 w=1.6u l=0.13u
MP8038 (n8034 cd6 vdd vdd) p12 w=2.4u l=0.13u
MP8039 (n8034 n6901 vdd vdd) p12 w=2.4u l=0.13u
MN8042 (n8040 dd6 n8041 vss) n12 w=1.6u l=0.13u
MN8043 (n8041 n6904 vss vss) n12 w=1.6u l=0.13u
MP8044 (n8040 dd6 vdd vdd) p12 w=2.4u l=0.13u
MP8045 (n8040 n6904 vdd vdd) p12 w=2.4u l=0.13u
MN8048 (n8046 n8034 n8047 vss) n12 w=1.6u l=0.13u
MN8049 (n8047 n8040 vss vss) n12 w=1.6u l=0.13u
MP8050 (n8046 n8034 vdd vdd) p12 w=2.4u l=0.13u
MP8051 (n8046 n8040 vdd vdd) p12 w=2.4u l=0.13u
MN8056 (n8046 clk_low108 storage8055 vss) n12 w=1.2u l=0.13u
MP8057 (n8046 clk_lowb109 storage8055 vdd) p12 w=3.6u l=0.13u
MN8058 (qm8052 clk_high110 storage8055 vss) n12 w=1.2u l=0.13u
MP8059 (qm8052 clk_highb111 storage8055 vdd) p12 w=3.6u l=0.13u
MN8060 (qmb8053 storage8055 vss vss) n12 w=0.5u l=0.13u
MP8061 (qmb8053 storage8055 vdd vdd) p12 w=1.5u l=0.13u
MN8062 (qm8052 qmb8053 vss vss) n12 w=0.5u l=0.13u
MP8063 (qm8052 qmb8053 vdd vdd) p12 w=1.5u l=0.13u
MN8064 (storage8055 rst vss vss) n12 w=2u l=0.13u
MN8066 (qm8052 clk_high110 storage8065 vss) n12 w=1.2u l=0.13u
MP8067 (qm8052 clk_highb111 storage8065 vdd) p12 w=3.6u l=0.13u
MN8068 (dd6 clk_low108 storage8065 vss) n12 w=1.2u l=0.13u
MP8069 (dd6 clk_lowb109 storage8065 vdd) p12 w=3.6u l=0.13u
MN8070 (qb8054 storage8065 vss vss) n12 w=0.5u l=0.13u
MP8071 (qb8054 storage8065 vdd vdd) p12 w=1.5u l=0.13u
MN8072 (dd6 qb8054 vss vss) n12 w=0.5u l=0.13u
MP8073 (dd6 qb8054 vdd vdd) p12 w=1.5u l=0.13u
MN8074 (storage8065 rst vss vss) n12 w=2u l=0.13u
MN8077 (n8075 cd7 n8076 vss) n12 w=1.6u l=0.13u
MN8078 (n8076 n6901 vss vss) n12 w=1.6u l=0.13u
MP8079 (n8075 cd7 vdd vdd) p12 w=2.4u l=0.13u
MP8080 (n8075 n6901 vdd vdd) p12 w=2.4u l=0.13u
MN8083 (n8081 dd7 n8082 vss) n12 w=1.6u l=0.13u
MN8084 (n8082 n6904 vss vss) n12 w=1.6u l=0.13u
MP8085 (n8081 dd7 vdd vdd) p12 w=2.4u l=0.13u
MP8086 (n8081 n6904 vdd vdd) p12 w=2.4u l=0.13u
MN8089 (n8087 n8075 n8088 vss) n12 w=1.6u l=0.13u
MN8090 (n8088 n8081 vss vss) n12 w=1.6u l=0.13u
MP8091 (n8087 n8075 vdd vdd) p12 w=2.4u l=0.13u
MP8092 (n8087 n8081 vdd vdd) p12 w=2.4u l=0.13u
MN8097 (n8087 clk_low108 storage8096 vss) n12 w=1.2u l=0.13u
MP8098 (n8087 clk_lowb109 storage8096 vdd) p12 w=3.6u l=0.13u
MN8099 (qm8093 clk_high110 storage8096 vss) n12 w=1.2u l=0.13u
MP8100 (qm8093 clk_highb111 storage8096 vdd) p12 w=3.6u l=0.13u
MN8101 (qmb8094 storage8096 vss vss) n12 w=0.5u l=0.13u
MP8102 (qmb8094 storage8096 vdd vdd) p12 w=1.5u l=0.13u
MN8103 (qm8093 qmb8094 vss vss) n12 w=0.5u l=0.13u
MP8104 (qm8093 qmb8094 vdd vdd) p12 w=1.5u l=0.13u
MN8105 (storage8096 rst vss vss) n12 w=2u l=0.13u
MN8107 (qm8093 clk_high110 storage8106 vss) n12 w=1.2u l=0.13u
MP8108 (qm8093 clk_highb111 storage8106 vdd) p12 w=3.6u l=0.13u
MN8109 (dd7 clk_low108 storage8106 vss) n12 w=1.2u l=0.13u
MP8110 (dd7 clk_lowb109 storage8106 vdd) p12 w=3.6u l=0.13u
MN8111 (qb8095 storage8106 vss vss) n12 w=0.5u l=0.13u
MP8112 (qb8095 storage8106 vdd vdd) p12 w=1.5u l=0.13u
MN8113 (dd7 qb8095 vss vss) n12 w=0.5u l=0.13u
MP8114 (dd7 qb8095 vdd vdd) p12 w=1.5u l=0.13u
MN8115 (storage8106 rst vss vss) n12 w=2u l=0.13u
MN8118 (n8116 cd8 n8117 vss) n12 w=1.6u l=0.13u
MN8119 (n8117 n6901 vss vss) n12 w=1.6u l=0.13u
MP8120 (n8116 cd8 vdd vdd) p12 w=2.4u l=0.13u
MP8121 (n8116 n6901 vdd vdd) p12 w=2.4u l=0.13u
MN8124 (n8122 dd8 n8123 vss) n12 w=1.6u l=0.13u
MN8125 (n8123 n6904 vss vss) n12 w=1.6u l=0.13u
MP8126 (n8122 dd8 vdd vdd) p12 w=2.4u l=0.13u
MP8127 (n8122 n6904 vdd vdd) p12 w=2.4u l=0.13u
MN8130 (n8128 n8116 n8129 vss) n12 w=1.6u l=0.13u
MN8131 (n8129 n8122 vss vss) n12 w=1.6u l=0.13u
MP8132 (n8128 n8116 vdd vdd) p12 w=2.4u l=0.13u
MP8133 (n8128 n8122 vdd vdd) p12 w=2.4u l=0.13u
MN8138 (n8128 clk_low108 storage8137 vss) n12 w=1.2u l=0.13u
MP8139 (n8128 clk_lowb109 storage8137 vdd) p12 w=3.6u l=0.13u
MN8140 (qm8134 clk_high110 storage8137 vss) n12 w=1.2u l=0.13u
MP8141 (qm8134 clk_highb111 storage8137 vdd) p12 w=3.6u l=0.13u
MN8142 (qmb8135 storage8137 vss vss) n12 w=0.5u l=0.13u
MP8143 (qmb8135 storage8137 vdd vdd) p12 w=1.5u l=0.13u
MN8144 (qm8134 qmb8135 vss vss) n12 w=0.5u l=0.13u
MP8145 (qm8134 qmb8135 vdd vdd) p12 w=1.5u l=0.13u
MN8146 (storage8137 rst vss vss) n12 w=2u l=0.13u
MN8148 (qm8134 clk_high110 storage8147 vss) n12 w=1.2u l=0.13u
MP8149 (qm8134 clk_highb111 storage8147 vdd) p12 w=3.6u l=0.13u
MN8150 (dd8 clk_low108 storage8147 vss) n12 w=1.2u l=0.13u
MP8151 (dd8 clk_lowb109 storage8147 vdd) p12 w=3.6u l=0.13u
MN8152 (qb8136 storage8147 vss vss) n12 w=0.5u l=0.13u
MP8153 (qb8136 storage8147 vdd vdd) p12 w=1.5u l=0.13u
MN8154 (dd8 qb8136 vss vss) n12 w=0.5u l=0.13u
MP8155 (dd8 qb8136 vdd vdd) p12 w=1.5u l=0.13u
MN8156 (storage8147 rst vss vss) n12 w=2u l=0.13u
MN8158 (n8157 settle vss vss) n12 w=0.8u l=0.13u
MP8159 (n8157 settle vdd vdd) p12 w=2.4u l=0.13u
MN8162 (n8160 n8157 vss vss) n12 w=0.8u l=0.13u
MN8163 (n8160 rst vss vss) n12 w=0.8u l=0.13u
MP8164 (n8160 n8157 n8161 vdd) p12 w=4.8u l=0.13u
MP8165 (n8161 rst vdd vdd) p12 w=4.8u l=0.13u
MN8167 (n8166 n8160 vss vss) n12 w=0.8u l=0.13u
MP8168 (n8166 n8160 vdd vdd) p12 w=2.4u l=0.13u
MN8170 (n8169 settletick0 vss vss) n12 w=0.8u l=0.13u
MP8171 (n8169 settletick0 vdd vdd) p12 w=2.4u l=0.13u
MN8173 (n8172 n8166 vss vss) n12 w=0.8u l=0.13u
MP8174 (n8172 n8166 vdd vdd) p12 w=2.4u l=0.13u
MN8183 (n8179 n22 n8180 vss) n12 w=3.2u l=0.13u
MP8184 (n8179 n22 vdd vdd) p12 w=2.4u l=0.13u
MN8185 (n8180 n102 n8181 vss) n12 w=3.2u l=0.13u
MP8186 (n8179 n102 vdd vdd) p12 w=2.4u l=0.13u
MN8187 (n8181 clk_highb8178 n8182 vss) n12 w=3.2u l=0.13u
MP8188 (n8179 clk_highb8178 vdd vdd) p12 w=2.4u l=0.13u
MN8189 (n8182 n8172 vss vss) n12 w=3.2u l=0.13u
MP8190 (n8179 n8172 vdd vdd) p12 w=2.4u l=0.13u
MN8195 (n8191 n19 n8192 vss) n12 w=3.2u l=0.13u
MP8196 (n8191 n19 vdd vdd) p12 w=2.4u l=0.13u
MN8197 (n8192 delay99 n8193 vss) n12 w=3.2u l=0.13u
MP8198 (n8191 delay99 vdd vdd) p12 w=2.4u l=0.13u
MN8199 (n8193 clk_lowb8176 n8194 vss) n12 w=3.2u l=0.13u
MP8200 (n8191 clk_lowb8176 vdd vdd) p12 w=2.4u l=0.13u
MN8201 (n8194 n8172 vss vss) n12 w=3.2u l=0.13u
MP8202 (n8191 n8172 vdd vdd) p12 w=2.4u l=0.13u
MN8203 (clk_low8175 n8179 vss vss) n12 w=8u l=0.13u
MP8204 (clk_low8175 n8179 vdd vdd) p12 w=24u l=0.13u
MN8205 (clk_lowb8176 clk_low8175 vss vss) n12 w=8u l=0.13u
MP8206 (clk_lowb8176 clk_low8175 vdd vdd) p12 w=24u l=0.13u
MN8207 (clk_high8177 n8191 vss vss) n12 w=8u l=0.13u
MP8208 (clk_high8177 n8191 vdd vdd) p12 w=24u l=0.13u
MN8209 (clk_highb8178 clk_high8177 vss vss) n12 w=8u l=0.13u
MP8210 (clk_highb8178 clk_high8177 vdd vdd) p12 w=24u l=0.13u
MN8215 (n8169 clk_low8175 storage8214 vss) n12 w=1.2u l=0.13u
MP8216 (n8169 clk_lowb8176 storage8214 vdd) p12 w=3.6u l=0.13u
MN8217 (qm8211 clk_high8177 storage8214 vss) n12 w=1.2u l=0.13u
MP8218 (qm8211 clk_highb8178 storage8214 vdd) p12 w=3.6u l=0.13u
MN8219 (qmb8212 storage8214 vss vss) n12 w=0.5u l=0.13u
MP8220 (qmb8212 storage8214 vdd vdd) p12 w=1.5u l=0.13u
MN8221 (qm8211 qmb8212 vss vss) n12 w=0.5u l=0.13u
MP8222 (qm8211 qmb8212 vdd vdd) p12 w=1.5u l=0.13u
MN8223 (storage8214 n8166 vss vss) n12 w=2u l=0.13u
MN8225 (qm8211 clk_high8177 storage8224 vss) n12 w=1.2u l=0.13u
MP8226 (qm8211 clk_highb8178 storage8224 vdd) p12 w=3.6u l=0.13u
MN8227 (settletick0 clk_low8175 storage8224 vss) n12 w=1.2u l=0.13u
MP8228 (settletick0 clk_lowb8176 storage8224 vdd) p12 w=3.6u l=0.13u
MN8229 (qb8213 storage8224 vss vss) n12 w=0.5u l=0.13u
MP8230 (qb8213 storage8224 vdd vdd) p12 w=1.5u l=0.13u
MN8231 (settletick0 qb8213 vss vss) n12 w=0.5u l=0.13u
MP8232 (settletick0 qb8213 vdd vdd) p12 w=1.5u l=0.13u
MN8233 (storage8224 n8166 vss vss) n12 w=2u l=0.13u
MN8236 (n8234 settletick0 n8235 vss) n12 w=1.6u l=0.13u
MN8237 (n8235 settletick1 vss vss) n12 w=1.6u l=0.13u
MP8238 (n8234 settletick0 vdd vdd) p12 w=2.4u l=0.13u
MP8239 (n8234 settletick1 vdd vdd) p12 w=2.4u l=0.13u
MN8242 (n8240 n8234 n8241 vss) n12 w=1.6u l=0.13u
MN8243 (n8241 settletick0 vss vss) n12 w=1.6u l=0.13u
MP8244 (n8240 n8234 vdd vdd) p12 w=2.4u l=0.13u
MP8245 (n8240 settletick0 vdd vdd) p12 w=2.4u l=0.13u
MN8248 (n8246 n8234 n8247 vss) n12 w=1.6u l=0.13u
MN8249 (n8247 settletick1 vss vss) n12 w=1.6u l=0.13u
MP8250 (n8246 n8234 vdd vdd) p12 w=2.4u l=0.13u
MP8251 (n8246 settletick1 vdd vdd) p12 w=2.4u l=0.13u
MN8254 (n8252 n8240 n8253 vss) n12 w=1.6u l=0.13u
MN8255 (n8253 n8246 vss vss) n12 w=1.6u l=0.13u
MP8256 (n8252 n8240 vdd vdd) p12 w=2.4u l=0.13u
MP8257 (n8252 n8246 vdd vdd) p12 w=2.4u l=0.13u
MN8259 (n8258 n8234 vss vss) n12 w=0.8u l=0.13u
MP8260 (n8258 n8234 vdd vdd) p12 w=2.4u l=0.13u
MN8265 (n8252 clk_low8175 storage8264 vss) n12 w=1.2u l=0.13u
MP8266 (n8252 clk_lowb8176 storage8264 vdd) p12 w=3.6u l=0.13u
MN8267 (qm8261 clk_high8177 storage8264 vss) n12 w=1.2u l=0.13u
MP8268 (qm8261 clk_highb8178 storage8264 vdd) p12 w=3.6u l=0.13u
MN8269 (qmb8262 storage8264 vss vss) n12 w=0.5u l=0.13u
MP8270 (qmb8262 storage8264 vdd vdd) p12 w=1.5u l=0.13u
MN8271 (qm8261 qmb8262 vss vss) n12 w=0.5u l=0.13u
MP8272 (qm8261 qmb8262 vdd vdd) p12 w=1.5u l=0.13u
MN8273 (storage8264 n8166 vss vss) n12 w=2u l=0.13u
MN8275 (qm8261 clk_high8177 storage8274 vss) n12 w=1.2u l=0.13u
MP8276 (qm8261 clk_highb8178 storage8274 vdd) p12 w=3.6u l=0.13u
MN8277 (settletick1 clk_low8175 storage8274 vss) n12 w=1.2u l=0.13u
MP8278 (settletick1 clk_lowb8176 storage8274 vdd) p12 w=3.6u l=0.13u
MN8279 (qb8263 storage8274 vss vss) n12 w=0.5u l=0.13u
MP8280 (qb8263 storage8274 vdd vdd) p12 w=1.5u l=0.13u
MN8281 (settletick1 qb8263 vss vss) n12 w=0.5u l=0.13u
MP8282 (settletick1 qb8263 vdd vdd) p12 w=1.5u l=0.13u
MN8283 (storage8274 n8166 vss vss) n12 w=2u l=0.13u
MN8286 (n8284 n8258 n8285 vss) n12 w=1.6u l=0.13u
MN8287 (n8285 settletick2 vss vss) n12 w=1.6u l=0.13u
MP8288 (n8284 n8258 vdd vdd) p12 w=2.4u l=0.13u
MP8289 (n8284 settletick2 vdd vdd) p12 w=2.4u l=0.13u
MN8292 (n8290 n8258 n8291 vss) n12 w=1.6u l=0.13u
MN8293 (n8291 n8284 vss vss) n12 w=1.6u l=0.13u
MP8294 (n8290 n8258 vdd vdd) p12 w=2.4u l=0.13u
MP8295 (n8290 n8284 vdd vdd) p12 w=2.4u l=0.13u
MN8298 (n8296 n8284 n8297 vss) n12 w=1.6u l=0.13u
MN8299 (n8297 settletick2 vss vss) n12 w=1.6u l=0.13u
MP8300 (n8296 n8284 vdd vdd) p12 w=2.4u l=0.13u
MP8301 (n8296 settletick2 vdd vdd) p12 w=2.4u l=0.13u
MN8304 (n8302 n8290 n8303 vss) n12 w=1.6u l=0.13u
MN8305 (n8303 n8296 vss vss) n12 w=1.6u l=0.13u
MP8306 (n8302 n8290 vdd vdd) p12 w=2.4u l=0.13u
MP8307 (n8302 n8296 vdd vdd) p12 w=2.4u l=0.13u
MN8309 (n8308 n8284 vss vss) n12 w=0.8u l=0.13u
MP8310 (n8308 n8284 vdd vdd) p12 w=2.4u l=0.13u
MN8315 (n8302 clk_low8175 storage8314 vss) n12 w=1.2u l=0.13u
MP8316 (n8302 clk_lowb8176 storage8314 vdd) p12 w=3.6u l=0.13u
MN8317 (qm8311 clk_high8177 storage8314 vss) n12 w=1.2u l=0.13u
MP8318 (qm8311 clk_highb8178 storage8314 vdd) p12 w=3.6u l=0.13u
MN8319 (qmb8312 storage8314 vss vss) n12 w=0.5u l=0.13u
MP8320 (qmb8312 storage8314 vdd vdd) p12 w=1.5u l=0.13u
MN8321 (qm8311 qmb8312 vss vss) n12 w=0.5u l=0.13u
MP8322 (qm8311 qmb8312 vdd vdd) p12 w=1.5u l=0.13u
MN8323 (storage8314 n8166 vss vss) n12 w=2u l=0.13u
MN8325 (qm8311 clk_high8177 storage8324 vss) n12 w=1.2u l=0.13u
MP8326 (qm8311 clk_highb8178 storage8324 vdd) p12 w=3.6u l=0.13u
MN8327 (settletick2 clk_low8175 storage8324 vss) n12 w=1.2u l=0.13u
MP8328 (settletick2 clk_lowb8176 storage8324 vdd) p12 w=3.6u l=0.13u
MN8329 (qb8313 storage8324 vss vss) n12 w=0.5u l=0.13u
MP8330 (qb8313 storage8324 vdd vdd) p12 w=1.5u l=0.13u
MN8331 (settletick2 qb8313 vss vss) n12 w=0.5u l=0.13u
MP8332 (settletick2 qb8313 vdd vdd) p12 w=1.5u l=0.13u
MN8333 (storage8324 n8166 vss vss) n12 w=2u l=0.13u
MN8335 (n8334 settletick2 vss vss) n12 w=0.8u l=0.13u
MP8336 (n8334 settletick2 vdd vdd) p12 w=2.4u l=0.13u
MN8339 (n8337 settle n8338 vss) n12 w=1.6u l=0.13u
MN8340 (n8338 settletick0 vss vss) n12 w=1.6u l=0.13u
MP8341 (n8337 settle vdd vdd) p12 w=2.4u l=0.13u
MP8342 (n8337 settletick0 vdd vdd) p12 w=2.4u l=0.13u
MN8344 (n8343 n8337 vss vss) n12 w=0.8u l=0.13u
MP8345 (n8343 n8337 vdd vdd) p12 w=2.4u l=0.13u
MN8348 (n8346 n8334 n8347 vss) n12 w=1.6u l=0.13u
MN8349 (n8347 settletick1 vss vss) n12 w=1.6u l=0.13u
MP8350 (n8346 n8334 vdd vdd) p12 w=2.4u l=0.13u
MP8351 (n8346 settletick1 vdd vdd) p12 w=2.4u l=0.13u
MN8353 (n8352 n8346 vss vss) n12 w=0.8u l=0.13u
MP8354 (n8352 n8346 vdd vdd) p12 w=2.4u l=0.13u
MN8357 (n8355 n8343 n8356 vss) n12 w=1.6u l=0.13u
MN8358 (n8356 n8352 vss vss) n12 w=1.6u l=0.13u
MP8359 (n8355 n8343 vdd vdd) p12 w=2.4u l=0.13u
MP8360 (n8355 n8352 vdd vdd) p12 w=2.4u l=0.13u
MN8362 (n8361 n8355 vss vss) n12 w=0.8u l=0.13u
MP8363 (n8361 n8355 vdd vdd) p12 w=2.4u l=0.13u
MN8365 (n8364 arm vss vss) n12 w=0.8u l=0.13u
MP8366 (n8364 arm vdd vdd) p12 w=2.4u l=0.13u
MN8369 (n8367 n8364 vss vss) n12 w=0.8u l=0.13u
MN8370 (n8367 rst vss vss) n12 w=0.8u l=0.13u
MP8371 (n8367 n8364 n8368 vdd) p12 w=4.8u l=0.13u
MP8372 (n8368 rst vdd vdd) p12 w=4.8u l=0.13u
MN8374 (n8373 n8367 vss vss) n12 w=0.8u l=0.13u
MP8375 (n8373 n8367 vdd vdd) p12 w=2.4u l=0.13u
MN8377 (n8376 armtick0 vss vss) n12 w=0.8u l=0.13u
MP8378 (n8376 armtick0 vdd vdd) p12 w=2.4u l=0.13u
MN8380 (n8379 n8373 vss vss) n12 w=0.8u l=0.13u
MP8381 (n8379 n8373 vdd vdd) p12 w=2.4u l=0.13u
MN8390 (n8386 n22 n8387 vss) n12 w=3.2u l=0.13u
MP8391 (n8386 n22 vdd vdd) p12 w=2.4u l=0.13u
MN8392 (n8387 n102 n8388 vss) n12 w=3.2u l=0.13u
MP8393 (n8386 n102 vdd vdd) p12 w=2.4u l=0.13u
MN8394 (n8388 clk_highb8385 n8389 vss) n12 w=3.2u l=0.13u
MP8395 (n8386 clk_highb8385 vdd vdd) p12 w=2.4u l=0.13u
MN8396 (n8389 n8379 vss vss) n12 w=3.2u l=0.13u
MP8397 (n8386 n8379 vdd vdd) p12 w=2.4u l=0.13u
MN8402 (n8398 n19 n8399 vss) n12 w=3.2u l=0.13u
MP8403 (n8398 n19 vdd vdd) p12 w=2.4u l=0.13u
MN8404 (n8399 delay99 n8400 vss) n12 w=3.2u l=0.13u
MP8405 (n8398 delay99 vdd vdd) p12 w=2.4u l=0.13u
MN8406 (n8400 clk_lowb8383 n8401 vss) n12 w=3.2u l=0.13u
MP8407 (n8398 clk_lowb8383 vdd vdd) p12 w=2.4u l=0.13u
MN8408 (n8401 n8379 vss vss) n12 w=3.2u l=0.13u
MP8409 (n8398 n8379 vdd vdd) p12 w=2.4u l=0.13u
MN8410 (clk_low8382 n8386 vss vss) n12 w=8u l=0.13u
MP8411 (clk_low8382 n8386 vdd vdd) p12 w=24u l=0.13u
MN8412 (clk_lowb8383 clk_low8382 vss vss) n12 w=8u l=0.13u
MP8413 (clk_lowb8383 clk_low8382 vdd vdd) p12 w=24u l=0.13u
MN8414 (clk_high8384 n8398 vss vss) n12 w=8u l=0.13u
MP8415 (clk_high8384 n8398 vdd vdd) p12 w=24u l=0.13u
MN8416 (clk_highb8385 clk_high8384 vss vss) n12 w=8u l=0.13u
MP8417 (clk_highb8385 clk_high8384 vdd vdd) p12 w=24u l=0.13u
MN8422 (n8376 clk_low8382 storage8421 vss) n12 w=1.2u l=0.13u
MP8423 (n8376 clk_lowb8383 storage8421 vdd) p12 w=3.6u l=0.13u
MN8424 (qm8418 clk_high8384 storage8421 vss) n12 w=1.2u l=0.13u
MP8425 (qm8418 clk_highb8385 storage8421 vdd) p12 w=3.6u l=0.13u
MN8426 (qmb8419 storage8421 vss vss) n12 w=0.5u l=0.13u
MP8427 (qmb8419 storage8421 vdd vdd) p12 w=1.5u l=0.13u
MN8428 (qm8418 qmb8419 vss vss) n12 w=0.5u l=0.13u
MP8429 (qm8418 qmb8419 vdd vdd) p12 w=1.5u l=0.13u
MN8430 (storage8421 n8373 vss vss) n12 w=2u l=0.13u
MN8432 (qm8418 clk_high8384 storage8431 vss) n12 w=1.2u l=0.13u
MP8433 (qm8418 clk_highb8385 storage8431 vdd) p12 w=3.6u l=0.13u
MN8434 (armtick0 clk_low8382 storage8431 vss) n12 w=1.2u l=0.13u
MP8435 (armtick0 clk_lowb8383 storage8431 vdd) p12 w=3.6u l=0.13u
MN8436 (qb8420 storage8431 vss vss) n12 w=0.5u l=0.13u
MP8437 (qb8420 storage8431 vdd vdd) p12 w=1.5u l=0.13u
MN8438 (armtick0 qb8420 vss vss) n12 w=0.5u l=0.13u
MP8439 (armtick0 qb8420 vdd vdd) p12 w=1.5u l=0.13u
MN8440 (storage8431 n8373 vss vss) n12 w=2u l=0.13u
MN8443 (n8441 armtick0 n8442 vss) n12 w=1.6u l=0.13u
MN8444 (n8442 armtick1 vss vss) n12 w=1.6u l=0.13u
MP8445 (n8441 armtick0 vdd vdd) p12 w=2.4u l=0.13u
MP8446 (n8441 armtick1 vdd vdd) p12 w=2.4u l=0.13u
MN8449 (n8447 armtick0 n8448 vss) n12 w=1.6u l=0.13u
MN8450 (n8448 n8441 vss vss) n12 w=1.6u l=0.13u
MP8451 (n8447 armtick0 vdd vdd) p12 w=2.4u l=0.13u
MP8452 (n8447 n8441 vdd vdd) p12 w=2.4u l=0.13u
MN8455 (n8453 armtick1 n8454 vss) n12 w=1.6u l=0.13u
MN8456 (n8454 n8441 vss vss) n12 w=1.6u l=0.13u
MP8457 (n8453 armtick1 vdd vdd) p12 w=2.4u l=0.13u
MP8458 (n8453 n8441 vdd vdd) p12 w=2.4u l=0.13u
MN8461 (n8459 n8447 n8460 vss) n12 w=1.6u l=0.13u
MN8462 (n8460 n8453 vss vss) n12 w=1.6u l=0.13u
MP8463 (n8459 n8447 vdd vdd) p12 w=2.4u l=0.13u
MP8464 (n8459 n8453 vdd vdd) p12 w=2.4u l=0.13u
MN8466 (n8465 n8441 vss vss) n12 w=0.8u l=0.13u
MP8467 (n8465 n8441 vdd vdd) p12 w=2.4u l=0.13u
MN8472 (n8459 clk_low8382 storage8471 vss) n12 w=1.2u l=0.13u
MP8473 (n8459 clk_lowb8383 storage8471 vdd) p12 w=3.6u l=0.13u
MN8474 (qm8468 clk_high8384 storage8471 vss) n12 w=1.2u l=0.13u
MP8475 (qm8468 clk_highb8385 storage8471 vdd) p12 w=3.6u l=0.13u
MN8476 (qmb8469 storage8471 vss vss) n12 w=0.5u l=0.13u
MP8477 (qmb8469 storage8471 vdd vdd) p12 w=1.5u l=0.13u
MN8478 (qm8468 qmb8469 vss vss) n12 w=0.5u l=0.13u
MP8479 (qm8468 qmb8469 vdd vdd) p12 w=1.5u l=0.13u
MN8480 (storage8471 n8373 vss vss) n12 w=2u l=0.13u
MN8482 (qm8468 clk_high8384 storage8481 vss) n12 w=1.2u l=0.13u
MP8483 (qm8468 clk_highb8385 storage8481 vdd) p12 w=3.6u l=0.13u
MN8484 (armtick1 clk_low8382 storage8481 vss) n12 w=1.2u l=0.13u
MP8485 (armtick1 clk_lowb8383 storage8481 vdd) p12 w=3.6u l=0.13u
MN8486 (qb8470 storage8481 vss vss) n12 w=0.5u l=0.13u
MP8487 (qb8470 storage8481 vdd vdd) p12 w=1.5u l=0.13u
MN8488 (armtick1 qb8470 vss vss) n12 w=0.5u l=0.13u
MP8489 (armtick1 qb8470 vdd vdd) p12 w=1.5u l=0.13u
MN8490 (storage8481 n8373 vss vss) n12 w=2u l=0.13u
MN8493 (n8491 armtick2 n8492 vss) n12 w=1.6u l=0.13u
MN8494 (n8492 n8465 vss vss) n12 w=1.6u l=0.13u
MP8495 (n8491 armtick2 vdd vdd) p12 w=2.4u l=0.13u
MP8496 (n8491 n8465 vdd vdd) p12 w=2.4u l=0.13u
MN8499 (n8497 armtick2 n8498 vss) n12 w=1.6u l=0.13u
MN8500 (n8498 n8491 vss vss) n12 w=1.6u l=0.13u
MP8501 (n8497 armtick2 vdd vdd) p12 w=2.4u l=0.13u
MP8502 (n8497 n8491 vdd vdd) p12 w=2.4u l=0.13u
MN8505 (n8503 n8465 n8504 vss) n12 w=1.6u l=0.13u
MN8506 (n8504 n8491 vss vss) n12 w=1.6u l=0.13u
MP8507 (n8503 n8465 vdd vdd) p12 w=2.4u l=0.13u
MP8508 (n8503 n8491 vdd vdd) p12 w=2.4u l=0.13u
MN8511 (n8509 n8497 n8510 vss) n12 w=1.6u l=0.13u
MN8512 (n8510 n8503 vss vss) n12 w=1.6u l=0.13u
MP8513 (n8509 n8497 vdd vdd) p12 w=2.4u l=0.13u
MP8514 (n8509 n8503 vdd vdd) p12 w=2.4u l=0.13u
MN8516 (n8515 n8491 vss vss) n12 w=0.8u l=0.13u
MP8517 (n8515 n8491 vdd vdd) p12 w=2.4u l=0.13u
MN8522 (n8509 clk_low8382 storage8521 vss) n12 w=1.2u l=0.13u
MP8523 (n8509 clk_lowb8383 storage8521 vdd) p12 w=3.6u l=0.13u
MN8524 (qm8518 clk_high8384 storage8521 vss) n12 w=1.2u l=0.13u
MP8525 (qm8518 clk_highb8385 storage8521 vdd) p12 w=3.6u l=0.13u
MN8526 (qmb8519 storage8521 vss vss) n12 w=0.5u l=0.13u
MP8527 (qmb8519 storage8521 vdd vdd) p12 w=1.5u l=0.13u
MN8528 (qm8518 qmb8519 vss vss) n12 w=0.5u l=0.13u
MP8529 (qm8518 qmb8519 vdd vdd) p12 w=1.5u l=0.13u
MN8530 (storage8521 n8373 vss vss) n12 w=2u l=0.13u
MN8532 (qm8518 clk_high8384 storage8531 vss) n12 w=1.2u l=0.13u
MP8533 (qm8518 clk_highb8385 storage8531 vdd) p12 w=3.6u l=0.13u
MN8534 (armtick2 clk_low8382 storage8531 vss) n12 w=1.2u l=0.13u
MP8535 (armtick2 clk_lowb8383 storage8531 vdd) p12 w=3.6u l=0.13u
MN8536 (qb8520 storage8531 vss vss) n12 w=0.5u l=0.13u
MP8537 (qb8520 storage8531 vdd vdd) p12 w=1.5u l=0.13u
MN8538 (armtick2 qb8520 vss vss) n12 w=0.5u l=0.13u
MP8539 (armtick2 qb8520 vdd vdd) p12 w=1.5u l=0.13u
MN8540 (storage8531 n8373 vss vss) n12 w=2u l=0.13u
MN8543 (n8541 armtick3 n8542 vss) n12 w=1.6u l=0.13u
MN8544 (n8542 n8515 vss vss) n12 w=1.6u l=0.13u
MP8545 (n8541 armtick3 vdd vdd) p12 w=2.4u l=0.13u
MP8546 (n8541 n8515 vdd vdd) p12 w=2.4u l=0.13u
MN8549 (n8547 armtick3 n8548 vss) n12 w=1.6u l=0.13u
MN8550 (n8548 n8541 vss vss) n12 w=1.6u l=0.13u
MP8551 (n8547 armtick3 vdd vdd) p12 w=2.4u l=0.13u
MP8552 (n8547 n8541 vdd vdd) p12 w=2.4u l=0.13u
MN8555 (n8553 n8515 n8554 vss) n12 w=1.6u l=0.13u
MN8556 (n8554 n8541 vss vss) n12 w=1.6u l=0.13u
MP8557 (n8553 n8515 vdd vdd) p12 w=2.4u l=0.13u
MP8558 (n8553 n8541 vdd vdd) p12 w=2.4u l=0.13u
MN8561 (n8559 n8547 n8560 vss) n12 w=1.6u l=0.13u
MN8562 (n8560 n8553 vss vss) n12 w=1.6u l=0.13u
MP8563 (n8559 n8547 vdd vdd) p12 w=2.4u l=0.13u
MP8564 (n8559 n8553 vdd vdd) p12 w=2.4u l=0.13u
MN8566 (n8565 n8541 vss vss) n12 w=0.8u l=0.13u
MP8567 (n8565 n8541 vdd vdd) p12 w=2.4u l=0.13u
MN8572 (n8559 clk_low8382 storage8571 vss) n12 w=1.2u l=0.13u
MP8573 (n8559 clk_lowb8383 storage8571 vdd) p12 w=3.6u l=0.13u
MN8574 (qm8568 clk_high8384 storage8571 vss) n12 w=1.2u l=0.13u
MP8575 (qm8568 clk_highb8385 storage8571 vdd) p12 w=3.6u l=0.13u
MN8576 (qmb8569 storage8571 vss vss) n12 w=0.5u l=0.13u
MP8577 (qmb8569 storage8571 vdd vdd) p12 w=1.5u l=0.13u
MN8578 (qm8568 qmb8569 vss vss) n12 w=0.5u l=0.13u
MP8579 (qm8568 qmb8569 vdd vdd) p12 w=1.5u l=0.13u
MN8580 (storage8571 n8373 vss vss) n12 w=2u l=0.13u
MN8582 (qm8568 clk_high8384 storage8581 vss) n12 w=1.2u l=0.13u
MP8583 (qm8568 clk_highb8385 storage8581 vdd) p12 w=3.6u l=0.13u
MN8584 (armtick3 clk_low8382 storage8581 vss) n12 w=1.2u l=0.13u
MP8585 (armtick3 clk_lowb8383 storage8581 vdd) p12 w=3.6u l=0.13u
MN8586 (qb8570 storage8581 vss vss) n12 w=0.5u l=0.13u
MP8587 (qb8570 storage8581 vdd vdd) p12 w=1.5u l=0.13u
MN8588 (armtick3 qb8570 vss vss) n12 w=0.5u l=0.13u
MP8589 (armtick3 qb8570 vdd vdd) p12 w=1.5u l=0.13u
MN8590 (storage8581 n8373 vss vss) n12 w=2u l=0.13u
MN8593 (n8591 armtick4 n8592 vss) n12 w=1.6u l=0.13u
MN8594 (n8592 n8565 vss vss) n12 w=1.6u l=0.13u
MP8595 (n8591 armtick4 vdd vdd) p12 w=2.4u l=0.13u
MP8596 (n8591 n8565 vdd vdd) p12 w=2.4u l=0.13u
MN8599 (n8597 armtick4 n8598 vss) n12 w=1.6u l=0.13u
MN8600 (n8598 n8591 vss vss) n12 w=1.6u l=0.13u
MP8601 (n8597 armtick4 vdd vdd) p12 w=2.4u l=0.13u
MP8602 (n8597 n8591 vdd vdd) p12 w=2.4u l=0.13u
MN8605 (n8603 n8565 n8604 vss) n12 w=1.6u l=0.13u
MN8606 (n8604 n8591 vss vss) n12 w=1.6u l=0.13u
MP8607 (n8603 n8565 vdd vdd) p12 w=2.4u l=0.13u
MP8608 (n8603 n8591 vdd vdd) p12 w=2.4u l=0.13u
MN8611 (n8609 n8597 n8610 vss) n12 w=1.6u l=0.13u
MN8612 (n8610 n8603 vss vss) n12 w=1.6u l=0.13u
MP8613 (n8609 n8597 vdd vdd) p12 w=2.4u l=0.13u
MP8614 (n8609 n8603 vdd vdd) p12 w=2.4u l=0.13u
MN8616 (n8615 n8591 vss vss) n12 w=0.8u l=0.13u
MP8617 (n8615 n8591 vdd vdd) p12 w=2.4u l=0.13u
MN8622 (n8609 clk_low8382 storage8621 vss) n12 w=1.2u l=0.13u
MP8623 (n8609 clk_lowb8383 storage8621 vdd) p12 w=3.6u l=0.13u
MN8624 (qm8618 clk_high8384 storage8621 vss) n12 w=1.2u l=0.13u
MP8625 (qm8618 clk_highb8385 storage8621 vdd) p12 w=3.6u l=0.13u
MN8626 (qmb8619 storage8621 vss vss) n12 w=0.5u l=0.13u
MP8627 (qmb8619 storage8621 vdd vdd) p12 w=1.5u l=0.13u
MN8628 (qm8618 qmb8619 vss vss) n12 w=0.5u l=0.13u
MP8629 (qm8618 qmb8619 vdd vdd) p12 w=1.5u l=0.13u
MN8630 (storage8621 n8373 vss vss) n12 w=2u l=0.13u
MN8632 (qm8618 clk_high8384 storage8631 vss) n12 w=1.2u l=0.13u
MP8633 (qm8618 clk_highb8385 storage8631 vdd) p12 w=3.6u l=0.13u
MN8634 (armtick4 clk_low8382 storage8631 vss) n12 w=1.2u l=0.13u
MP8635 (armtick4 clk_lowb8383 storage8631 vdd) p12 w=3.6u l=0.13u
MN8636 (qb8620 storage8631 vss vss) n12 w=0.5u l=0.13u
MP8637 (qb8620 storage8631 vdd vdd) p12 w=1.5u l=0.13u
MN8638 (armtick4 qb8620 vss vss) n12 w=0.5u l=0.13u
MP8639 (armtick4 qb8620 vdd vdd) p12 w=1.5u l=0.13u
MN8640 (storage8631 n8373 vss vss) n12 w=2u l=0.13u
MN8643 (n8641 armtick5 n8642 vss) n12 w=1.6u l=0.13u
MN8644 (n8642 n8615 vss vss) n12 w=1.6u l=0.13u
MP8645 (n8641 armtick5 vdd vdd) p12 w=2.4u l=0.13u
MP8646 (n8641 n8615 vdd vdd) p12 w=2.4u l=0.13u
MN8649 (n8647 armtick5 n8648 vss) n12 w=1.6u l=0.13u
MN8650 (n8648 n8641 vss vss) n12 w=1.6u l=0.13u
MP8651 (n8647 armtick5 vdd vdd) p12 w=2.4u l=0.13u
MP8652 (n8647 n8641 vdd vdd) p12 w=2.4u l=0.13u
MN8655 (n8653 n8615 n8654 vss) n12 w=1.6u l=0.13u
MN8656 (n8654 n8641 vss vss) n12 w=1.6u l=0.13u
MP8657 (n8653 n8615 vdd vdd) p12 w=2.4u l=0.13u
MP8658 (n8653 n8641 vdd vdd) p12 w=2.4u l=0.13u
MN8661 (n8659 n8647 n8660 vss) n12 w=1.6u l=0.13u
MN8662 (n8660 n8653 vss vss) n12 w=1.6u l=0.13u
MP8663 (n8659 n8647 vdd vdd) p12 w=2.4u l=0.13u
MP8664 (n8659 n8653 vdd vdd) p12 w=2.4u l=0.13u
MN8666 (n8665 n8641 vss vss) n12 w=0.8u l=0.13u
MP8667 (n8665 n8641 vdd vdd) p12 w=2.4u l=0.13u
MN8672 (n8659 clk_low8382 storage8671 vss) n12 w=1.2u l=0.13u
MP8673 (n8659 clk_lowb8383 storage8671 vdd) p12 w=3.6u l=0.13u
MN8674 (qm8668 clk_high8384 storage8671 vss) n12 w=1.2u l=0.13u
MP8675 (qm8668 clk_highb8385 storage8671 vdd) p12 w=3.6u l=0.13u
MN8676 (qmb8669 storage8671 vss vss) n12 w=0.5u l=0.13u
MP8677 (qmb8669 storage8671 vdd vdd) p12 w=1.5u l=0.13u
MN8678 (qm8668 qmb8669 vss vss) n12 w=0.5u l=0.13u
MP8679 (qm8668 qmb8669 vdd vdd) p12 w=1.5u l=0.13u
MN8680 (storage8671 n8373 vss vss) n12 w=2u l=0.13u
MN8682 (qm8668 clk_high8384 storage8681 vss) n12 w=1.2u l=0.13u
MP8683 (qm8668 clk_highb8385 storage8681 vdd) p12 w=3.6u l=0.13u
MN8684 (armtick5 clk_low8382 storage8681 vss) n12 w=1.2u l=0.13u
MP8685 (armtick5 clk_lowb8383 storage8681 vdd) p12 w=3.6u l=0.13u
MN8686 (qb8670 storage8681 vss vss) n12 w=0.5u l=0.13u
MP8687 (qb8670 storage8681 vdd vdd) p12 w=1.5u l=0.13u
MN8688 (armtick5 qb8670 vss vss) n12 w=0.5u l=0.13u
MP8689 (armtick5 qb8670 vdd vdd) p12 w=1.5u l=0.13u
MN8690 (storage8681 n8373 vss vss) n12 w=2u l=0.13u
MN8693 (n8691 arm n8692 vss) n12 w=1.6u l=0.13u
MN8694 (n8692 epoch_valid vss vss) n12 w=1.6u l=0.13u
MP8695 (n8691 arm vdd vdd) p12 w=2.4u l=0.13u
MP8696 (n8691 epoch_valid vdd vdd) p12 w=2.4u l=0.13u
MN8698 (n8697 n8691 vss vss) n12 w=0.8u l=0.13u
MP8699 (n8697 n8691 vdd vdd) p12 w=2.4u l=0.13u
MN8701 (n8700 epoch_valid vss vss) n12 w=0.8u l=0.13u
MP8702 (n8700 epoch_valid vdd vdd) p12 w=2.4u l=0.13u
MN8705 (n8703 arm n8704 vss) n12 w=1.6u l=0.13u
MN8706 (n8704 armtick5 vss vss) n12 w=1.6u l=0.13u
MP8707 (n8703 arm vdd vdd) p12 w=2.4u l=0.13u
MP8708 (n8703 armtick5 vdd vdd) p12 w=2.4u l=0.13u
MN8710 (n8709 n8703 vss vss) n12 w=0.8u l=0.13u
MP8711 (n8709 n8703 vdd vdd) p12 w=2.4u l=0.13u
MN8714 (n8712 n8700 n8713 vss) n12 w=1.6u l=0.13u
MN8715 (n8713 n8709 vss vss) n12 w=1.6u l=0.13u
MP8716 (n8712 n8700 vdd vdd) p12 w=2.4u l=0.13u
MP8717 (n8712 n8709 vdd vdd) p12 w=2.4u l=0.13u
MN8719 (n8718 n8712 vss vss) n12 w=0.8u l=0.13u
MP8720 (n8718 n8712 vdd vdd) p12 w=2.4u l=0.13u
MN8722 (n8721 drain vss vss) n12 w=0.8u l=0.13u
MP8723 (n8721 drain vdd vdd) p12 w=2.4u l=0.13u
MN8726 (n8724 n8721 vss vss) n12 w=0.8u l=0.13u
MN8727 (n8724 rst vss vss) n12 w=0.8u l=0.13u
MP8728 (n8724 n8721 n8725 vdd) p12 w=4.8u l=0.13u
MP8729 (n8725 rst vdd vdd) p12 w=4.8u l=0.13u
MN8731 (n8730 n8724 vss vss) n12 w=0.8u l=0.13u
MP8732 (n8730 n8724 vdd vdd) p12 w=2.4u l=0.13u
MN8734 (n8733 draintick0 vss vss) n12 w=0.8u l=0.13u
MP8735 (n8733 draintick0 vdd vdd) p12 w=2.4u l=0.13u
MN8737 (n8736 n8730 vss vss) n12 w=0.8u l=0.13u
MP8738 (n8736 n8730 vdd vdd) p12 w=2.4u l=0.13u
MN8747 (n8743 n22 n8744 vss) n12 w=3.2u l=0.13u
MP8748 (n8743 n22 vdd vdd) p12 w=2.4u l=0.13u
MN8749 (n8744 n102 n8745 vss) n12 w=3.2u l=0.13u
MP8750 (n8743 n102 vdd vdd) p12 w=2.4u l=0.13u
MN8751 (n8745 clk_highb8742 n8746 vss) n12 w=3.2u l=0.13u
MP8752 (n8743 clk_highb8742 vdd vdd) p12 w=2.4u l=0.13u
MN8753 (n8746 n8736 vss vss) n12 w=3.2u l=0.13u
MP8754 (n8743 n8736 vdd vdd) p12 w=2.4u l=0.13u
MN8759 (n8755 n19 n8756 vss) n12 w=3.2u l=0.13u
MP8760 (n8755 n19 vdd vdd) p12 w=2.4u l=0.13u
MN8761 (n8756 delay99 n8757 vss) n12 w=3.2u l=0.13u
MP8762 (n8755 delay99 vdd vdd) p12 w=2.4u l=0.13u
MN8763 (n8757 clk_lowb8740 n8758 vss) n12 w=3.2u l=0.13u
MP8764 (n8755 clk_lowb8740 vdd vdd) p12 w=2.4u l=0.13u
MN8765 (n8758 n8736 vss vss) n12 w=3.2u l=0.13u
MP8766 (n8755 n8736 vdd vdd) p12 w=2.4u l=0.13u
MN8767 (clk_low8739 n8743 vss vss) n12 w=8u l=0.13u
MP8768 (clk_low8739 n8743 vdd vdd) p12 w=24u l=0.13u
MN8769 (clk_lowb8740 clk_low8739 vss vss) n12 w=8u l=0.13u
MP8770 (clk_lowb8740 clk_low8739 vdd vdd) p12 w=24u l=0.13u
MN8771 (clk_high8741 n8755 vss vss) n12 w=8u l=0.13u
MP8772 (clk_high8741 n8755 vdd vdd) p12 w=24u l=0.13u
MN8773 (clk_highb8742 clk_high8741 vss vss) n12 w=8u l=0.13u
MP8774 (clk_highb8742 clk_high8741 vdd vdd) p12 w=24u l=0.13u
MN8779 (n8733 clk_low8739 storage8778 vss) n12 w=1.2u l=0.13u
MP8780 (n8733 clk_lowb8740 storage8778 vdd) p12 w=3.6u l=0.13u
MN8781 (qm8775 clk_high8741 storage8778 vss) n12 w=1.2u l=0.13u
MP8782 (qm8775 clk_highb8742 storage8778 vdd) p12 w=3.6u l=0.13u
MN8783 (qmb8776 storage8778 vss vss) n12 w=0.5u l=0.13u
MP8784 (qmb8776 storage8778 vdd vdd) p12 w=1.5u l=0.13u
MN8785 (qm8775 qmb8776 vss vss) n12 w=0.5u l=0.13u
MP8786 (qm8775 qmb8776 vdd vdd) p12 w=1.5u l=0.13u
MN8787 (storage8778 n8730 vss vss) n12 w=2u l=0.13u
MN8789 (qm8775 clk_high8741 storage8788 vss) n12 w=1.2u l=0.13u
MP8790 (qm8775 clk_highb8742 storage8788 vdd) p12 w=3.6u l=0.13u
MN8791 (draintick0 clk_low8739 storage8788 vss) n12 w=1.2u l=0.13u
MP8792 (draintick0 clk_lowb8740 storage8788 vdd) p12 w=3.6u l=0.13u
MN8793 (qb8777 storage8788 vss vss) n12 w=0.5u l=0.13u
MP8794 (qb8777 storage8788 vdd vdd) p12 w=1.5u l=0.13u
MN8795 (draintick0 qb8777 vss vss) n12 w=0.5u l=0.13u
MP8796 (draintick0 qb8777 vdd vdd) p12 w=1.5u l=0.13u
MN8797 (storage8788 n8730 vss vss) n12 w=2u l=0.13u
MN8800 (n8798 draintick0 n8799 vss) n12 w=1.6u l=0.13u
MN8801 (n8799 draintick1 vss vss) n12 w=1.6u l=0.13u
MP8802 (n8798 draintick0 vdd vdd) p12 w=2.4u l=0.13u
MP8803 (n8798 draintick1 vdd vdd) p12 w=2.4u l=0.13u
MN8806 (n8804 draintick0 n8805 vss) n12 w=1.6u l=0.13u
MN8807 (n8805 n8798 vss vss) n12 w=1.6u l=0.13u
MP8808 (n8804 draintick0 vdd vdd) p12 w=2.4u l=0.13u
MP8809 (n8804 n8798 vdd vdd) p12 w=2.4u l=0.13u
MN8812 (n8810 draintick1 n8811 vss) n12 w=1.6u l=0.13u
MN8813 (n8811 n8798 vss vss) n12 w=1.6u l=0.13u
MP8814 (n8810 draintick1 vdd vdd) p12 w=2.4u l=0.13u
MP8815 (n8810 n8798 vdd vdd) p12 w=2.4u l=0.13u
MN8818 (n8816 n8804 n8817 vss) n12 w=1.6u l=0.13u
MN8819 (n8817 n8810 vss vss) n12 w=1.6u l=0.13u
MP8820 (n8816 n8804 vdd vdd) p12 w=2.4u l=0.13u
MP8821 (n8816 n8810 vdd vdd) p12 w=2.4u l=0.13u
MN8823 (n8822 n8798 vss vss) n12 w=0.8u l=0.13u
MP8824 (n8822 n8798 vdd vdd) p12 w=2.4u l=0.13u
MN8829 (n8816 clk_low8739 storage8828 vss) n12 w=1.2u l=0.13u
MP8830 (n8816 clk_lowb8740 storage8828 vdd) p12 w=3.6u l=0.13u
MN8831 (qm8825 clk_high8741 storage8828 vss) n12 w=1.2u l=0.13u
MP8832 (qm8825 clk_highb8742 storage8828 vdd) p12 w=3.6u l=0.13u
MN8833 (qmb8826 storage8828 vss vss) n12 w=0.5u l=0.13u
MP8834 (qmb8826 storage8828 vdd vdd) p12 w=1.5u l=0.13u
MN8835 (qm8825 qmb8826 vss vss) n12 w=0.5u l=0.13u
MP8836 (qm8825 qmb8826 vdd vdd) p12 w=1.5u l=0.13u
MN8837 (storage8828 n8730 vss vss) n12 w=2u l=0.13u
MN8839 (qm8825 clk_high8741 storage8838 vss) n12 w=1.2u l=0.13u
MP8840 (qm8825 clk_highb8742 storage8838 vdd) p12 w=3.6u l=0.13u
MN8841 (draintick1 clk_low8739 storage8838 vss) n12 w=1.2u l=0.13u
MP8842 (draintick1 clk_lowb8740 storage8838 vdd) p12 w=3.6u l=0.13u
MN8843 (qb8827 storage8838 vss vss) n12 w=0.5u l=0.13u
MP8844 (qb8827 storage8838 vdd vdd) p12 w=1.5u l=0.13u
MN8845 (draintick1 qb8827 vss vss) n12 w=0.5u l=0.13u
MP8846 (draintick1 qb8827 vdd vdd) p12 w=1.5u l=0.13u
MN8847 (storage8838 n8730 vss vss) n12 w=2u l=0.13u
MN8850 (n8848 drain n8849 vss) n12 w=1.6u l=0.13u
MN8851 (n8849 draintick0 vss vss) n12 w=1.6u l=0.13u
MP8852 (n8848 drain vdd vdd) p12 w=2.4u l=0.13u
MP8853 (n8848 draintick0 vdd vdd) p12 w=2.4u l=0.13u
MN8855 (n8854 n8848 vss vss) n12 w=0.8u l=0.13u
MP8856 (n8854 n8848 vdd vdd) p12 w=2.4u l=0.13u
MN8858 (n8857 n337 vss vss) n12 w=0.8u l=0.13u
MP8859 (n8857 n337 vdd vdd) p12 w=2.4u l=0.13u
MN8861 (n8860 n8857 vss vss) n12 w=0.8u l=0.13u
MP8862 (n8860 n8857 vdd vdd) p12 w=2.4u l=0.13u
MN8863 (counter_age_reset n8860 vss vss) n12 w=0.8u l=0.13u
MP8864 (counter_age_reset n8860 vdd vdd) p12 w=2.4u l=0.13u
MN8866 (n8865 counterage0 vss vss) n12 w=0.8u l=0.13u
MP8867 (n8865 counterage0 vdd vdd) p12 w=2.4u l=0.13u
MN8869 (n8868 counter_age_reset vss vss) n12 w=0.8u l=0.13u
MP8870 (n8868 counter_age_reset vdd vdd) p12 w=2.4u l=0.13u
MN8879 (n8875 n22 n8876 vss) n12 w=3.2u l=0.13u
MP8880 (n8875 n22 vdd vdd) p12 w=2.4u l=0.13u
MN8881 (n8876 n102 n8877 vss) n12 w=3.2u l=0.13u
MP8882 (n8875 n102 vdd vdd) p12 w=2.4u l=0.13u
MN8883 (n8877 clk_highb8874 n8878 vss) n12 w=3.2u l=0.13u
MP8884 (n8875 clk_highb8874 vdd vdd) p12 w=2.4u l=0.13u
MN8885 (n8878 n8868 vss vss) n12 w=3.2u l=0.13u
MP8886 (n8875 n8868 vdd vdd) p12 w=2.4u l=0.13u
MN8891 (n8887 n19 n8888 vss) n12 w=3.2u l=0.13u
MP8892 (n8887 n19 vdd vdd) p12 w=2.4u l=0.13u
MN8893 (n8888 delay99 n8889 vss) n12 w=3.2u l=0.13u
MP8894 (n8887 delay99 vdd vdd) p12 w=2.4u l=0.13u
MN8895 (n8889 clk_lowb8872 n8890 vss) n12 w=3.2u l=0.13u
MP8896 (n8887 clk_lowb8872 vdd vdd) p12 w=2.4u l=0.13u
MN8897 (n8890 n8868 vss vss) n12 w=3.2u l=0.13u
MP8898 (n8887 n8868 vdd vdd) p12 w=2.4u l=0.13u
MN8899 (clk_low8871 n8875 vss vss) n12 w=8u l=0.13u
MP8900 (clk_low8871 n8875 vdd vdd) p12 w=24u l=0.13u
MN8901 (clk_lowb8872 clk_low8871 vss vss) n12 w=8u l=0.13u
MP8902 (clk_lowb8872 clk_low8871 vdd vdd) p12 w=24u l=0.13u
MN8903 (clk_high8873 n8887 vss vss) n12 w=8u l=0.13u
MP8904 (clk_high8873 n8887 vdd vdd) p12 w=24u l=0.13u
MN8905 (clk_highb8874 clk_high8873 vss vss) n12 w=8u l=0.13u
MP8906 (clk_highb8874 clk_high8873 vdd vdd) p12 w=24u l=0.13u
MN8911 (n8865 clk_low8871 storage8910 vss) n12 w=1.2u l=0.13u
MP8912 (n8865 clk_lowb8872 storage8910 vdd) p12 w=3.6u l=0.13u
MN8913 (qm8907 clk_high8873 storage8910 vss) n12 w=1.2u l=0.13u
MP8914 (qm8907 clk_highb8874 storage8910 vdd) p12 w=3.6u l=0.13u
MN8915 (qmb8908 storage8910 vss vss) n12 w=0.5u l=0.13u
MP8916 (qmb8908 storage8910 vdd vdd) p12 w=1.5u l=0.13u
MN8917 (qm8907 qmb8908 vss vss) n12 w=0.5u l=0.13u
MP8918 (qm8907 qmb8908 vdd vdd) p12 w=1.5u l=0.13u
MN8919 (storage8910 counter_age_reset vss vss) n12 w=2u l=0.13u
MN8921 (qm8907 clk_high8873 storage8920 vss) n12 w=1.2u l=0.13u
MP8922 (qm8907 clk_highb8874 storage8920 vdd) p12 w=3.6u l=0.13u
MN8923 (counterage0 clk_low8871 storage8920 vss) n12 w=1.2u l=0.13u
MP8924 (counterage0 clk_lowb8872 storage8920 vdd) p12 w=3.6u l=0.13u
MN8925 (qb8909 storage8920 vss vss) n12 w=0.5u l=0.13u
MP8926 (qb8909 storage8920 vdd vdd) p12 w=1.5u l=0.13u
MN8927 (counterage0 qb8909 vss vss) n12 w=0.5u l=0.13u
MP8928 (counterage0 qb8909 vdd vdd) p12 w=1.5u l=0.13u
MN8929 (storage8920 counter_age_reset vss vss) n12 w=2u l=0.13u
MN8932 (n8930 counterage0 n8931 vss) n12 w=1.6u l=0.13u
MN8933 (n8931 counterage1 vss vss) n12 w=1.6u l=0.13u
MP8934 (n8930 counterage0 vdd vdd) p12 w=2.4u l=0.13u
MP8935 (n8930 counterage1 vdd vdd) p12 w=2.4u l=0.13u
MN8938 (n8936 counterage0 n8937 vss) n12 w=1.6u l=0.13u
MN8939 (n8937 n8930 vss vss) n12 w=1.6u l=0.13u
MP8940 (n8936 counterage0 vdd vdd) p12 w=2.4u l=0.13u
MP8941 (n8936 n8930 vdd vdd) p12 w=2.4u l=0.13u
MN8944 (n8942 counterage1 n8943 vss) n12 w=1.6u l=0.13u
MN8945 (n8943 n8930 vss vss) n12 w=1.6u l=0.13u
MP8946 (n8942 counterage1 vdd vdd) p12 w=2.4u l=0.13u
MP8947 (n8942 n8930 vdd vdd) p12 w=2.4u l=0.13u
MN8950 (n8948 n8936 n8949 vss) n12 w=1.6u l=0.13u
MN8951 (n8949 n8942 vss vss) n12 w=1.6u l=0.13u
MP8952 (n8948 n8936 vdd vdd) p12 w=2.4u l=0.13u
MP8953 (n8948 n8942 vdd vdd) p12 w=2.4u l=0.13u
MN8955 (n8954 n8930 vss vss) n12 w=0.8u l=0.13u
MP8956 (n8954 n8930 vdd vdd) p12 w=2.4u l=0.13u
MN8961 (n8948 clk_low8871 storage8960 vss) n12 w=1.2u l=0.13u
MP8962 (n8948 clk_lowb8872 storage8960 vdd) p12 w=3.6u l=0.13u
MN8963 (qm8957 clk_high8873 storage8960 vss) n12 w=1.2u l=0.13u
MP8964 (qm8957 clk_highb8874 storage8960 vdd) p12 w=3.6u l=0.13u
MN8965 (qmb8958 storage8960 vss vss) n12 w=0.5u l=0.13u
MP8966 (qmb8958 storage8960 vdd vdd) p12 w=1.5u l=0.13u
MN8967 (qm8957 qmb8958 vss vss) n12 w=0.5u l=0.13u
MP8968 (qm8957 qmb8958 vdd vdd) p12 w=1.5u l=0.13u
MN8969 (storage8960 counter_age_reset vss vss) n12 w=2u l=0.13u
MN8971 (qm8957 clk_high8873 storage8970 vss) n12 w=1.2u l=0.13u
MP8972 (qm8957 clk_highb8874 storage8970 vdd) p12 w=3.6u l=0.13u
MN8973 (counterage1 clk_low8871 storage8970 vss) n12 w=1.2u l=0.13u
MP8974 (counterage1 clk_lowb8872 storage8970 vdd) p12 w=3.6u l=0.13u
MN8975 (qb8959 storage8970 vss vss) n12 w=0.5u l=0.13u
MP8976 (qb8959 storage8970 vdd vdd) p12 w=1.5u l=0.13u
MN8977 (counterage1 qb8959 vss vss) n12 w=0.5u l=0.13u
MP8978 (counterage1 qb8959 vdd vdd) p12 w=1.5u l=0.13u
MN8979 (storage8970 counter_age_reset vss vss) n12 w=2u l=0.13u
MN8982 (n8980 counterage2 n8981 vss) n12 w=1.6u l=0.13u
MN8983 (n8981 n8954 vss vss) n12 w=1.6u l=0.13u
MP8984 (n8980 counterage2 vdd vdd) p12 w=2.4u l=0.13u
MP8985 (n8980 n8954 vdd vdd) p12 w=2.4u l=0.13u
MN8988 (n8986 counterage2 n8987 vss) n12 w=1.6u l=0.13u
MN8989 (n8987 n8980 vss vss) n12 w=1.6u l=0.13u
MP8990 (n8986 counterage2 vdd vdd) p12 w=2.4u l=0.13u
MP8991 (n8986 n8980 vdd vdd) p12 w=2.4u l=0.13u
MN8994 (n8992 n8954 n8993 vss) n12 w=1.6u l=0.13u
MN8995 (n8993 n8980 vss vss) n12 w=1.6u l=0.13u
MP8996 (n8992 n8954 vdd vdd) p12 w=2.4u l=0.13u
MP8997 (n8992 n8980 vdd vdd) p12 w=2.4u l=0.13u
MN9000 (n8998 n8986 n8999 vss) n12 w=1.6u l=0.13u
MN9001 (n8999 n8992 vss vss) n12 w=1.6u l=0.13u
MP9002 (n8998 n8986 vdd vdd) p12 w=2.4u l=0.13u
MP9003 (n8998 n8992 vdd vdd) p12 w=2.4u l=0.13u
MN9005 (n9004 n8980 vss vss) n12 w=0.8u l=0.13u
MP9006 (n9004 n8980 vdd vdd) p12 w=2.4u l=0.13u
MN9011 (n8998 clk_low8871 storage9010 vss) n12 w=1.2u l=0.13u
MP9012 (n8998 clk_lowb8872 storage9010 vdd) p12 w=3.6u l=0.13u
MN9013 (qm9007 clk_high8873 storage9010 vss) n12 w=1.2u l=0.13u
MP9014 (qm9007 clk_highb8874 storage9010 vdd) p12 w=3.6u l=0.13u
MN9015 (qmb9008 storage9010 vss vss) n12 w=0.5u l=0.13u
MP9016 (qmb9008 storage9010 vdd vdd) p12 w=1.5u l=0.13u
MN9017 (qm9007 qmb9008 vss vss) n12 w=0.5u l=0.13u
MP9018 (qm9007 qmb9008 vdd vdd) p12 w=1.5u l=0.13u
MN9019 (storage9010 counter_age_reset vss vss) n12 w=2u l=0.13u
MN9021 (qm9007 clk_high8873 storage9020 vss) n12 w=1.2u l=0.13u
MP9022 (qm9007 clk_highb8874 storage9020 vdd) p12 w=3.6u l=0.13u
MN9023 (counterage2 clk_low8871 storage9020 vss) n12 w=1.2u l=0.13u
MP9024 (counterage2 clk_lowb8872 storage9020 vdd) p12 w=3.6u l=0.13u
MN9025 (qb9009 storage9020 vss vss) n12 w=0.5u l=0.13u
MP9026 (qb9009 storage9020 vdd vdd) p12 w=1.5u l=0.13u
MN9027 (counterage2 qb9009 vss vss) n12 w=0.5u l=0.13u
MP9028 (counterage2 qb9009 vdd vdd) p12 w=1.5u l=0.13u
MN9029 (storage9020 counter_age_reset vss vss) n12 w=2u l=0.13u
MN9032 (n9030 counterage3 n9031 vss) n12 w=1.6u l=0.13u
MN9033 (n9031 n9004 vss vss) n12 w=1.6u l=0.13u
MP9034 (n9030 counterage3 vdd vdd) p12 w=2.4u l=0.13u
MP9035 (n9030 n9004 vdd vdd) p12 w=2.4u l=0.13u
MN9038 (n9036 counterage3 n9037 vss) n12 w=1.6u l=0.13u
MN9039 (n9037 n9030 vss vss) n12 w=1.6u l=0.13u
MP9040 (n9036 counterage3 vdd vdd) p12 w=2.4u l=0.13u
MP9041 (n9036 n9030 vdd vdd) p12 w=2.4u l=0.13u
MN9044 (n9042 n9004 n9043 vss) n12 w=1.6u l=0.13u
MN9045 (n9043 n9030 vss vss) n12 w=1.6u l=0.13u
MP9046 (n9042 n9004 vdd vdd) p12 w=2.4u l=0.13u
MP9047 (n9042 n9030 vdd vdd) p12 w=2.4u l=0.13u
MN9050 (n9048 n9036 n9049 vss) n12 w=1.6u l=0.13u
MN9051 (n9049 n9042 vss vss) n12 w=1.6u l=0.13u
MP9052 (n9048 n9036 vdd vdd) p12 w=2.4u l=0.13u
MP9053 (n9048 n9042 vdd vdd) p12 w=2.4u l=0.13u
MN9055 (n9054 n9030 vss vss) n12 w=0.8u l=0.13u
MP9056 (n9054 n9030 vdd vdd) p12 w=2.4u l=0.13u
MN9061 (n9048 clk_low8871 storage9060 vss) n12 w=1.2u l=0.13u
MP9062 (n9048 clk_lowb8872 storage9060 vdd) p12 w=3.6u l=0.13u
MN9063 (qm9057 clk_high8873 storage9060 vss) n12 w=1.2u l=0.13u
MP9064 (qm9057 clk_highb8874 storage9060 vdd) p12 w=3.6u l=0.13u
MN9065 (qmb9058 storage9060 vss vss) n12 w=0.5u l=0.13u
MP9066 (qmb9058 storage9060 vdd vdd) p12 w=1.5u l=0.13u
MN9067 (qm9057 qmb9058 vss vss) n12 w=0.5u l=0.13u
MP9068 (qm9057 qmb9058 vdd vdd) p12 w=1.5u l=0.13u
MN9069 (storage9060 counter_age_reset vss vss) n12 w=2u l=0.13u
MN9071 (qm9057 clk_high8873 storage9070 vss) n12 w=1.2u l=0.13u
MP9072 (qm9057 clk_highb8874 storage9070 vdd) p12 w=3.6u l=0.13u
MN9073 (counterage3 clk_low8871 storage9070 vss) n12 w=1.2u l=0.13u
MP9074 (counterage3 clk_lowb8872 storage9070 vdd) p12 w=3.6u l=0.13u
MN9075 (qb9059 storage9070 vss vss) n12 w=0.5u l=0.13u
MP9076 (qb9059 storage9070 vdd vdd) p12 w=1.5u l=0.13u
MN9077 (counterage3 qb9059 vss vss) n12 w=0.5u l=0.13u
MP9078 (counterage3 qb9059 vdd vdd) p12 w=1.5u l=0.13u
MN9079 (storage9070 counter_age_reset vss vss) n12 w=2u l=0.13u
MN9082 (n9080 counterage4 n9081 vss) n12 w=1.6u l=0.13u
MN9083 (n9081 n9054 vss vss) n12 w=1.6u l=0.13u
MP9084 (n9080 counterage4 vdd vdd) p12 w=2.4u l=0.13u
MP9085 (n9080 n9054 vdd vdd) p12 w=2.4u l=0.13u
MN9088 (n9086 counterage4 n9087 vss) n12 w=1.6u l=0.13u
MN9089 (n9087 n9080 vss vss) n12 w=1.6u l=0.13u
MP9090 (n9086 counterage4 vdd vdd) p12 w=2.4u l=0.13u
MP9091 (n9086 n9080 vdd vdd) p12 w=2.4u l=0.13u
MN9094 (n9092 n9054 n9093 vss) n12 w=1.6u l=0.13u
MN9095 (n9093 n9080 vss vss) n12 w=1.6u l=0.13u
MP9096 (n9092 n9054 vdd vdd) p12 w=2.4u l=0.13u
MP9097 (n9092 n9080 vdd vdd) p12 w=2.4u l=0.13u
MN9100 (n9098 n9086 n9099 vss) n12 w=1.6u l=0.13u
MN9101 (n9099 n9092 vss vss) n12 w=1.6u l=0.13u
MP9102 (n9098 n9086 vdd vdd) p12 w=2.4u l=0.13u
MP9103 (n9098 n9092 vdd vdd) p12 w=2.4u l=0.13u
MN9105 (n9104 n9080 vss vss) n12 w=0.8u l=0.13u
MP9106 (n9104 n9080 vdd vdd) p12 w=2.4u l=0.13u
MN9111 (n9098 clk_low8871 storage9110 vss) n12 w=1.2u l=0.13u
MP9112 (n9098 clk_lowb8872 storage9110 vdd) p12 w=3.6u l=0.13u
MN9113 (qm9107 clk_high8873 storage9110 vss) n12 w=1.2u l=0.13u
MP9114 (qm9107 clk_highb8874 storage9110 vdd) p12 w=3.6u l=0.13u
MN9115 (qmb9108 storage9110 vss vss) n12 w=0.5u l=0.13u
MP9116 (qmb9108 storage9110 vdd vdd) p12 w=1.5u l=0.13u
MN9117 (qm9107 qmb9108 vss vss) n12 w=0.5u l=0.13u
MP9118 (qm9107 qmb9108 vdd vdd) p12 w=1.5u l=0.13u
MN9119 (storage9110 counter_age_reset vss vss) n12 w=2u l=0.13u
MN9121 (qm9107 clk_high8873 storage9120 vss) n12 w=1.2u l=0.13u
MP9122 (qm9107 clk_highb8874 storage9120 vdd) p12 w=3.6u l=0.13u
MN9123 (counterage4 clk_low8871 storage9120 vss) n12 w=1.2u l=0.13u
MP9124 (counterage4 clk_lowb8872 storage9120 vdd) p12 w=3.6u l=0.13u
MN9125 (qb9109 storage9120 vss vss) n12 w=0.5u l=0.13u
MP9126 (qb9109 storage9120 vdd vdd) p12 w=1.5u l=0.13u
MN9127 (counterage4 qb9109 vss vss) n12 w=0.5u l=0.13u
MP9128 (counterage4 qb9109 vdd vdd) p12 w=1.5u l=0.13u
MN9129 (storage9120 counter_age_reset vss vss) n12 w=2u l=0.13u
MN9132 (n9130 counterage5 n9131 vss) n12 w=1.6u l=0.13u
MN9133 (n9131 n9104 vss vss) n12 w=1.6u l=0.13u
MP9134 (n9130 counterage5 vdd vdd) p12 w=2.4u l=0.13u
MP9135 (n9130 n9104 vdd vdd) p12 w=2.4u l=0.13u
MN9138 (n9136 counterage5 n9137 vss) n12 w=1.6u l=0.13u
MN9139 (n9137 n9130 vss vss) n12 w=1.6u l=0.13u
MP9140 (n9136 counterage5 vdd vdd) p12 w=2.4u l=0.13u
MP9141 (n9136 n9130 vdd vdd) p12 w=2.4u l=0.13u
MN9144 (n9142 n9104 n9143 vss) n12 w=1.6u l=0.13u
MN9145 (n9143 n9130 vss vss) n12 w=1.6u l=0.13u
MP9146 (n9142 n9104 vdd vdd) p12 w=2.4u l=0.13u
MP9147 (n9142 n9130 vdd vdd) p12 w=2.4u l=0.13u
MN9150 (n9148 n9136 n9149 vss) n12 w=1.6u l=0.13u
MN9151 (n9149 n9142 vss vss) n12 w=1.6u l=0.13u
MP9152 (n9148 n9136 vdd vdd) p12 w=2.4u l=0.13u
MP9153 (n9148 n9142 vdd vdd) p12 w=2.4u l=0.13u
MN9155 (n9154 n9130 vss vss) n12 w=0.8u l=0.13u
MP9156 (n9154 n9130 vdd vdd) p12 w=2.4u l=0.13u
MN9161 (n9148 clk_low8871 storage9160 vss) n12 w=1.2u l=0.13u
MP9162 (n9148 clk_lowb8872 storage9160 vdd) p12 w=3.6u l=0.13u
MN9163 (qm9157 clk_high8873 storage9160 vss) n12 w=1.2u l=0.13u
MP9164 (qm9157 clk_highb8874 storage9160 vdd) p12 w=3.6u l=0.13u
MN9165 (qmb9158 storage9160 vss vss) n12 w=0.5u l=0.13u
MP9166 (qmb9158 storage9160 vdd vdd) p12 w=1.5u l=0.13u
MN9167 (qm9157 qmb9158 vss vss) n12 w=0.5u l=0.13u
MP9168 (qm9157 qmb9158 vdd vdd) p12 w=1.5u l=0.13u
MN9169 (storage9160 counter_age_reset vss vss) n12 w=2u l=0.13u
MN9171 (qm9157 clk_high8873 storage9170 vss) n12 w=1.2u l=0.13u
MP9172 (qm9157 clk_highb8874 storage9170 vdd) p12 w=3.6u l=0.13u
MN9173 (counterage5 clk_low8871 storage9170 vss) n12 w=1.2u l=0.13u
MP9174 (counterage5 clk_lowb8872 storage9170 vdd) p12 w=3.6u l=0.13u
MN9175 (qb9159 storage9170 vss vss) n12 w=0.5u l=0.13u
MP9176 (qb9159 storage9170 vdd vdd) p12 w=1.5u l=0.13u
MN9177 (counterage5 qb9159 vss vss) n12 w=0.5u l=0.13u
MP9178 (counterage5 qb9159 vdd vdd) p12 w=1.5u l=0.13u
MN9179 (storage9170 counter_age_reset vss vss) n12 w=2u l=0.13u
MN9182 (n9180 counterage6 n9181 vss) n12 w=1.6u l=0.13u
MN9183 (n9181 n9154 vss vss) n12 w=1.6u l=0.13u
MP9184 (n9180 counterage6 vdd vdd) p12 w=2.4u l=0.13u
MP9185 (n9180 n9154 vdd vdd) p12 w=2.4u l=0.13u
MN9188 (n9186 counterage6 n9187 vss) n12 w=1.6u l=0.13u
MN9189 (n9187 n9180 vss vss) n12 w=1.6u l=0.13u
MP9190 (n9186 counterage6 vdd vdd) p12 w=2.4u l=0.13u
MP9191 (n9186 n9180 vdd vdd) p12 w=2.4u l=0.13u
MN9194 (n9192 n9154 n9193 vss) n12 w=1.6u l=0.13u
MN9195 (n9193 n9180 vss vss) n12 w=1.6u l=0.13u
MP9196 (n9192 n9154 vdd vdd) p12 w=2.4u l=0.13u
MP9197 (n9192 n9180 vdd vdd) p12 w=2.4u l=0.13u
MN9200 (n9198 n9186 n9199 vss) n12 w=1.6u l=0.13u
MN9201 (n9199 n9192 vss vss) n12 w=1.6u l=0.13u
MP9202 (n9198 n9186 vdd vdd) p12 w=2.4u l=0.13u
MP9203 (n9198 n9192 vdd vdd) p12 w=2.4u l=0.13u
MN9205 (n9204 n9180 vss vss) n12 w=0.8u l=0.13u
MP9206 (n9204 n9180 vdd vdd) p12 w=2.4u l=0.13u
MN9211 (n9198 clk_low8871 storage9210 vss) n12 w=1.2u l=0.13u
MP9212 (n9198 clk_lowb8872 storage9210 vdd) p12 w=3.6u l=0.13u
MN9213 (qm9207 clk_high8873 storage9210 vss) n12 w=1.2u l=0.13u
MP9214 (qm9207 clk_highb8874 storage9210 vdd) p12 w=3.6u l=0.13u
MN9215 (qmb9208 storage9210 vss vss) n12 w=0.5u l=0.13u
MP9216 (qmb9208 storage9210 vdd vdd) p12 w=1.5u l=0.13u
MN9217 (qm9207 qmb9208 vss vss) n12 w=0.5u l=0.13u
MP9218 (qm9207 qmb9208 vdd vdd) p12 w=1.5u l=0.13u
MN9219 (storage9210 counter_age_reset vss vss) n12 w=2u l=0.13u
MN9221 (qm9207 clk_high8873 storage9220 vss) n12 w=1.2u l=0.13u
MP9222 (qm9207 clk_highb8874 storage9220 vdd) p12 w=3.6u l=0.13u
MN9223 (counterage6 clk_low8871 storage9220 vss) n12 w=1.2u l=0.13u
MP9224 (counterage6 clk_lowb8872 storage9220 vdd) p12 w=3.6u l=0.13u
MN9225 (qb9209 storage9220 vss vss) n12 w=0.5u l=0.13u
MP9226 (qb9209 storage9220 vdd vdd) p12 w=1.5u l=0.13u
MN9227 (counterage6 qb9209 vss vss) n12 w=0.5u l=0.13u
MP9228 (counterage6 qb9209 vdd vdd) p12 w=1.5u l=0.13u
MN9229 (storage9220 counter_age_reset vss vss) n12 w=2u l=0.13u
MN9232 (n9230 counterage7 n9231 vss) n12 w=1.6u l=0.13u
MN9233 (n9231 n9204 vss vss) n12 w=1.6u l=0.13u
MP9234 (n9230 counterage7 vdd vdd) p12 w=2.4u l=0.13u
MP9235 (n9230 n9204 vdd vdd) p12 w=2.4u l=0.13u
MN9238 (n9236 counterage7 n9237 vss) n12 w=1.6u l=0.13u
MN9239 (n9237 n9230 vss vss) n12 w=1.6u l=0.13u
MP9240 (n9236 counterage7 vdd vdd) p12 w=2.4u l=0.13u
MP9241 (n9236 n9230 vdd vdd) p12 w=2.4u l=0.13u
MN9244 (n9242 n9204 n9243 vss) n12 w=1.6u l=0.13u
MN9245 (n9243 n9230 vss vss) n12 w=1.6u l=0.13u
MP9246 (n9242 n9204 vdd vdd) p12 w=2.4u l=0.13u
MP9247 (n9242 n9230 vdd vdd) p12 w=2.4u l=0.13u
MN9250 (n9248 n9236 n9249 vss) n12 w=1.6u l=0.13u
MN9251 (n9249 n9242 vss vss) n12 w=1.6u l=0.13u
MP9252 (n9248 n9236 vdd vdd) p12 w=2.4u l=0.13u
MP9253 (n9248 n9242 vdd vdd) p12 w=2.4u l=0.13u
MN9255 (n9254 n9230 vss vss) n12 w=0.8u l=0.13u
MP9256 (n9254 n9230 vdd vdd) p12 w=2.4u l=0.13u
MN9261 (n9248 clk_low8871 storage9260 vss) n12 w=1.2u l=0.13u
MP9262 (n9248 clk_lowb8872 storage9260 vdd) p12 w=3.6u l=0.13u
MN9263 (qm9257 clk_high8873 storage9260 vss) n12 w=1.2u l=0.13u
MP9264 (qm9257 clk_highb8874 storage9260 vdd) p12 w=3.6u l=0.13u
MN9265 (qmb9258 storage9260 vss vss) n12 w=0.5u l=0.13u
MP9266 (qmb9258 storage9260 vdd vdd) p12 w=1.5u l=0.13u
MN9267 (qm9257 qmb9258 vss vss) n12 w=0.5u l=0.13u
MP9268 (qm9257 qmb9258 vdd vdd) p12 w=1.5u l=0.13u
MN9269 (storage9260 counter_age_reset vss vss) n12 w=2u l=0.13u
MN9271 (qm9257 clk_high8873 storage9270 vss) n12 w=1.2u l=0.13u
MP9272 (qm9257 clk_highb8874 storage9270 vdd) p12 w=3.6u l=0.13u
MN9273 (counterage7 clk_low8871 storage9270 vss) n12 w=1.2u l=0.13u
MP9274 (counterage7 clk_lowb8872 storage9270 vdd) p12 w=3.6u l=0.13u
MN9275 (qb9259 storage9270 vss vss) n12 w=0.5u l=0.13u
MP9276 (qb9259 storage9270 vdd vdd) p12 w=1.5u l=0.13u
MN9277 (counterage7 qb9259 vss vss) n12 w=0.5u l=0.13u
MP9278 (counterage7 qb9259 vdd vdd) p12 w=1.5u l=0.13u
MN9279 (storage9270 counter_age_reset vss vss) n12 w=2u l=0.13u
MN9282 (n9280 counterage6 n9281 vss) n12 w=1.6u l=0.13u
MN9283 (n9281 counterage7 vss vss) n12 w=1.6u l=0.13u
MP9284 (n9280 counterage6 vdd vdd) p12 w=2.4u l=0.13u
MP9285 (n9280 counterage7 vdd vdd) p12 w=2.4u l=0.13u
MN9287 (n9286 n9280 vss vss) n12 w=0.8u l=0.13u
MP9288 (n9286 n9280 vdd vdd) p12 w=2.4u l=0.13u
MN9291 (n9289 counterage4 n9290 vss) n12 w=1.6u l=0.13u
MN9292 (n9290 counterage5 vss vss) n12 w=1.6u l=0.13u
MP9293 (n9289 counterage4 vdd vdd) p12 w=2.4u l=0.13u
MP9294 (n9289 counterage5 vdd vdd) p12 w=2.4u l=0.13u
MN9296 (n9295 n9289 vss vss) n12 w=0.8u l=0.13u
MP9297 (n9295 n9289 vdd vdd) p12 w=2.4u l=0.13u
MN9300 (n9298 n9286 n9299 vss) n12 w=1.6u l=0.13u
MN9301 (n9299 n9295 vss vss) n12 w=1.6u l=0.13u
MP9302 (n9298 n9286 vdd vdd) p12 w=2.4u l=0.13u
MP9303 (n9298 n9295 vdd vdd) p12 w=2.4u l=0.13u
MN9305 (n9304 n9298 vss vss) n12 w=0.8u l=0.13u
MP9306 (n9304 n9298 vdd vdd) p12 w=2.4u l=0.13u
MN9309 (n9307 counterage3 n9308 vss) n12 w=1.6u l=0.13u
MN9310 (n9308 n9304 vss vss) n12 w=1.6u l=0.13u
MP9311 (n9307 counterage3 vdd vdd) p12 w=2.4u l=0.13u
MP9312 (n9307 n9304 vdd vdd) p12 w=2.4u l=0.13u
MN9314 (n9313 n9307 vss vss) n12 w=0.8u l=0.13u
MP9315 (n9313 n9307 vdd vdd) p12 w=2.4u l=0.13u
MN9318 (n9316 arm vss vss) n12 w=0.8u l=0.13u
MN9319 (n9316 measure vss vss) n12 w=0.8u l=0.13u
MP9320 (n9316 arm n9317 vdd) p12 w=4.8u l=0.13u
MP9321 (n9317 measure vdd vdd) p12 w=4.8u l=0.13u
MN9323 (n9322 n9316 vss vss) n12 w=0.8u l=0.13u
MP9324 (n9322 n9316 vdd vdd) p12 w=2.4u l=0.13u
MN9327 (n9325 count_run n9326 vss) n12 w=1.6u l=0.13u
MN9328 (n9326 n9322 vss vss) n12 w=1.6u l=0.13u
MP9329 (n9325 count_run vdd vdd) p12 w=2.4u l=0.13u
MP9330 (n9325 n9322 vdd vdd) p12 w=2.4u l=0.13u
MN9332 (n9331 n9325 vss vss) n12 w=0.8u l=0.13u
MP9333 (n9331 n9325 vdd vdd) p12 w=2.4u l=0.13u
MN9336 (n9334 n203 n9335 vss) n12 w=1.6u l=0.13u
MN9337 (n9335 n337 vss vss) n12 w=1.6u l=0.13u
MP9338 (n9334 n203 vdd vdd) p12 w=2.4u l=0.13u
MP9339 (n9334 n337 vdd vdd) p12 w=2.4u l=0.13u
MN9341 (n9340 n9334 vss vss) n12 w=0.8u l=0.13u
MP9342 (n9340 n9334 vdd vdd) p12 w=2.4u l=0.13u
MN9345 (n9343 n9331 n9344 vss) n12 w=1.6u l=0.13u
MN9346 (n9344 n9340 vss vss) n12 w=1.6u l=0.13u
MP9347 (n9343 n9331 vdd vdd) p12 w=2.4u l=0.13u
MP9348 (n9343 n9340 vdd vdd) p12 w=2.4u l=0.13u
MN9350 (n9349 n9343 vss vss) n12 w=0.8u l=0.13u
MP9351 (n9349 n9343 vdd vdd) p12 w=2.4u l=0.13u
MN9354 (n9352 n9313 n9353 vss) n12 w=1.6u l=0.13u
MN9355 (n9353 n9349 vss vss) n12 w=1.6u l=0.13u
MP9356 (n9352 n9313 vdd vdd) p12 w=2.4u l=0.13u
MP9357 (n9352 n9349 vdd vdd) p12 w=2.4u l=0.13u
MN9359 (n9358 n9352 vss vss) n12 w=0.8u l=0.13u
MP9360 (n9358 n9352 vdd vdd) p12 w=2.4u l=0.13u
MN9362 (n9361 n9358 vss vss) n12 w=0.8u l=0.13u
MP9363 (n9361 n9358 vdd vdd) p12 w=2.4u l=0.13u
MN9365 (n9364 n9361 vss vss) n12 w=0.8u l=0.13u
MP9366 (n9364 n9361 vdd vdd) p12 w=2.4u l=0.13u
MN9368 (n9367 n9364 vss vss) n12 w=0.8u l=0.13u
MP9369 (n9367 n9364 vdd vdd) p12 w=2.4u l=0.13u
MN9370 (epoch_watchdog n9367 vss vss) n12 w=0.8u l=0.13u
MP9371 (epoch_watchdog n9367 vdd vdd) p12 w=2.4u l=0.13u
MN9372 (measure_watchdog n9367 vss vss) n12 w=0.8u l=0.13u
MP9373 (measure_watchdog n9367 vdd vdd) p12 w=2.4u l=0.13u
MN9376 (n9374 step1 vss vss) n12 w=0.8u l=0.13u
MN9377 (n9374 step2 vss vss) n12 w=0.8u l=0.13u
MP9378 (n9374 step1 n9375 vdd) p12 w=4.8u l=0.13u
MP9379 (n9375 step2 vdd vdd) p12 w=4.8u l=0.13u
MN9381 (n9380 n9374 vss vss) n12 w=0.8u l=0.13u
MP9382 (n9380 n9374 vdd vdd) p12 w=2.4u l=0.13u
MN9385 (n9383 step4 vss vss) n12 w=0.8u l=0.13u
MN9386 (n9383 step8 vss vss) n12 w=0.8u l=0.13u
MP9387 (n9383 step4 n9384 vdd) p12 w=4.8u l=0.13u
MP9388 (n9384 step8 vdd vdd) p12 w=4.8u l=0.13u
MN9390 (n9389 n9383 vss vss) n12 w=0.8u l=0.13u
MP9391 (n9389 n9383 vdd vdd) p12 w=2.4u l=0.13u
MN9394 (n9392 n9380 vss vss) n12 w=0.8u l=0.13u
MN9395 (n9392 n9389 vss vss) n12 w=0.8u l=0.13u
MP9396 (n9392 n9380 n9393 vdd) p12 w=4.8u l=0.13u
MP9397 (n9393 n9389 vdd vdd) p12 w=4.8u l=0.13u
MN9399 (n9398 n9392 vss vss) n12 w=0.8u l=0.13u
MP9400 (n9398 n9392 vdd vdd) p12 w=2.4u l=0.13u
MN9402 (n9401 n9398 vss vss) n12 w=0.8u l=0.13u
MP9403 (n9401 n9398 vdd vdd) p12 w=2.4u l=0.13u
MN9405 (n9404 s1 vss vss) n12 w=0.8u l=0.13u
MP9406 (n9404 s1 vdd vdd) p12 w=2.4u l=0.13u
MN9408 (n9407 s2 vss vss) n12 w=0.8u l=0.13u
MP9409 (n9407 s2 vdd vdd) p12 w=2.4u l=0.13u
MN9411 (n9410 s3 vss vss) n12 w=0.8u l=0.13u
MP9412 (n9410 s3 vdd vdd) p12 w=2.4u l=0.13u
MN9414 (n9413 s4 vss vss) n12 w=0.8u l=0.13u
MP9415 (n9413 s4 vdd vdd) p12 w=2.4u l=0.13u
MN9418 (n9416 n9404 n9417 vss) n12 w=1.6u l=0.13u
MN9419 (n9417 s0 vss vss) n12 w=1.6u l=0.13u
MP9420 (n9416 n9404 vdd vdd) p12 w=2.4u l=0.13u
MP9421 (n9416 s0 vdd vdd) p12 w=2.4u l=0.13u
MN9423 (n9422 n9416 vss vss) n12 w=0.8u l=0.13u
MP9424 (n9422 n9416 vdd vdd) p12 w=2.4u l=0.13u
MN9427 (n9425 n9407 n9426 vss) n12 w=1.6u l=0.13u
MN9428 (n9426 n9410 vss vss) n12 w=1.6u l=0.13u
MP9429 (n9425 n9407 vdd vdd) p12 w=2.4u l=0.13u
MP9430 (n9425 n9410 vdd vdd) p12 w=2.4u l=0.13u
MN9432 (n9431 n9425 vss vss) n12 w=0.8u l=0.13u
MP9433 (n9431 n9425 vdd vdd) p12 w=2.4u l=0.13u
MN9436 (n9434 n9422 n9435 vss) n12 w=1.6u l=0.13u
MN9437 (n9435 n9431 vss vss) n12 w=1.6u l=0.13u
MP9438 (n9434 n9422 vdd vdd) p12 w=2.4u l=0.13u
MP9439 (n9434 n9431 vdd vdd) p12 w=2.4u l=0.13u
MN9441 (n9440 n9434 vss vss) n12 w=0.8u l=0.13u
MP9442 (n9440 n9434 vdd vdd) p12 w=2.4u l=0.13u
MN9445 (n9443 n9413 n9444 vss) n12 w=1.6u l=0.13u
MN9446 (n9444 n9440 vss vss) n12 w=1.6u l=0.13u
MP9447 (n9443 n9413 vdd vdd) p12 w=2.4u l=0.13u
MP9448 (n9443 n9440 vdd vdd) p12 w=2.4u l=0.13u
MN9450 (n9449 n9443 vss vss) n12 w=0.8u l=0.13u
MP9451 (n9449 n9443 vdd vdd) p12 w=2.4u l=0.13u
MN9454 (n9452 s0 n9453 vss) n12 w=1.6u l=0.13u
MN9455 (n9453 s1 vss vss) n12 w=1.6u l=0.13u
MP9456 (n9452 s0 vdd vdd) p12 w=2.4u l=0.13u
MP9457 (n9452 s1 vdd vdd) p12 w=2.4u l=0.13u
MN9459 (n9458 n9452 vss vss) n12 w=0.8u l=0.13u
MP9460 (n9458 n9452 vdd vdd) p12 w=2.4u l=0.13u
MN9463 (n9461 s2 n9462 vss) n12 w=1.6u l=0.13u
MN9464 (n9462 s3 vss vss) n12 w=1.6u l=0.13u
MP9465 (n9461 s2 vdd vdd) p12 w=2.4u l=0.13u
MP9466 (n9461 s3 vdd vdd) p12 w=2.4u l=0.13u
MN9468 (n9467 n9461 vss vss) n12 w=0.8u l=0.13u
MP9469 (n9467 n9461 vdd vdd) p12 w=2.4u l=0.13u
MN9472 (n9470 n9458 n9471 vss) n12 w=1.6u l=0.13u
MN9473 (n9471 n9467 vss vss) n12 w=1.6u l=0.13u
MP9474 (n9470 n9458 vdd vdd) p12 w=2.4u l=0.13u
MP9475 (n9470 n9467 vdd vdd) p12 w=2.4u l=0.13u
MN9477 (n9476 n9470 vss vss) n12 w=0.8u l=0.13u
MP9478 (n9476 n9470 vdd vdd) p12 w=2.4u l=0.13u
MN9481 (n9479 n9476 n9480 vss) n12 w=1.6u l=0.13u
MN9482 (n9480 s4 vss vss) n12 w=1.6u l=0.13u
MP9483 (n9479 n9476 vdd vdd) p12 w=2.4u l=0.13u
MP9484 (n9479 s4 vdd vdd) p12 w=2.4u l=0.13u
MN9486 (n9485 n9479 vss vss) n12 w=0.8u l=0.13u
MP9487 (n9485 n9479 vdd vdd) p12 w=2.4u l=0.13u
MN9490 (n9488 n9449 n9489 vss) n12 w=1.6u l=0.13u
MN9491 (n9489 was_fast vss vss) n12 w=1.6u l=0.13u
MP9492 (n9488 n9449 vdd vdd) p12 w=2.4u l=0.13u
MP9493 (n9488 was_fast vdd vdd) p12 w=2.4u l=0.13u
MN9495 (n9494 n9488 vss vss) n12 w=0.8u l=0.13u
MP9496 (n9494 n9488 vdd vdd) p12 w=2.4u l=0.13u
MN9499 (n9497 n9485 n9498 vss) n12 w=1.6u l=0.13u
MN9500 (n9498 was_slow vss vss) n12 w=1.6u l=0.13u
MP9501 (n9497 n9485 vdd vdd) p12 w=2.4u l=0.13u
MP9502 (n9497 was_slow vdd vdd) p12 w=2.4u l=0.13u
MN9504 (n9503 n9497 vss vss) n12 w=0.8u l=0.13u
MP9505 (n9503 n9497 vdd vdd) p12 w=2.4u l=0.13u
MN9508 (n9506 n9494 vss vss) n12 w=0.8u l=0.13u
MN9509 (n9506 n9503 vss vss) n12 w=0.8u l=0.13u
MP9510 (n9506 n9494 n9507 vdd) p12 w=4.8u l=0.13u
MP9511 (n9507 n9503 vdd vdd) p12 w=4.8u l=0.13u
MN9513 (n9512 n9506 vss vss) n12 w=0.8u l=0.13u
MP9514 (n9512 n9506 vdd vdd) p12 w=2.4u l=0.13u
MN9517 (n9515 n9401 vss vss) n12 w=0.8u l=0.13u
MN9518 (n9515 was_near vss vss) n12 w=0.8u l=0.13u
MP9519 (n9515 n9401 n9516 vdd) p12 w=4.8u l=0.13u
MP9520 (n9516 was_near vdd vdd) p12 w=4.8u l=0.13u
MN9522 (n9521 n9515 vss vss) n12 w=0.8u l=0.13u
MP9523 (n9521 n9515 vdd vdd) p12 w=2.4u l=0.13u
MN9526 (n9524 measure n9525 vss) n12 w=1.6u l=0.13u
MN9527 (n9525 n6874 vss vss) n12 w=1.6u l=0.13u
MP9528 (n9524 measure vdd vdd) p12 w=2.4u l=0.13u
MP9529 (n9524 n6874 vdd vdd) p12 w=2.4u l=0.13u
MN9531 (n9530 n9524 vss vss) n12 w=0.8u l=0.13u
MP9532 (n9530 n9524 vdd vdd) p12 w=2.4u l=0.13u
MN9535 (n9533 n8854 n9534 vss) n12 w=1.6u l=0.13u
MN9536 (n9534 n9521 vss vss) n12 w=1.6u l=0.13u
MP9537 (n9533 n8854 vdd vdd) p12 w=2.4u l=0.13u
MP9538 (n9533 n9521 vdd vdd) p12 w=2.4u l=0.13u
MN9540 (n9539 n9533 vss vss) n12 w=0.8u l=0.13u
MP9541 (n9539 n9533 vdd vdd) p12 w=2.4u l=0.13u
MN9544 (n9542 n9512 n9543 vss) n12 w=1.6u l=0.13u
MN9545 (n9543 n9539 vss vss) n12 w=1.6u l=0.13u
MP9546 (n9542 n9512 vdd vdd) p12 w=2.4u l=0.13u
MP9547 (n9542 n9539 vdd vdd) p12 w=2.4u l=0.13u
MN9549 (n9548 n9542 vss vss) n12 w=0.8u l=0.13u
MP9550 (n9548 n9542 vdd vdd) p12 w=2.4u l=0.13u
MN9553 (n9551 n8718 vss vss) n12 w=0.8u l=0.13u
MN9554 (n9551 n9358 vss vss) n12 w=0.8u l=0.13u
MP9555 (n9551 n8718 n9552 vdd) p12 w=4.8u l=0.13u
MP9556 (n9552 n9358 vdd vdd) p12 w=4.8u l=0.13u
MN9558 (n9557 n9551 vss vss) n12 w=0.8u l=0.13u
MP9559 (n9557 n9551 vdd vdd) p12 w=2.4u l=0.13u
MN9562 (n9560 n9530 vss vss) n12 w=0.8u l=0.13u
MN9563 (n9560 n9548 vss vss) n12 w=0.8u l=0.13u
MP9564 (n9560 n9530 n9561 vdd) p12 w=4.8u l=0.13u
MP9565 (n9561 n9548 vdd vdd) p12 w=4.8u l=0.13u
MN9567 (n9566 n9560 vss vss) n12 w=0.8u l=0.13u
MP9568 (n9566 n9560 vdd vdd) p12 w=2.4u l=0.13u
MN9571 (n9569 n9557 vss vss) n12 w=0.8u l=0.13u
MN9572 (n9569 n9566 vss vss) n12 w=0.8u l=0.13u
MP9573 (n9569 n9557 n9570 vdd) p12 w=4.8u l=0.13u
MP9574 (n9570 n9566 vdd vdd) p12 w=4.8u l=0.13u
MN9576 (n9575 n9569 vss vss) n12 w=0.8u l=0.13u
MP9577 (n9575 n9569 vdd vdd) p12 w=2.4u l=0.13u
MN9579 (n9578 n9512 vss vss) n12 w=0.8u l=0.13u
MP9580 (n9578 n9512 vdd vdd) p12 w=2.4u l=0.13u
MN9582 (n9581 n9575 vss vss) n12 w=0.8u l=0.13u
MP9583 (n9581 n9575 vdd vdd) p12 w=2.4u l=0.13u
MN9586 (n9584 n9578 n9585 vss) n12 w=1.6u l=0.13u
MN9587 (n9585 n9581 vss vss) n12 w=1.6u l=0.13u
MP9588 (n9584 n9578 vdd vdd) p12 w=2.4u l=0.13u
MP9589 (n9584 n9581 vdd vdd) p12 w=2.4u l=0.13u
MN9591 (n9590 n9584 vss vss) n12 w=0.8u l=0.13u
MP9592 (n9590 n9584 vdd vdd) p12 w=2.4u l=0.13u
MN9595 (n9593 n9539 n9594 vss) n12 w=1.6u l=0.13u
MN9596 (n9594 n9590 vss vss) n12 w=1.6u l=0.13u
MP9597 (n9593 n9539 vdd vdd) p12 w=2.4u l=0.13u
MP9598 (n9593 n9590 vdd vdd) p12 w=2.4u l=0.13u
MN9600 (n9599 n9593 vss vss) n12 w=0.8u l=0.13u
MP9601 (n9599 n9593 vdd vdd) p12 w=2.4u l=0.13u
MN9604 (n9602 n6901 vss vss) n12 w=0.8u l=0.13u
MN9605 (n9602 n9575 vss vss) n12 w=0.8u l=0.13u
MP9606 (n9602 n6901 n9603 vdd) p12 w=4.8u l=0.13u
MP9607 (n9603 n9575 vdd vdd) p12 w=4.8u l=0.13u
MN9609 (n9608 n9602 vss vss) n12 w=0.8u l=0.13u
MP9610 (n9608 n9602 vdd vdd) p12 w=2.4u l=0.13u
MN9612 (n9611 n9608 vss vss) n12 w=0.8u l=0.13u
MP9613 (n9611 n9608 vdd vdd) p12 w=2.4u l=0.13u
MN9616 (n9614 n6901 vss vss) n12 w=0.8u l=0.13u
MN9617 (n9614 n8361 vss vss) n12 w=0.8u l=0.13u
MP9618 (n9614 n6901 n9615 vdd) p12 w=4.8u l=0.13u
MP9619 (n9615 n8361 vdd vdd) p12 w=4.8u l=0.13u
MN9621 (n9620 n9614 vss vss) n12 w=0.8u l=0.13u
MP9622 (n9620 n9614 vdd vdd) p12 w=2.4u l=0.13u
MN9625 (n9623 n9575 vss vss) n12 w=0.8u l=0.13u
MN9626 (n9623 n9620 vss vss) n12 w=0.8u l=0.13u
MP9627 (n9623 n9575 n9624 vdd) p12 w=4.8u l=0.13u
MP9628 (n9624 n9620 vdd vdd) p12 w=4.8u l=0.13u
MN9630 (n9629 n9623 vss vss) n12 w=0.8u l=0.13u
MP9631 (n9629 n9623 vdd vdd) p12 w=2.4u l=0.13u
MN9634 (n9632 n9611 n9633 vss) n12 w=1.6u l=0.13u
MN9635 (n9633 n9629 vss vss) n12 w=1.6u l=0.13u
MP9636 (n9632 n9611 vdd vdd) p12 w=2.4u l=0.13u
MP9637 (n9632 n9629 vdd vdd) p12 w=2.4u l=0.13u
MN9639 (n9638 n9629 vss vss) n12 w=0.8u l=0.13u
MP9640 (n9638 n9629 vdd vdd) p12 w=2.4u l=0.13u
MN9643 (n9641 count_run n9642 vss) n12 w=1.6u l=0.13u
MN9644 (n9642 n9638 vss vss) n12 w=1.6u l=0.13u
MP9645 (n9641 count_run vdd vdd) p12 w=2.4u l=0.13u
MP9646 (n9641 n9638 vdd vdd) p12 w=2.4u l=0.13u
MN9649 (n9647 n9632 n9648 vss) n12 w=1.6u l=0.13u
MN9650 (n9648 n9641 vss vss) n12 w=1.6u l=0.13u
MP9651 (n9647 n9632 vdd vdd) p12 w=2.4u l=0.13u
MP9652 (n9647 n9641 vdd vdd) p12 w=2.4u l=0.13u
MN9657 (n9647 clk_low108 storage9656 vss) n12 w=1.2u l=0.13u
MP9658 (n9647 clk_lowb109 storage9656 vdd) p12 w=3.6u l=0.13u
MN9659 (qm9653 clk_high110 storage9656 vss) n12 w=1.2u l=0.13u
MP9660 (qm9653 clk_highb111 storage9656 vdd) p12 w=3.6u l=0.13u
MN9661 (qmb9654 storage9656 vss vss) n12 w=0.5u l=0.13u
MP9662 (qmb9654 storage9656 vdd vdd) p12 w=1.5u l=0.13u
MN9663 (qm9653 qmb9654 vss vss) n12 w=0.5u l=0.13u
MP9664 (qm9653 qmb9654 vdd vdd) p12 w=1.5u l=0.13u
MN9665 (storage9656 rst vss vss) n12 w=2u l=0.13u
MN9667 (qm9653 clk_high110 storage9666 vss) n12 w=1.2u l=0.13u
MP9668 (qm9653 clk_highb111 storage9666 vdd) p12 w=3.6u l=0.13u
MN9669 (count_run clk_low108 storage9666 vss) n12 w=1.2u l=0.13u
MP9670 (count_run clk_lowb109 storage9666 vdd) p12 w=3.6u l=0.13u
MN9671 (qb9655 storage9666 vss vss) n12 w=0.5u l=0.13u
MP9672 (qb9655 storage9666 vdd vdd) p12 w=1.5u l=0.13u
MN9673 (count_run qb9655 vss vss) n12 w=0.5u l=0.13u
MP9674 (count_run qb9655 vdd vdd) p12 w=1.5u l=0.13u
MN9675 (storage9666 rst vss vss) n12 w=2u l=0.13u
MN9677 (n9676 n9599 vss vss) n12 w=0.8u l=0.13u
MP9678 (n9676 n9599 vdd vdd) p12 w=2.4u l=0.13u
MN9681 (n9679 done n9680 vss) n12 w=1.6u l=0.13u
MN9682 (n9680 n9676 vss vss) n12 w=1.6u l=0.13u
MP9683 (n9679 done vdd vdd) p12 w=2.4u l=0.13u
MP9684 (n9679 n9676 vdd vdd) p12 w=2.4u l=0.13u
MN9687 (n9685 n9676 n9686 vss) n12 w=1.6u l=0.13u
MN9688 (n9686 n9679 vss vss) n12 w=1.6u l=0.13u
MP9689 (n9685 n9676 vdd vdd) p12 w=2.4u l=0.13u
MP9690 (n9685 n9679 vdd vdd) p12 w=2.4u l=0.13u
MN9695 (n9685 clk_low108 storage9694 vss) n12 w=1.2u l=0.13u
MP9696 (n9685 clk_lowb109 storage9694 vdd) p12 w=3.6u l=0.13u
MN9697 (qm9691 clk_high110 storage9694 vss) n12 w=1.2u l=0.13u
MP9698 (qm9691 clk_highb111 storage9694 vdd) p12 w=3.6u l=0.13u
MN9699 (qmb9692 storage9694 vss vss) n12 w=0.5u l=0.13u
MP9700 (qmb9692 storage9694 vdd vdd) p12 w=1.5u l=0.13u
MN9701 (qm9691 qmb9692 vss vss) n12 w=0.5u l=0.13u
MP9702 (qm9691 qmb9692 vdd vdd) p12 w=1.5u l=0.13u
MN9703 (storage9694 rst vss vss) n12 w=2u l=0.13u
MN9705 (qm9691 clk_high110 storage9704 vss) n12 w=1.2u l=0.13u
MP9706 (qm9691 clk_highb111 storage9704 vdd) p12 w=3.6u l=0.13u
MN9707 (done clk_low108 storage9704 vss) n12 w=1.2u l=0.13u
MP9708 (done clk_lowb109 storage9704 vdd) p12 w=3.6u l=0.13u
MN9709 (qb9693 storage9704 vss vss) n12 w=0.5u l=0.13u
MP9710 (qb9693 storage9704 vdd vdd) p12 w=1.5u l=0.13u
MN9711 (done qb9693 vss vss) n12 w=0.5u l=0.13u
MP9712 (done qb9693 vdd vdd) p12 w=1.5u l=0.13u
MN9713 (storage9704 rst vss vss) n12 w=2u l=0.13u
MN9716 (n9714 fail n9715 vss) n12 w=1.6u l=0.13u
MN9717 (n9715 n9581 vss vss) n12 w=1.6u l=0.13u
MP9718 (n9714 fail vdd vdd) p12 w=2.4u l=0.13u
MP9719 (n9714 n9581 vdd vdd) p12 w=2.4u l=0.13u
MN9722 (n9720 n9581 n9721 vss) n12 w=1.6u l=0.13u
MN9723 (n9721 n9714 vss vss) n12 w=1.6u l=0.13u
MP9724 (n9720 n9581 vdd vdd) p12 w=2.4u l=0.13u
MP9725 (n9720 n9714 vdd vdd) p12 w=2.4u l=0.13u
MN9730 (n9720 clk_low108 storage9729 vss) n12 w=1.2u l=0.13u
MP9731 (n9720 clk_lowb109 storage9729 vdd) p12 w=3.6u l=0.13u
MN9732 (qm9726 clk_high110 storage9729 vss) n12 w=1.2u l=0.13u
MP9733 (qm9726 clk_highb111 storage9729 vdd) p12 w=3.6u l=0.13u
MN9734 (qmb9727 storage9729 vss vss) n12 w=0.5u l=0.13u
MP9735 (qmb9727 storage9729 vdd vdd) p12 w=1.5u l=0.13u
MN9736 (qm9726 qmb9727 vss vss) n12 w=0.5u l=0.13u
MP9737 (qm9726 qmb9727 vdd vdd) p12 w=1.5u l=0.13u
MN9738 (storage9729 rst vss vss) n12 w=2u l=0.13u
MN9740 (qm9726 clk_high110 storage9739 vss) n12 w=1.2u l=0.13u
MP9741 (qm9726 clk_highb111 storage9739 vdd) p12 w=3.6u l=0.13u
MN9742 (fail clk_low108 storage9739 vss) n12 w=1.2u l=0.13u
MP9743 (fail clk_lowb109 storage9739 vdd) p12 w=3.6u l=0.13u
MN9744 (qb9728 storage9739 vss vss) n12 w=0.5u l=0.13u
MP9745 (qb9728 storage9739 vdd vdd) p12 w=1.5u l=0.13u
MN9746 (fail qb9728 vss vss) n12 w=0.5u l=0.13u
MP9747 (fail qb9728 vdd vdd) p12 w=1.5u l=0.13u
MN9748 (storage9739 rst vss vss) n12 w=2u l=0.13u
MN9750 (n9749 n9521 vss vss) n12 w=0.8u l=0.13u
MP9751 (n9749 n9521 vdd vdd) p12 w=2.4u l=0.13u
MN9754 (n9752 n8854 n9753 vss) n12 w=1.6u l=0.13u
MN9755 (n9753 n9749 vss vss) n12 w=1.6u l=0.13u
MP9756 (n9752 n8854 vdd vdd) p12 w=2.4u l=0.13u
MP9757 (n9752 n9749 vdd vdd) p12 w=2.4u l=0.13u
MN9759 (n9758 n9752 vss vss) n12 w=0.8u l=0.13u
MP9760 (n9758 n9752 vdd vdd) p12 w=2.4u l=0.13u
MN9763 (n9761 n9581 n9762 vss) n12 w=1.6u l=0.13u
MN9764 (n9762 n9758 vss vss) n12 w=1.6u l=0.13u
MP9765 (n9761 n9581 vdd vdd) p12 w=2.4u l=0.13u
MP9766 (n9761 n9758 vdd vdd) p12 w=2.4u l=0.13u
MN9768 (n9767 n9761 vss vss) n12 w=0.8u l=0.13u
MP9769 (n9767 n9761 vdd vdd) p12 w=2.4u l=0.13u
MN9772 (n9770 n66 vss vss) n12 w=0.8u l=0.13u
MN9773 (n9770 n9767 vss vss) n12 w=0.8u l=0.13u
MP9774 (n9770 n66 n9771 vdd) p12 w=4.8u l=0.13u
MP9775 (n9771 n9767 vdd vdd) p12 w=4.8u l=0.13u
MN9777 (n9776 n9770 vss vss) n12 w=0.8u l=0.13u
MP9778 (n9776 n9770 vdd vdd) p12 w=2.4u l=0.13u
MN9781 (n9779 n9575 vss vss) n12 w=0.8u l=0.13u
MN9782 (n9779 n9599 vss vss) n12 w=0.8u l=0.13u
MP9783 (n9779 n9575 n9780 vdd) p12 w=4.8u l=0.13u
MP9784 (n9780 n9599 vdd vdd) p12 w=4.8u l=0.13u
MN9786 (n9785 n9779 vss vss) n12 w=0.8u l=0.13u
MP9787 (n9785 n9779 vdd vdd) p12 w=2.4u l=0.13u
MN9790 (n9788 n9776 vss vss) n12 w=0.8u l=0.13u
MN9791 (n9788 n9785 vss vss) n12 w=0.8u l=0.13u
MP9792 (n9788 n9776 n9789 vdd) p12 w=4.8u l=0.13u
MP9793 (n9789 n9785 vdd vdd) p12 w=4.8u l=0.13u
MN9795 (n9794 n9788 vss vss) n12 w=0.8u l=0.13u
MP9796 (n9794 n9788 vdd vdd) p12 w=2.4u l=0.13u
MN9798 (n9797 n8361 vss vss) n12 w=0.8u l=0.13u
MP9799 (n9797 n8361 vdd vdd) p12 w=2.4u l=0.13u
MN9802 (n9800 n8361 vss vss) n12 w=0.8u l=0.13u
MN9803 (n9800 n9794 vss vss) n12 w=0.8u l=0.13u
MP9804 (n9800 n8361 n9801 vdd) p12 w=4.8u l=0.13u
MP9805 (n9801 n9794 vdd vdd) p12 w=4.8u l=0.13u
MN9807 (n9806 n9800 vss vss) n12 w=0.8u l=0.13u
MP9808 (n9806 n9800 vdd vdd) p12 w=2.4u l=0.13u
MN9811 (n9809 n9797 n9810 vss) n12 w=1.6u l=0.13u
MN9812 (n9810 n9806 vss vss) n12 w=1.6u l=0.13u
MP9813 (n9809 n9797 vdd vdd) p12 w=2.4u l=0.13u
MP9814 (n9809 n9806 vdd vdd) p12 w=2.4u l=0.13u
MN9816 (n9815 n9806 vss vss) n12 w=0.8u l=0.13u
MP9817 (n9815 n9806 vdd vdd) p12 w=2.4u l=0.13u
MN9820 (n9818 count_rst n9819 vss) n12 w=1.6u l=0.13u
MN9821 (n9819 n9815 vss vss) n12 w=1.6u l=0.13u
MP9822 (n9818 count_rst vdd vdd) p12 w=2.4u l=0.13u
MP9823 (n9818 n9815 vdd vdd) p12 w=2.4u l=0.13u
MN9826 (n9824 n9809 n9825 vss) n12 w=1.6u l=0.13u
MN9827 (n9825 n9818 vss vss) n12 w=1.6u l=0.13u
MP9828 (n9824 n9809 vdd vdd) p12 w=2.4u l=0.13u
MP9829 (n9824 n9818 vdd vdd) p12 w=2.4u l=0.13u
MN9833 (n9832 n9824 vss vss) n12 w=0.8u l=0.13u
MP9834 (n9832 n9824 vdd vdd) p12 w=2.4u l=0.13u
MN9837 (n9832 clk_low108 storage9836 vss) n12 w=1.2u l=0.13u
MP9838 (n9832 clk_lowb109 storage9836 vdd) p12 w=3.6u l=0.13u
MN9839 (qm9830 clk_high110 storage9836 vss) n12 w=1.2u l=0.13u
MP9840 (qm9830 clk_highb111 storage9836 vdd) p12 w=3.6u l=0.13u
MN9841 (qmb9831 storage9836 vss vss) n12 w=0.5u l=0.13u
MP9842 (qmb9831 storage9836 vdd vdd) p12 w=1.5u l=0.13u
MN9843 (qm9830 qmb9831 vss vss) n12 w=0.5u l=0.13u
MP9844 (qm9830 qmb9831 vdd vdd) p12 w=1.5u l=0.13u
MN9845 (storage9836 rst vss vss) n12 w=2u l=0.13u
MN9847 (qm9830 clk_high110 storage9846 vss) n12 w=1.2u l=0.13u
MP9848 (qm9830 clk_highb111 storage9846 vdd) p12 w=3.6u l=0.13u
MN9849 (qneg9835 clk_low108 storage9846 vss) n12 w=1.2u l=0.13u
MP9850 (qneg9835 clk_lowb109 storage9846 vdd) p12 w=3.6u l=0.13u
MN9851 (count_rst storage9846 vss vss) n12 w=0.5u l=0.13u
MP9852 (count_rst storage9846 vdd vdd) p12 w=1.5u l=0.13u
MN9853 (qneg9835 count_rst vss vss) n12 w=0.5u l=0.13u
MP9854 (qneg9835 count_rst vdd vdd) p12 w=1.5u l=0.13u
MN9855 (storage9846 rst vss vss) n12 w=2u l=0.13u
MN9858 (n9856 s0 n9857 vss) n12 w=1.6u l=0.13u
MN9859 (n9857 step1 vss vss) n12 w=1.6u l=0.13u
MP9860 (n9856 s0 vdd vdd) p12 w=2.4u l=0.13u
MP9861 (n9856 step1 vdd vdd) p12 w=2.4u l=0.13u
MN9864 (n9862 n9856 n9863 vss) n12 w=1.6u l=0.13u
MN9865 (n9863 s0 vss vss) n12 w=1.6u l=0.13u
MP9866 (n9862 n9856 vdd vdd) p12 w=2.4u l=0.13u
MP9867 (n9862 s0 vdd vdd) p12 w=2.4u l=0.13u
MN9870 (n9868 n9856 n9869 vss) n12 w=1.6u l=0.13u
MN9871 (n9869 step1 vss vss) n12 w=1.6u l=0.13u
MP9872 (n9868 n9856 vdd vdd) p12 w=2.4u l=0.13u
MP9873 (n9868 step1 vdd vdd) p12 w=2.4u l=0.13u
MN9876 (n9874 n9862 n9875 vss) n12 w=1.6u l=0.13u
MN9877 (n9875 n9868 vss vss) n12 w=1.6u l=0.13u
MP9878 (n9874 n9862 vdd vdd) p12 w=2.4u l=0.13u
MP9879 (n9874 n9868 vdd vdd) p12 w=2.4u l=0.13u
MN9882 (n9880 n9767 n9881 vss) n12 w=1.6u l=0.13u
MN9883 (n9881 n9874 vss vss) n12 w=1.6u l=0.13u
MP9884 (n9880 n9767 vdd vdd) p12 w=2.4u l=0.13u
MP9885 (n9880 n9874 vdd vdd) p12 w=2.4u l=0.13u
MN9887 (n9886 n9767 vss vss) n12 w=0.8u l=0.13u
MP9888 (n9886 n9767 vdd vdd) p12 w=2.4u l=0.13u
MN9891 (n9889 n9886 n9890 vss) n12 w=1.6u l=0.13u
MN9892 (n9890 s0 vss vss) n12 w=1.6u l=0.13u
MP9893 (n9889 n9886 vdd vdd) p12 w=2.4u l=0.13u
MP9894 (n9889 s0 vdd vdd) p12 w=2.4u l=0.13u
MN9897 (n9895 n9880 n9896 vss) n12 w=1.6u l=0.13u
MN9898 (n9896 n9889 vss vss) n12 w=1.6u l=0.13u
MP9899 (n9895 n9880 vdd vdd) p12 w=2.4u l=0.13u
MP9900 (n9895 n9889 vdd vdd) p12 w=2.4u l=0.13u
MN9905 (n9895 clk_low108 storage9904 vss) n12 w=1.2u l=0.13u
MP9906 (n9895 clk_lowb109 storage9904 vdd) p12 w=3.6u l=0.13u
MN9907 (qm9901 clk_high110 storage9904 vss) n12 w=1.2u l=0.13u
MP9908 (qm9901 clk_highb111 storage9904 vdd) p12 w=3.6u l=0.13u
MN9909 (qmb9902 storage9904 vss vss) n12 w=0.5u l=0.13u
MP9910 (qmb9902 storage9904 vdd vdd) p12 w=1.5u l=0.13u
MN9911 (qm9901 qmb9902 vss vss) n12 w=0.5u l=0.13u
MP9912 (qm9901 qmb9902 vdd vdd) p12 w=1.5u l=0.13u
MN9913 (storage9904 rst vss vss) n12 w=2u l=0.13u
MN9915 (qm9901 clk_high110 storage9914 vss) n12 w=1.2u l=0.13u
MP9916 (qm9901 clk_highb111 storage9914 vdd) p12 w=3.6u l=0.13u
MN9917 (s0 clk_low108 storage9914 vss) n12 w=1.2u l=0.13u
MP9918 (s0 clk_lowb109 storage9914 vdd) p12 w=3.6u l=0.13u
MN9919 (qb9903 storage9914 vss vss) n12 w=0.5u l=0.13u
MP9920 (qb9903 storage9914 vdd vdd) p12 w=1.5u l=0.13u
MN9921 (s0 qb9903 vss vss) n12 w=0.5u l=0.13u
MP9922 (s0 qb9903 vdd vdd) p12 w=1.5u l=0.13u
MN9923 (storage9914 rst vss vss) n12 w=2u l=0.13u
MN9925 (n9924 s0 vss vss) n12 w=0.8u l=0.13u
MP9926 (n9924 s0 vdd vdd) p12 w=2.4u l=0.13u
MN9929 (n9927 n9924 n9928 vss) n12 w=1.6u l=0.13u
MN9930 (n9928 step1 vss vss) n12 w=1.6u l=0.13u
MP9931 (n9927 n9924 vdd vdd) p12 w=2.4u l=0.13u
MP9932 (n9927 step1 vdd vdd) p12 w=2.4u l=0.13u
MN9934 (n9933 n9927 vss vss) n12 w=0.8u l=0.13u
MP9935 (n9933 n9927 vdd vdd) p12 w=2.4u l=0.13u
MN9937 (n9936 n9856 vss vss) n12 w=0.8u l=0.13u
MP9938 (n9936 n9856 vdd vdd) p12 w=2.4u l=0.13u
MN9941 (n9939 n9933 vss vss) n12 w=0.8u l=0.13u
MN9942 (n9939 step2 vss vss) n12 w=0.8u l=0.13u
MP9943 (n9939 n9933 n9940 vdd) p12 w=4.8u l=0.13u
MP9944 (n9940 step2 vdd vdd) p12 w=4.8u l=0.13u
MN9946 (n9945 n9939 vss vss) n12 w=0.8u l=0.13u
MP9947 (n9945 n9939 vdd vdd) p12 w=2.4u l=0.13u
MN9950 (n9948 n9936 vss vss) n12 w=0.8u l=0.13u
MN9951 (n9948 step2 vss vss) n12 w=0.8u l=0.13u
MP9952 (n9948 n9936 n9949 vdd) p12 w=4.8u l=0.13u
MP9953 (n9949 step2 vdd vdd) p12 w=4.8u l=0.13u
MN9955 (n9954 n9948 vss vss) n12 w=0.8u l=0.13u
MP9956 (n9954 n9948 vdd vdd) p12 w=2.4u l=0.13u
MN9959 (n9957 n9945 n9958 vss) n12 w=1.6u l=0.13u
MN9960 (n9958 was_fast vss vss) n12 w=1.6u l=0.13u
MP9961 (n9957 n9945 vdd vdd) p12 w=2.4u l=0.13u
MP9962 (n9957 was_fast vdd vdd) p12 w=2.4u l=0.13u
MN9964 (n9963 was_fast vss vss) n12 w=0.8u l=0.13u
MP9965 (n9963 was_fast vdd vdd) p12 w=2.4u l=0.13u
MN9968 (n9966 n9954 n9967 vss) n12 w=1.6u l=0.13u
MN9969 (n9967 n9963 vss vss) n12 w=1.6u l=0.13u
MP9970 (n9966 n9954 vdd vdd) p12 w=2.4u l=0.13u
MP9971 (n9966 n9963 vdd vdd) p12 w=2.4u l=0.13u
MN9974 (n9972 n9957 n9973 vss) n12 w=1.6u l=0.13u
MN9975 (n9973 n9966 vss vss) n12 w=1.6u l=0.13u
MP9976 (n9972 n9957 vdd vdd) p12 w=2.4u l=0.13u
MP9977 (n9972 n9966 vdd vdd) p12 w=2.4u l=0.13u
MN9980 (n9978 n9972 n9979 vss) n12 w=1.6u l=0.13u
MN9981 (n9979 s1 vss vss) n12 w=1.6u l=0.13u
MP9982 (n9978 n9972 vdd vdd) p12 w=2.4u l=0.13u
MP9983 (n9978 s1 vdd vdd) p12 w=2.4u l=0.13u
MN9986 (n9984 n9972 n9985 vss) n12 w=1.6u l=0.13u
MN9987 (n9985 n9978 vss vss) n12 w=1.6u l=0.13u
MP9988 (n9984 n9972 vdd vdd) p12 w=2.4u l=0.13u
MP9989 (n9984 n9978 vdd vdd) p12 w=2.4u l=0.13u
MN9992 (n9990 n9978 n9991 vss) n12 w=1.6u l=0.13u
MN9993 (n9991 s1 vss vss) n12 w=1.6u l=0.13u
MP9994 (n9990 n9978 vdd vdd) p12 w=2.4u l=0.13u
MP9995 (n9990 s1 vdd vdd) p12 w=2.4u l=0.13u
MN9998 (n9996 n9984 n9997 vss) n12 w=1.6u l=0.13u
MN9999 (n9997 n9990 vss vss) n12 w=1.6u l=0.13u
MP10000 (n9996 n9984 vdd vdd) p12 w=2.4u l=0.13u
MP10001 (n9996 n9990 vdd vdd) p12 w=2.4u l=0.13u
MN10004 (n10002 n9767 n10003 vss) n12 w=1.6u l=0.13u
MN10005 (n10003 n9996 vss vss) n12 w=1.6u l=0.13u
MP10006 (n10002 n9767 vdd vdd) p12 w=2.4u l=0.13u
MP10007 (n10002 n9996 vdd vdd) p12 w=2.4u l=0.13u
MN10010 (n10008 n9886 n10009 vss) n12 w=1.6u l=0.13u
MN10011 (n10009 s1 vss vss) n12 w=1.6u l=0.13u
MP10012 (n10008 n9886 vdd vdd) p12 w=2.4u l=0.13u
MP10013 (n10008 s1 vdd vdd) p12 w=2.4u l=0.13u
MN10016 (n10014 n10002 n10015 vss) n12 w=1.6u l=0.13u
MN10017 (n10015 n10008 vss vss) n12 w=1.6u l=0.13u
MP10018 (n10014 n10002 vdd vdd) p12 w=2.4u l=0.13u
MP10019 (n10014 n10008 vdd vdd) p12 w=2.4u l=0.13u
MN10024 (n10014 clk_low108 storage10023 vss) n12 w=1.2u l=0.13u
MP10025 (n10014 clk_lowb109 storage10023 vdd) p12 w=3.6u l=0.13u
MN10026 (qm10020 clk_high110 storage10023 vss) n12 w=1.2u l=0.13u
MP10027 (qm10020 clk_highb111 storage10023 vdd) p12 w=3.6u l=0.13u
MN10028 (qmb10021 storage10023 vss vss) n12 w=0.5u l=0.13u
MP10029 (qmb10021 storage10023 vdd vdd) p12 w=1.5u l=0.13u
MN10030 (qm10020 qmb10021 vss vss) n12 w=0.5u l=0.13u
MP10031 (qm10020 qmb10021 vdd vdd) p12 w=1.5u l=0.13u
MN10032 (storage10023 rst vss vss) n12 w=2u l=0.13u
MN10034 (qm10020 clk_high110 storage10033 vss) n12 w=1.2u l=0.13u
MP10035 (qm10020 clk_highb111 storage10033 vdd) p12 w=3.6u l=0.13u
MN10036 (s1 clk_low108 storage10033 vss) n12 w=1.2u l=0.13u
MP10037 (s1 clk_lowb109 storage10033 vdd) p12 w=3.6u l=0.13u
MN10038 (qb10022 storage10033 vss vss) n12 w=0.5u l=0.13u
MP10039 (qb10022 storage10033 vdd vdd) p12 w=1.5u l=0.13u
MN10040 (s1 qb10022 vss vss) n12 w=0.5u l=0.13u
MP10041 (s1 qb10022 vdd vdd) p12 w=1.5u l=0.13u
MN10042 (storage10033 rst vss vss) n12 w=2u l=0.13u
MN10045 (n10043 n9404 n10044 vss) n12 w=1.6u l=0.13u
MN10046 (n10044 n9933 vss vss) n12 w=1.6u l=0.13u
MP10047 (n10043 n9404 vdd vdd) p12 w=2.4u l=0.13u
MP10048 (n10043 n9933 vdd vdd) p12 w=2.4u l=0.13u
MN10050 (n10049 n10043 vss vss) n12 w=0.8u l=0.13u
MP10051 (n10049 n10043 vdd vdd) p12 w=2.4u l=0.13u
MN10054 (n10052 n9936 n10053 vss) n12 w=1.6u l=0.13u
MN10055 (n10053 s1 vss vss) n12 w=1.6u l=0.13u
MP10056 (n10052 n9936 vdd vdd) p12 w=2.4u l=0.13u
MP10057 (n10052 s1 vdd vdd) p12 w=2.4u l=0.13u
MN10059 (n10058 n10052 vss vss) n12 w=0.8u l=0.13u
MP10060 (n10058 n10052 vdd vdd) p12 w=2.4u l=0.13u
MN10063 (n10061 n9404 n10062 vss) n12 w=1.6u l=0.13u
MN10064 (n10062 step2 vss vss) n12 w=1.6u l=0.13u
MP10065 (n10061 n9404 vdd vdd) p12 w=2.4u l=0.13u
MP10066 (n10061 step2 vdd vdd) p12 w=2.4u l=0.13u
MN10068 (n10067 n10061 vss vss) n12 w=0.8u l=0.13u
MP10069 (n10067 n10061 vdd vdd) p12 w=2.4u l=0.13u
MN10072 (n10070 s1 n10071 vss) n12 w=1.6u l=0.13u
MN10073 (n10071 step2 vss vss) n12 w=1.6u l=0.13u
MP10074 (n10070 s1 vdd vdd) p12 w=2.4u l=0.13u
MP10075 (n10070 step2 vdd vdd) p12 w=2.4u l=0.13u
MN10077 (n10076 n10070 vss vss) n12 w=0.8u l=0.13u
MP10078 (n10076 n10070 vdd vdd) p12 w=2.4u l=0.13u
MN10081 (n10079 n10049 vss vss) n12 w=0.8u l=0.13u
MN10082 (n10079 n10067 vss vss) n12 w=0.8u l=0.13u
MP10083 (n10079 n10049 n10080 vdd) p12 w=4.8u l=0.13u
MP10084 (n10080 n10067 vdd vdd) p12 w=4.8u l=0.13u
MN10086 (n10085 n10079 vss vss) n12 w=0.8u l=0.13u
MP10087 (n10085 n10079 vdd vdd) p12 w=2.4u l=0.13u
MN10090 (n10088 n10085 vss vss) n12 w=0.8u l=0.13u
MN10091 (n10088 step4 vss vss) n12 w=0.8u l=0.13u
MP10092 (n10088 n10085 n10089 vdd) p12 w=4.8u l=0.13u
MP10093 (n10089 step4 vdd vdd) p12 w=4.8u l=0.13u
MN10095 (n10094 n10088 vss vss) n12 w=0.8u l=0.13u
MP10096 (n10094 n10088 vdd vdd) p12 w=2.4u l=0.13u
MN10099 (n10097 n10058 vss vss) n12 w=0.8u l=0.13u
MN10100 (n10097 n10076 vss vss) n12 w=0.8u l=0.13u
MP10101 (n10097 n10058 n10098 vdd) p12 w=4.8u l=0.13u
MP10102 (n10098 n10076 vdd vdd) p12 w=4.8u l=0.13u
MN10104 (n10103 n10097 vss vss) n12 w=0.8u l=0.13u
MP10105 (n10103 n10097 vdd vdd) p12 w=2.4u l=0.13u
MN10108 (n10106 n10103 vss vss) n12 w=0.8u l=0.13u
MN10109 (n10106 step4 vss vss) n12 w=0.8u l=0.13u
MP10110 (n10106 n10103 n10107 vdd) p12 w=4.8u l=0.13u
MP10111 (n10107 step4 vdd vdd) p12 w=4.8u l=0.13u
MN10113 (n10112 n10106 vss vss) n12 w=0.8u l=0.13u
MP10114 (n10112 n10106 vdd vdd) p12 w=2.4u l=0.13u
MN10117 (n10115 n10094 n10116 vss) n12 w=1.6u l=0.13u
MN10118 (n10116 was_fast vss vss) n12 w=1.6u l=0.13u
MP10119 (n10115 n10094 vdd vdd) p12 w=2.4u l=0.13u
MP10120 (n10115 was_fast vdd vdd) p12 w=2.4u l=0.13u
MN10123 (n10121 n10112 n10122 vss) n12 w=1.6u l=0.13u
MN10124 (n10122 n9963 vss vss) n12 w=1.6u l=0.13u
MP10125 (n10121 n10112 vdd vdd) p12 w=2.4u l=0.13u
MP10126 (n10121 n9963 vdd vdd) p12 w=2.4u l=0.13u
MN10129 (n10127 n10115 n10128 vss) n12 w=1.6u l=0.13u
MN10130 (n10128 n10121 vss vss) n12 w=1.6u l=0.13u
MP10131 (n10127 n10115 vdd vdd) p12 w=2.4u l=0.13u
MP10132 (n10127 n10121 vdd vdd) p12 w=2.4u l=0.13u
MN10135 (n10133 n10127 n10134 vss) n12 w=1.6u l=0.13u
MN10136 (n10134 s2 vss vss) n12 w=1.6u l=0.13u
MP10137 (n10133 n10127 vdd vdd) p12 w=2.4u l=0.13u
MP10138 (n10133 s2 vdd vdd) p12 w=2.4u l=0.13u
MN10141 (n10139 n10127 n10140 vss) n12 w=1.6u l=0.13u
MN10142 (n10140 n10133 vss vss) n12 w=1.6u l=0.13u
MP10143 (n10139 n10127 vdd vdd) p12 w=2.4u l=0.13u
MP10144 (n10139 n10133 vdd vdd) p12 w=2.4u l=0.13u
MN10147 (n10145 n10133 n10146 vss) n12 w=1.6u l=0.13u
MN10148 (n10146 s2 vss vss) n12 w=1.6u l=0.13u
MP10149 (n10145 n10133 vdd vdd) p12 w=2.4u l=0.13u
MP10150 (n10145 s2 vdd vdd) p12 w=2.4u l=0.13u
MN10153 (n10151 n10139 n10152 vss) n12 w=1.6u l=0.13u
MN10154 (n10152 n10145 vss vss) n12 w=1.6u l=0.13u
MP10155 (n10151 n10139 vdd vdd) p12 w=2.4u l=0.13u
MP10156 (n10151 n10145 vdd vdd) p12 w=2.4u l=0.13u
MN10159 (n10157 n10151 n10158 vss) n12 w=1.6u l=0.13u
MN10160 (n10158 n9767 vss vss) n12 w=1.6u l=0.13u
MP10161 (n10157 n10151 vdd vdd) p12 w=2.4u l=0.13u
MP10162 (n10157 n9767 vdd vdd) p12 w=2.4u l=0.13u
MN10165 (n10163 n9886 n10164 vss) n12 w=1.6u l=0.13u
MN10166 (n10164 s2 vss vss) n12 w=1.6u l=0.13u
MP10167 (n10163 n9886 vdd vdd) p12 w=2.4u l=0.13u
MP10168 (n10163 s2 vdd vdd) p12 w=2.4u l=0.13u
MN10171 (n10169 n10157 n10170 vss) n12 w=1.6u l=0.13u
MN10172 (n10170 n10163 vss vss) n12 w=1.6u l=0.13u
MP10173 (n10169 n10157 vdd vdd) p12 w=2.4u l=0.13u
MP10174 (n10169 n10163 vdd vdd) p12 w=2.4u l=0.13u
MN10179 (n10169 clk_low108 storage10178 vss) n12 w=1.2u l=0.13u
MP10180 (n10169 clk_lowb109 storage10178 vdd) p12 w=3.6u l=0.13u
MN10181 (qm10175 clk_high110 storage10178 vss) n12 w=1.2u l=0.13u
MP10182 (qm10175 clk_highb111 storage10178 vdd) p12 w=3.6u l=0.13u
MN10183 (qmb10176 storage10178 vss vss) n12 w=0.5u l=0.13u
MP10184 (qmb10176 storage10178 vdd vdd) p12 w=1.5u l=0.13u
MN10185 (qm10175 qmb10176 vss vss) n12 w=0.5u l=0.13u
MP10186 (qm10175 qmb10176 vdd vdd) p12 w=1.5u l=0.13u
MN10187 (storage10178 rst vss vss) n12 w=2u l=0.13u
MN10189 (qm10175 clk_high110 storage10188 vss) n12 w=1.2u l=0.13u
MP10190 (qm10175 clk_highb111 storage10188 vdd) p12 w=3.6u l=0.13u
MN10191 (s2 clk_low108 storage10188 vss) n12 w=1.2u l=0.13u
MP10192 (s2 clk_lowb109 storage10188 vdd) p12 w=3.6u l=0.13u
MN10193 (qb10177 storage10188 vss vss) n12 w=0.5u l=0.13u
MP10194 (qb10177 storage10188 vdd vdd) p12 w=1.5u l=0.13u
MN10195 (s2 qb10177 vss vss) n12 w=0.5u l=0.13u
MP10196 (s2 qb10177 vdd vdd) p12 w=1.5u l=0.13u
MN10197 (storage10188 rst vss vss) n12 w=2u l=0.13u
MN10200 (n10198 n9404 n10199 vss) n12 w=1.6u l=0.13u
MN10201 (n10199 n9407 vss vss) n12 w=1.6u l=0.13u
MP10202 (n10198 n9404 vdd vdd) p12 w=2.4u l=0.13u
MP10203 (n10198 n9407 vdd vdd) p12 w=2.4u l=0.13u
MN10205 (n10204 n10198 vss vss) n12 w=0.8u l=0.13u
MP10206 (n10204 n10198 vdd vdd) p12 w=2.4u l=0.13u
MN10209 (n10207 n10204 n10208 vss) n12 w=1.6u l=0.13u
MN10210 (n10208 n9933 vss vss) n12 w=1.6u l=0.13u
MP10211 (n10207 n10204 vdd vdd) p12 w=2.4u l=0.13u
MP10212 (n10207 n9933 vdd vdd) p12 w=2.4u l=0.13u
MN10214 (n10213 n10207 vss vss) n12 w=0.8u l=0.13u
MP10215 (n10213 n10207 vdd vdd) p12 w=2.4u l=0.13u
MN10218 (n10216 s1 n10217 vss) n12 w=1.6u l=0.13u
MN10219 (n10217 s2 vss vss) n12 w=1.6u l=0.13u
MP10220 (n10216 s1 vdd vdd) p12 w=2.4u l=0.13u
MP10221 (n10216 s2 vdd vdd) p12 w=2.4u l=0.13u
MN10223 (n10222 n10216 vss vss) n12 w=0.8u l=0.13u
MP10224 (n10222 n10216 vdd vdd) p12 w=2.4u l=0.13u
MN10227 (n10225 n10222 n10226 vss) n12 w=1.6u l=0.13u
MN10228 (n10226 n9936 vss vss) n12 w=1.6u l=0.13u
MP10229 (n10225 n10222 vdd vdd) p12 w=2.4u l=0.13u
MP10230 (n10225 n9936 vdd vdd) p12 w=2.4u l=0.13u
MN10232 (n10231 n10225 vss vss) n12 w=0.8u l=0.13u
MP10233 (n10231 n10225 vdd vdd) p12 w=2.4u l=0.13u
MN10236 (n10234 n10067 n10235 vss) n12 w=1.6u l=0.13u
MN10237 (n10235 n9407 vss vss) n12 w=1.6u l=0.13u
MP10238 (n10234 n10067 vdd vdd) p12 w=2.4u l=0.13u
MP10239 (n10234 n9407 vdd vdd) p12 w=2.4u l=0.13u
MN10241 (n10240 n10234 vss vss) n12 w=0.8u l=0.13u
MP10242 (n10240 n10234 vdd vdd) p12 w=2.4u l=0.13u
MN10245 (n10243 n10076 n10244 vss) n12 w=1.6u l=0.13u
MN10246 (n10244 s2 vss vss) n12 w=1.6u l=0.13u
MP10247 (n10243 n10076 vdd vdd) p12 w=2.4u l=0.13u
MP10248 (n10243 s2 vdd vdd) p12 w=2.4u l=0.13u
MN10250 (n10249 n10243 vss vss) n12 w=0.8u l=0.13u
MP10251 (n10249 n10243 vdd vdd) p12 w=2.4u l=0.13u
MN10254 (n10252 n9407 n10253 vss) n12 w=1.6u l=0.13u
MN10255 (n10253 step4 vss vss) n12 w=1.6u l=0.13u
MP10256 (n10252 n9407 vdd vdd) p12 w=2.4u l=0.13u
MP10257 (n10252 step4 vdd vdd) p12 w=2.4u l=0.13u
MN10259 (n10258 n10252 vss vss) n12 w=0.8u l=0.13u
MP10260 (n10258 n10252 vdd vdd) p12 w=2.4u l=0.13u
MN10263 (n10261 s2 n10262 vss) n12 w=1.6u l=0.13u
MN10264 (n10262 step4 vss vss) n12 w=1.6u l=0.13u
MP10265 (n10261 s2 vdd vdd) p12 w=2.4u l=0.13u
MP10266 (n10261 step4 vdd vdd) p12 w=2.4u l=0.13u
MN10268 (n10267 n10261 vss vss) n12 w=0.8u l=0.13u
MP10269 (n10267 n10261 vdd vdd) p12 w=2.4u l=0.13u
MN10272 (n10270 n10213 vss vss) n12 w=0.8u l=0.13u
MN10273 (n10270 n10240 vss vss) n12 w=0.8u l=0.13u
MP10274 (n10270 n10213 n10271 vdd) p12 w=4.8u l=0.13u
MP10275 (n10271 n10240 vdd vdd) p12 w=4.8u l=0.13u
MN10277 (n10276 n10270 vss vss) n12 w=0.8u l=0.13u
MP10278 (n10276 n10270 vdd vdd) p12 w=2.4u l=0.13u
MN10281 (n10279 n10258 vss vss) n12 w=0.8u l=0.13u
MN10282 (n10279 step8 vss vss) n12 w=0.8u l=0.13u
MP10283 (n10279 n10258 n10280 vdd) p12 w=4.8u l=0.13u
MP10284 (n10280 step8 vdd vdd) p12 w=4.8u l=0.13u
MN10286 (n10285 n10279 vss vss) n12 w=0.8u l=0.13u
MP10287 (n10285 n10279 vdd vdd) p12 w=2.4u l=0.13u
MN10290 (n10288 n10276 vss vss) n12 w=0.8u l=0.13u
MN10291 (n10288 n10285 vss vss) n12 w=0.8u l=0.13u
MP10292 (n10288 n10276 n10289 vdd) p12 w=4.8u l=0.13u
MP10293 (n10289 n10285 vdd vdd) p12 w=4.8u l=0.13u
MN10295 (n10294 n10288 vss vss) n12 w=0.8u l=0.13u
MP10296 (n10294 n10288 vdd vdd) p12 w=2.4u l=0.13u
MN10299 (n10297 n10231 vss vss) n12 w=0.8u l=0.13u
MN10300 (n10297 n10249 vss vss) n12 w=0.8u l=0.13u
MP10301 (n10297 n10231 n10298 vdd) p12 w=4.8u l=0.13u
MP10302 (n10298 n10249 vdd vdd) p12 w=4.8u l=0.13u
MN10304 (n10303 n10297 vss vss) n12 w=0.8u l=0.13u
MP10305 (n10303 n10297 vdd vdd) p12 w=2.4u l=0.13u
MN10308 (n10306 n10267 vss vss) n12 w=0.8u l=0.13u
MN10309 (n10306 step8 vss vss) n12 w=0.8u l=0.13u
MP10310 (n10306 n10267 n10307 vdd) p12 w=4.8u l=0.13u
MP10311 (n10307 step8 vdd vdd) p12 w=4.8u l=0.13u
MN10313 (n10312 n10306 vss vss) n12 w=0.8u l=0.13u
MP10314 (n10312 n10306 vdd vdd) p12 w=2.4u l=0.13u
MN10317 (n10315 n10303 vss vss) n12 w=0.8u l=0.13u
MN10318 (n10315 n10312 vss vss) n12 w=0.8u l=0.13u
MP10319 (n10315 n10303 n10316 vdd) p12 w=4.8u l=0.13u
MP10320 (n10316 n10312 vdd vdd) p12 w=4.8u l=0.13u
MN10322 (n10321 n10315 vss vss) n12 w=0.8u l=0.13u
MP10323 (n10321 n10315 vdd vdd) p12 w=2.4u l=0.13u
MN10326 (n10324 n10294 n10325 vss) n12 w=1.6u l=0.13u
MN10327 (n10325 was_fast vss vss) n12 w=1.6u l=0.13u
MP10328 (n10324 n10294 vdd vdd) p12 w=2.4u l=0.13u
MP10329 (n10324 was_fast vdd vdd) p12 w=2.4u l=0.13u
MN10332 (n10330 n10321 n10331 vss) n12 w=1.6u l=0.13u
MN10333 (n10331 n9963 vss vss) n12 w=1.6u l=0.13u
MP10334 (n10330 n10321 vdd vdd) p12 w=2.4u l=0.13u
MP10335 (n10330 n9963 vdd vdd) p12 w=2.4u l=0.13u
MN10338 (n10336 n10324 n10337 vss) n12 w=1.6u l=0.13u
MN10339 (n10337 n10330 vss vss) n12 w=1.6u l=0.13u
MP10340 (n10336 n10324 vdd vdd) p12 w=2.4u l=0.13u
MP10341 (n10336 n10330 vdd vdd) p12 w=2.4u l=0.13u
MN10344 (n10342 n10336 n10343 vss) n12 w=1.6u l=0.13u
MN10345 (n10343 s3 vss vss) n12 w=1.6u l=0.13u
MP10346 (n10342 n10336 vdd vdd) p12 w=2.4u l=0.13u
MP10347 (n10342 s3 vdd vdd) p12 w=2.4u l=0.13u
MN10350 (n10348 n10336 n10349 vss) n12 w=1.6u l=0.13u
MN10351 (n10349 n10342 vss vss) n12 w=1.6u l=0.13u
MP10352 (n10348 n10336 vdd vdd) p12 w=2.4u l=0.13u
MP10353 (n10348 n10342 vdd vdd) p12 w=2.4u l=0.13u
MN10356 (n10354 n10342 n10355 vss) n12 w=1.6u l=0.13u
MN10357 (n10355 s3 vss vss) n12 w=1.6u l=0.13u
MP10358 (n10354 n10342 vdd vdd) p12 w=2.4u l=0.13u
MP10359 (n10354 s3 vdd vdd) p12 w=2.4u l=0.13u
MN10362 (n10360 n10348 n10361 vss) n12 w=1.6u l=0.13u
MN10363 (n10361 n10354 vss vss) n12 w=1.6u l=0.13u
MP10364 (n10360 n10348 vdd vdd) p12 w=2.4u l=0.13u
MP10365 (n10360 n10354 vdd vdd) p12 w=2.4u l=0.13u
MN10368 (n10366 n10360 n10367 vss) n12 w=1.6u l=0.13u
MN10369 (n10367 n9767 vss vss) n12 w=1.6u l=0.13u
MP10370 (n10366 n10360 vdd vdd) p12 w=2.4u l=0.13u
MP10371 (n10366 n9767 vdd vdd) p12 w=2.4u l=0.13u
MN10374 (n10372 n9886 n10373 vss) n12 w=1.6u l=0.13u
MN10375 (n10373 s3 vss vss) n12 w=1.6u l=0.13u
MP10376 (n10372 n9886 vdd vdd) p12 w=2.4u l=0.13u
MP10377 (n10372 s3 vdd vdd) p12 w=2.4u l=0.13u
MN10380 (n10378 n10366 n10379 vss) n12 w=1.6u l=0.13u
MN10381 (n10379 n10372 vss vss) n12 w=1.6u l=0.13u
MP10382 (n10378 n10366 vdd vdd) p12 w=2.4u l=0.13u
MP10383 (n10378 n10372 vdd vdd) p12 w=2.4u l=0.13u
MN10388 (n10378 clk_low108 storage10387 vss) n12 w=1.2u l=0.13u
MP10389 (n10378 clk_lowb109 storage10387 vdd) p12 w=3.6u l=0.13u
MN10390 (qm10384 clk_high110 storage10387 vss) n12 w=1.2u l=0.13u
MP10391 (qm10384 clk_highb111 storage10387 vdd) p12 w=3.6u l=0.13u
MN10392 (qmb10385 storage10387 vss vss) n12 w=0.5u l=0.13u
MP10393 (qmb10385 storage10387 vdd vdd) p12 w=1.5u l=0.13u
MN10394 (qm10384 qmb10385 vss vss) n12 w=0.5u l=0.13u
MP10395 (qm10384 qmb10385 vdd vdd) p12 w=1.5u l=0.13u
MN10396 (storage10387 rst vss vss) n12 w=2u l=0.13u
MN10398 (qm10384 clk_high110 storage10397 vss) n12 w=1.2u l=0.13u
MP10399 (qm10384 clk_highb111 storage10397 vdd) p12 w=3.6u l=0.13u
MN10400 (s3 clk_low108 storage10397 vss) n12 w=1.2u l=0.13u
MP10401 (s3 clk_lowb109 storage10397 vdd) p12 w=3.6u l=0.13u
MN10402 (qb10386 storage10397 vss vss) n12 w=0.5u l=0.13u
MP10403 (qb10386 storage10397 vdd vdd) p12 w=1.5u l=0.13u
MN10404 (s3 qb10386 vss vss) n12 w=0.5u l=0.13u
MP10405 (s3 qb10386 vdd vdd) p12 w=1.5u l=0.13u
MN10406 (storage10397 rst vss vss) n12 w=2u l=0.13u
MN10409 (n10407 n10213 n10408 vss) n12 w=1.6u l=0.13u
MN10410 (n10408 n9410 vss vss) n12 w=1.6u l=0.13u
MP10411 (n10407 n10213 vdd vdd) p12 w=2.4u l=0.13u
MP10412 (n10407 n9410 vdd vdd) p12 w=2.4u l=0.13u
MN10414 (n10413 n10407 vss vss) n12 w=0.8u l=0.13u
MP10415 (n10413 n10407 vdd vdd) p12 w=2.4u l=0.13u
MN10418 (n10416 n10231 n10417 vss) n12 w=1.6u l=0.13u
MN10419 (n10417 s3 vss vss) n12 w=1.6u l=0.13u
MP10420 (n10416 n10231 vdd vdd) p12 w=2.4u l=0.13u
MP10421 (n10416 s3 vdd vdd) p12 w=2.4u l=0.13u
MN10423 (n10422 n10416 vss vss) n12 w=0.8u l=0.13u
MP10424 (n10422 n10416 vdd vdd) p12 w=2.4u l=0.13u
MN10427 (n10425 n10067 n10426 vss) n12 w=1.6u l=0.13u
MN10428 (n10426 n9431 vss vss) n12 w=1.6u l=0.13u
MP10429 (n10425 n10067 vdd vdd) p12 w=2.4u l=0.13u
MP10430 (n10425 n9431 vdd vdd) p12 w=2.4u l=0.13u
MN10432 (n10431 n10425 vss vss) n12 w=0.8u l=0.13u
MP10433 (n10431 n10425 vdd vdd) p12 w=2.4u l=0.13u
MN10436 (n10434 n10076 n10435 vss) n12 w=1.6u l=0.13u
MN10437 (n10435 n9467 vss vss) n12 w=1.6u l=0.13u
MP10438 (n10434 n10076 vdd vdd) p12 w=2.4u l=0.13u
MP10439 (n10434 n9467 vdd vdd) p12 w=2.4u l=0.13u
MN10441 (n10440 n10434 vss vss) n12 w=0.8u l=0.13u
MP10442 (n10440 n10434 vdd vdd) p12 w=2.4u l=0.13u
MN10445 (n10443 n10258 n10444 vss) n12 w=1.6u l=0.13u
MN10446 (n10444 n9410 vss vss) n12 w=1.6u l=0.13u
MP10447 (n10443 n10258 vdd vdd) p12 w=2.4u l=0.13u
MP10448 (n10443 n9410 vdd vdd) p12 w=2.4u l=0.13u
MN10450 (n10449 n10443 vss vss) n12 w=0.8u l=0.13u
MP10451 (n10449 n10443 vdd vdd) p12 w=2.4u l=0.13u
MN10454 (n10452 n10267 n10453 vss) n12 w=1.6u l=0.13u
MN10455 (n10453 s3 vss vss) n12 w=1.6u l=0.13u
MP10456 (n10452 n10267 vdd vdd) p12 w=2.4u l=0.13u
MP10457 (n10452 s3 vdd vdd) p12 w=2.4u l=0.13u
MN10459 (n10458 n10452 vss vss) n12 w=0.8u l=0.13u
MP10460 (n10458 n10452 vdd vdd) p12 w=2.4u l=0.13u
MN10463 (n10461 n9410 n10462 vss) n12 w=1.6u l=0.13u
MN10464 (n10462 step8 vss vss) n12 w=1.6u l=0.13u
MP10465 (n10461 n9410 vdd vdd) p12 w=2.4u l=0.13u
MP10466 (n10461 step8 vdd vdd) p12 w=2.4u l=0.13u
MN10468 (n10467 n10461 vss vss) n12 w=0.8u l=0.13u
MP10469 (n10467 n10461 vdd vdd) p12 w=2.4u l=0.13u
MN10472 (n10470 s3 n10471 vss) n12 w=1.6u l=0.13u
MN10473 (n10471 step8 vss vss) n12 w=1.6u l=0.13u
MP10474 (n10470 s3 vdd vdd) p12 w=2.4u l=0.13u
MP10475 (n10470 step8 vdd vdd) p12 w=2.4u l=0.13u
MN10477 (n10476 n10470 vss vss) n12 w=0.8u l=0.13u
MP10478 (n10476 n10470 vdd vdd) p12 w=2.4u l=0.13u
MN10481 (n10479 n10413 vss vss) n12 w=0.8u l=0.13u
MN10482 (n10479 n10431 vss vss) n12 w=0.8u l=0.13u
MP10483 (n10479 n10413 n10480 vdd) p12 w=4.8u l=0.13u
MP10484 (n10480 n10431 vdd vdd) p12 w=4.8u l=0.13u
MN10486 (n10485 n10479 vss vss) n12 w=0.8u l=0.13u
MP10487 (n10485 n10479 vdd vdd) p12 w=2.4u l=0.13u
MN10490 (n10488 n10449 vss vss) n12 w=0.8u l=0.13u
MN10491 (n10488 n10467 vss vss) n12 w=0.8u l=0.13u
MP10492 (n10488 n10449 n10489 vdd) p12 w=4.8u l=0.13u
MP10493 (n10489 n10467 vdd vdd) p12 w=4.8u l=0.13u
MN10495 (n10494 n10488 vss vss) n12 w=0.8u l=0.13u
MP10496 (n10494 n10488 vdd vdd) p12 w=2.4u l=0.13u
MN10499 (n10497 n10485 vss vss) n12 w=0.8u l=0.13u
MN10500 (n10497 n10494 vss vss) n12 w=0.8u l=0.13u
MP10501 (n10497 n10485 n10498 vdd) p12 w=4.8u l=0.13u
MP10502 (n10498 n10494 vdd vdd) p12 w=4.8u l=0.13u
MN10504 (n10503 n10497 vss vss) n12 w=0.8u l=0.13u
MP10505 (n10503 n10497 vdd vdd) p12 w=2.4u l=0.13u
MN10508 (n10506 n10422 vss vss) n12 w=0.8u l=0.13u
MN10509 (n10506 n10440 vss vss) n12 w=0.8u l=0.13u
MP10510 (n10506 n10422 n10507 vdd) p12 w=4.8u l=0.13u
MP10511 (n10507 n10440 vdd vdd) p12 w=4.8u l=0.13u
MN10513 (n10512 n10506 vss vss) n12 w=0.8u l=0.13u
MP10514 (n10512 n10506 vdd vdd) p12 w=2.4u l=0.13u
MN10517 (n10515 n10458 vss vss) n12 w=0.8u l=0.13u
MN10518 (n10515 n10476 vss vss) n12 w=0.8u l=0.13u
MP10519 (n10515 n10458 n10516 vdd) p12 w=4.8u l=0.13u
MP10520 (n10516 n10476 vdd vdd) p12 w=4.8u l=0.13u
MN10522 (n10521 n10515 vss vss) n12 w=0.8u l=0.13u
MP10523 (n10521 n10515 vdd vdd) p12 w=2.4u l=0.13u
MN10526 (n10524 n10512 vss vss) n12 w=0.8u l=0.13u
MN10527 (n10524 n10521 vss vss) n12 w=0.8u l=0.13u
MP10528 (n10524 n10512 n10525 vdd) p12 w=4.8u l=0.13u
MP10529 (n10525 n10521 vdd vdd) p12 w=4.8u l=0.13u
MN10531 (n10530 n10524 vss vss) n12 w=0.8u l=0.13u
MP10532 (n10530 n10524 vdd vdd) p12 w=2.4u l=0.13u
MN10535 (n10533 n10503 n10534 vss) n12 w=1.6u l=0.13u
MN10536 (n10534 was_fast vss vss) n12 w=1.6u l=0.13u
MP10537 (n10533 n10503 vdd vdd) p12 w=2.4u l=0.13u
MP10538 (n10533 was_fast vdd vdd) p12 w=2.4u l=0.13u
MN10541 (n10539 n10530 n10540 vss) n12 w=1.6u l=0.13u
MN10542 (n10540 n9963 vss vss) n12 w=1.6u l=0.13u
MP10543 (n10539 n10530 vdd vdd) p12 w=2.4u l=0.13u
MP10544 (n10539 n9963 vdd vdd) p12 w=2.4u l=0.13u
MN10547 (n10545 n10533 n10546 vss) n12 w=1.6u l=0.13u
MN10548 (n10546 n10539 vss vss) n12 w=1.6u l=0.13u
MP10549 (n10545 n10533 vdd vdd) p12 w=2.4u l=0.13u
MP10550 (n10545 n10539 vdd vdd) p12 w=2.4u l=0.13u
MN10553 (n10551 n10545 n10552 vss) n12 w=1.6u l=0.13u
MN10554 (n10552 s4 vss vss) n12 w=1.6u l=0.13u
MP10555 (n10551 n10545 vdd vdd) p12 w=2.4u l=0.13u
MP10556 (n10551 s4 vdd vdd) p12 w=2.4u l=0.13u
MN10559 (n10557 n10545 n10558 vss) n12 w=1.6u l=0.13u
MN10560 (n10558 n10551 vss vss) n12 w=1.6u l=0.13u
MP10561 (n10557 n10545 vdd vdd) p12 w=2.4u l=0.13u
MP10562 (n10557 n10551 vdd vdd) p12 w=2.4u l=0.13u
MN10565 (n10563 n10551 n10564 vss) n12 w=1.6u l=0.13u
MN10566 (n10564 s4 vss vss) n12 w=1.6u l=0.13u
MP10567 (n10563 n10551 vdd vdd) p12 w=2.4u l=0.13u
MP10568 (n10563 s4 vdd vdd) p12 w=2.4u l=0.13u
MN10571 (n10569 n10557 n10570 vss) n12 w=1.6u l=0.13u
MN10572 (n10570 n10563 vss vss) n12 w=1.6u l=0.13u
MP10573 (n10569 n10557 vdd vdd) p12 w=2.4u l=0.13u
MP10574 (n10569 n10563 vdd vdd) p12 w=2.4u l=0.13u
MN10577 (n10575 n10569 n10576 vss) n12 w=1.6u l=0.13u
MN10578 (n10576 n9767 vss vss) n12 w=1.6u l=0.13u
MP10579 (n10575 n10569 vdd vdd) p12 w=2.4u l=0.13u
MP10580 (n10575 n9767 vdd vdd) p12 w=2.4u l=0.13u
MN10583 (n10581 n9886 n10582 vss) n12 w=1.6u l=0.13u
MN10584 (n10582 s4 vss vss) n12 w=1.6u l=0.13u
MP10585 (n10581 n9886 vdd vdd) p12 w=2.4u l=0.13u
MP10586 (n10581 s4 vdd vdd) p12 w=2.4u l=0.13u
MN10589 (n10587 n10575 n10588 vss) n12 w=1.6u l=0.13u
MN10590 (n10588 n10581 vss vss) n12 w=1.6u l=0.13u
MP10591 (n10587 n10575 vdd vdd) p12 w=2.4u l=0.13u
MP10592 (n10587 n10581 vdd vdd) p12 w=2.4u l=0.13u
MN10596 (n10595 n10587 vss vss) n12 w=0.8u l=0.13u
MP10597 (n10595 n10587 vdd vdd) p12 w=2.4u l=0.13u
MN10600 (n10595 clk_low108 storage10599 vss) n12 w=1.2u l=0.13u
MP10601 (n10595 clk_lowb109 storage10599 vdd) p12 w=3.6u l=0.13u
MN10602 (qm10593 clk_high110 storage10599 vss) n12 w=1.2u l=0.13u
MP10603 (qm10593 clk_highb111 storage10599 vdd) p12 w=3.6u l=0.13u
MN10604 (qmb10594 storage10599 vss vss) n12 w=0.5u l=0.13u
MP10605 (qmb10594 storage10599 vdd vdd) p12 w=1.5u l=0.13u
MN10606 (qm10593 qmb10594 vss vss) n12 w=0.5u l=0.13u
MP10607 (qm10593 qmb10594 vdd vdd) p12 w=1.5u l=0.13u
MN10608 (storage10599 rst vss vss) n12 w=2u l=0.13u
MN10610 (qm10593 clk_high110 storage10609 vss) n12 w=1.2u l=0.13u
MP10611 (qm10593 clk_highb111 storage10609 vdd) p12 w=3.6u l=0.13u
MN10612 (qneg10598 clk_low108 storage10609 vss) n12 w=1.2u l=0.13u
MP10613 (qneg10598 clk_lowb109 storage10609 vdd) p12 w=3.6u l=0.13u
MN10614 (s4 storage10609 vss vss) n12 w=0.5u l=0.13u
MP10615 (s4 storage10609 vdd vdd) p12 w=1.5u l=0.13u
MN10616 (qneg10598 s4 vss vss) n12 w=0.5u l=0.13u
MP10617 (qneg10598 s4 vdd vdd) p12 w=1.5u l=0.13u
MN10618 (storage10609 rst vss vss) n12 w=2u l=0.13u
MN10621 (n10619 n9767 n10620 vss) n12 w=1.6u l=0.13u
MN10622 (n10620 step2 vss vss) n12 w=1.6u l=0.13u
MP10623 (n10619 n9767 vdd vdd) p12 w=2.4u l=0.13u
MP10624 (n10619 step2 vdd vdd) p12 w=2.4u l=0.13u
MN10627 (n10625 n9886 n10626 vss) n12 w=1.6u l=0.13u
MN10628 (n10626 step1 vss vss) n12 w=1.6u l=0.13u
MP10629 (n10625 n9886 vdd vdd) p12 w=2.4u l=0.13u
MP10630 (n10625 step1 vdd vdd) p12 w=2.4u l=0.13u
MN10633 (n10631 n10619 n10632 vss) n12 w=1.6u l=0.13u
MN10634 (n10632 n10625 vss vss) n12 w=1.6u l=0.13u
MP10635 (n10631 n10619 vdd vdd) p12 w=2.4u l=0.13u
MP10636 (n10631 n10625 vdd vdd) p12 w=2.4u l=0.13u
MN10641 (n10631 clk_low108 storage10640 vss) n12 w=1.2u l=0.13u
MP10642 (n10631 clk_lowb109 storage10640 vdd) p12 w=3.6u l=0.13u
MN10643 (qm10637 clk_high110 storage10640 vss) n12 w=1.2u l=0.13u
MP10644 (qm10637 clk_highb111 storage10640 vdd) p12 w=3.6u l=0.13u
MN10645 (qmb10638 storage10640 vss vss) n12 w=0.5u l=0.13u
MP10646 (qmb10638 storage10640 vdd vdd) p12 w=1.5u l=0.13u
MN10647 (qm10637 qmb10638 vss vss) n12 w=0.5u l=0.13u
MP10648 (qm10637 qmb10638 vdd vdd) p12 w=1.5u l=0.13u
MN10649 (storage10640 rst vss vss) n12 w=2u l=0.13u
MN10651 (qm10637 clk_high110 storage10650 vss) n12 w=1.2u l=0.13u
MP10652 (qm10637 clk_highb111 storage10650 vdd) p12 w=3.6u l=0.13u
MN10653 (step1 clk_low108 storage10650 vss) n12 w=1.2u l=0.13u
MP10654 (step1 clk_lowb109 storage10650 vdd) p12 w=3.6u l=0.13u
MN10655 (qb10639 storage10650 vss vss) n12 w=0.5u l=0.13u
MP10656 (qb10639 storage10650 vdd vdd) p12 w=1.5u l=0.13u
MN10657 (step1 qb10639 vss vss) n12 w=0.5u l=0.13u
MP10658 (step1 qb10639 vdd vdd) p12 w=1.5u l=0.13u
MN10659 (storage10650 rst vss vss) n12 w=2u l=0.13u
MN10662 (n10660 n9767 n10661 vss) n12 w=1.6u l=0.13u
MN10663 (n10661 step4 vss vss) n12 w=1.6u l=0.13u
MP10664 (n10660 n9767 vdd vdd) p12 w=2.4u l=0.13u
MP10665 (n10660 step4 vdd vdd) p12 w=2.4u l=0.13u
MN10668 (n10666 n9886 n10667 vss) n12 w=1.6u l=0.13u
MN10669 (n10667 step2 vss vss) n12 w=1.6u l=0.13u
MP10670 (n10666 n9886 vdd vdd) p12 w=2.4u l=0.13u
MP10671 (n10666 step2 vdd vdd) p12 w=2.4u l=0.13u
MN10674 (n10672 n10660 n10673 vss) n12 w=1.6u l=0.13u
MN10675 (n10673 n10666 vss vss) n12 w=1.6u l=0.13u
MP10676 (n10672 n10660 vdd vdd) p12 w=2.4u l=0.13u
MP10677 (n10672 n10666 vdd vdd) p12 w=2.4u l=0.13u
MN10682 (n10672 clk_low108 storage10681 vss) n12 w=1.2u l=0.13u
MP10683 (n10672 clk_lowb109 storage10681 vdd) p12 w=3.6u l=0.13u
MN10684 (qm10678 clk_high110 storage10681 vss) n12 w=1.2u l=0.13u
MP10685 (qm10678 clk_highb111 storage10681 vdd) p12 w=3.6u l=0.13u
MN10686 (qmb10679 storage10681 vss vss) n12 w=0.5u l=0.13u
MP10687 (qmb10679 storage10681 vdd vdd) p12 w=1.5u l=0.13u
MN10688 (qm10678 qmb10679 vss vss) n12 w=0.5u l=0.13u
MP10689 (qm10678 qmb10679 vdd vdd) p12 w=1.5u l=0.13u
MN10690 (storage10681 rst vss vss) n12 w=2u l=0.13u
MN10692 (qm10678 clk_high110 storage10691 vss) n12 w=1.2u l=0.13u
MP10693 (qm10678 clk_highb111 storage10691 vdd) p12 w=3.6u l=0.13u
MN10694 (step2 clk_low108 storage10691 vss) n12 w=1.2u l=0.13u
MP10695 (step2 clk_lowb109 storage10691 vdd) p12 w=3.6u l=0.13u
MN10696 (qb10680 storage10691 vss vss) n12 w=0.5u l=0.13u
MP10697 (qb10680 storage10691 vdd vdd) p12 w=1.5u l=0.13u
MN10698 (step2 qb10680 vss vss) n12 w=0.5u l=0.13u
MP10699 (step2 qb10680 vdd vdd) p12 w=1.5u l=0.13u
MN10700 (storage10691 rst vss vss) n12 w=2u l=0.13u
MN10703 (n10701 n9767 n10702 vss) n12 w=1.6u l=0.13u
MN10704 (n10702 step8 vss vss) n12 w=1.6u l=0.13u
MP10705 (n10701 n9767 vdd vdd) p12 w=2.4u l=0.13u
MP10706 (n10701 step8 vdd vdd) p12 w=2.4u l=0.13u
MN10709 (n10707 n9886 n10708 vss) n12 w=1.6u l=0.13u
MN10710 (n10708 step4 vss vss) n12 w=1.6u l=0.13u
MP10711 (n10707 n9886 vdd vdd) p12 w=2.4u l=0.13u
MP10712 (n10707 step4 vdd vdd) p12 w=2.4u l=0.13u
MN10715 (n10713 n10701 n10714 vss) n12 w=1.6u l=0.13u
MN10716 (n10714 n10707 vss vss) n12 w=1.6u l=0.13u
MP10717 (n10713 n10701 vdd vdd) p12 w=2.4u l=0.13u
MP10718 (n10713 n10707 vdd vdd) p12 w=2.4u l=0.13u
MN10723 (n10713 clk_low108 storage10722 vss) n12 w=1.2u l=0.13u
MP10724 (n10713 clk_lowb109 storage10722 vdd) p12 w=3.6u l=0.13u
MN10725 (qm10719 clk_high110 storage10722 vss) n12 w=1.2u l=0.13u
MP10726 (qm10719 clk_highb111 storage10722 vdd) p12 w=3.6u l=0.13u
MN10727 (qmb10720 storage10722 vss vss) n12 w=0.5u l=0.13u
MP10728 (qmb10720 storage10722 vdd vdd) p12 w=1.5u l=0.13u
MN10729 (qm10719 qmb10720 vss vss) n12 w=0.5u l=0.13u
MP10730 (qm10719 qmb10720 vdd vdd) p12 w=1.5u l=0.13u
MN10731 (storage10722 rst vss vss) n12 w=2u l=0.13u
MN10733 (qm10719 clk_high110 storage10732 vss) n12 w=1.2u l=0.13u
MP10734 (qm10719 clk_highb111 storage10732 vdd) p12 w=3.6u l=0.13u
MN10735 (step4 clk_low108 storage10732 vss) n12 w=1.2u l=0.13u
MP10736 (step4 clk_lowb109 storage10732 vdd) p12 w=3.6u l=0.13u
MN10737 (qb10721 storage10732 vss vss) n12 w=0.5u l=0.13u
MP10738 (qb10721 storage10732 vdd vdd) p12 w=1.5u l=0.13u
MN10739 (step4 qb10721 vss vss) n12 w=0.5u l=0.13u
MP10740 (step4 qb10721 vdd vdd) p12 w=1.5u l=0.13u
MN10741 (storage10732 rst vss vss) n12 w=2u l=0.13u
MN10744 (n10742 n9886 n10743 vss) n12 w=1.6u l=0.13u
MN10745 (n10743 step8 vss vss) n12 w=1.6u l=0.13u
MP10746 (n10742 n9886 vdd vdd) p12 w=2.4u l=0.13u
MP10747 (n10742 step8 vdd vdd) p12 w=2.4u l=0.13u
MN10749 (n10748 n10742 vss vss) n12 w=0.8u l=0.13u
MP10750 (n10748 n10742 vdd vdd) p12 w=2.4u l=0.13u
MN10754 (n10753 n10748 vss vss) n12 w=0.8u l=0.13u
MP10755 (n10753 n10748 vdd vdd) p12 w=2.4u l=0.13u
MN10758 (n10753 clk_low108 storage10757 vss) n12 w=1.2u l=0.13u
MP10759 (n10753 clk_lowb109 storage10757 vdd) p12 w=3.6u l=0.13u
MN10760 (qm10751 clk_high110 storage10757 vss) n12 w=1.2u l=0.13u
MP10761 (qm10751 clk_highb111 storage10757 vdd) p12 w=3.6u l=0.13u
MN10762 (qmb10752 storage10757 vss vss) n12 w=0.5u l=0.13u
MP10763 (qmb10752 storage10757 vdd vdd) p12 w=1.5u l=0.13u
MN10764 (qm10751 qmb10752 vss vss) n12 w=0.5u l=0.13u
MP10765 (qm10751 qmb10752 vdd vdd) p12 w=1.5u l=0.13u
MN10766 (storage10757 rst vss vss) n12 w=2u l=0.13u
MN10768 (qm10751 clk_high110 storage10767 vss) n12 w=1.2u l=0.13u
MP10769 (qm10751 clk_highb111 storage10767 vdd) p12 w=3.6u l=0.13u
MN10770 (qneg10756 clk_low108 storage10767 vss) n12 w=1.2u l=0.13u
MP10771 (qneg10756 clk_lowb109 storage10767 vdd) p12 w=3.6u l=0.13u
MN10772 (step8 storage10767 vss vss) n12 w=0.5u l=0.13u
MP10773 (step8 storage10767 vdd vdd) p12 w=1.5u l=0.13u
MN10774 (qneg10756 step8 vss vss) n12 w=0.5u l=0.13u
MP10775 (qneg10756 step8 vdd vdd) p12 w=1.5u l=0.13u
MN10776 (storage10767 rst vss vss) n12 w=2u l=0.13u
MN10779 (n10777 n9797 n10778 vss) n12 w=1.6u l=0.13u
MN10780 (n10778 settle vss vss) n12 w=1.6u l=0.13u
MP10781 (n10777 n9797 vdd vdd) p12 w=2.4u l=0.13u
MP10782 (n10777 settle vdd vdd) p12 w=2.4u l=0.13u
MN10784 (n10783 n10777 vss vss) n12 w=0.8u l=0.13u
MP10785 (n10783 n10777 vdd vdd) p12 w=2.4u l=0.13u
MN10788 (n10786 n10783 vss vss) n12 w=0.8u l=0.13u
MN10789 (n10786 n9776 vss vss) n12 w=0.8u l=0.13u
MP10790 (n10786 n10783 n10787 vdd) p12 w=4.8u l=0.13u
MP10791 (n10787 n9776 vdd vdd) p12 w=4.8u l=0.13u
MN10793 (n10792 n10786 vss vss) n12 w=0.8u l=0.13u
MP10794 (n10792 n10786 vdd vdd) p12 w=2.4u l=0.13u
MN10797 (n10795 n10792 n10796 vss) n12 w=1.6u l=0.13u
MN10798 (n10796 n9581 vss vss) n12 w=1.6u l=0.13u
MP10799 (n10795 n10792 vdd vdd) p12 w=2.4u l=0.13u
MP10800 (n10795 n9581 vdd vdd) p12 w=2.4u l=0.13u
MN10802 (n10801 n10795 vss vss) n12 w=0.8u l=0.13u
MP10803 (n10801 n10795 vdd vdd) p12 w=2.4u l=0.13u
MN10808 (n10801 clk_low108 storage10807 vss) n12 w=1.2u l=0.13u
MP10809 (n10801 clk_lowb109 storage10807 vdd) p12 w=3.6u l=0.13u
MN10810 (qm10804 clk_high110 storage10807 vss) n12 w=1.2u l=0.13u
MP10811 (qm10804 clk_highb111 storage10807 vdd) p12 w=3.6u l=0.13u
MN10812 (qmb10805 storage10807 vss vss) n12 w=0.5u l=0.13u
MP10813 (qmb10805 storage10807 vdd vdd) p12 w=1.5u l=0.13u
MN10814 (qm10804 qmb10805 vss vss) n12 w=0.5u l=0.13u
MP10815 (qm10804 qmb10805 vdd vdd) p12 w=1.5u l=0.13u
MN10816 (storage10807 rst vss vss) n12 w=2u l=0.13u
MN10818 (qm10804 clk_high110 storage10817 vss) n12 w=1.2u l=0.13u
MP10819 (qm10804 clk_highb111 storage10817 vdd) p12 w=3.6u l=0.13u
MN10820 (settle clk_low108 storage10817 vss) n12 w=1.2u l=0.13u
MP10821 (settle clk_lowb109 storage10817 vdd) p12 w=3.6u l=0.13u
MN10822 (qb10806 storage10817 vss vss) n12 w=0.5u l=0.13u
MP10823 (qb10806 storage10817 vdd vdd) p12 w=1.5u l=0.13u
MN10824 (settle qb10806 vss vss) n12 w=0.5u l=0.13u
MP10825 (settle qb10806 vdd vdd) p12 w=1.5u l=0.13u
MN10826 (storage10817 rst vss vss) n12 w=2u l=0.13u
MN10829 (n10827 n8697 vss vss) n12 w=0.8u l=0.13u
MN10830 (n10827 n8718 vss vss) n12 w=0.8u l=0.13u
MP10831 (n10827 n8697 n10828 vdd) p12 w=4.8u l=0.13u
MP10832 (n10828 n8718 vdd vdd) p12 w=4.8u l=0.13u
MN10834 (n10833 n10827 vss vss) n12 w=0.8u l=0.13u
MP10835 (n10833 n10827 vdd vdd) p12 w=2.4u l=0.13u
MN10837 (n10836 n10833 vss vss) n12 w=0.8u l=0.13u
MP10838 (n10836 n10833 vdd vdd) p12 w=2.4u l=0.13u
MN10841 (n10839 arm n10840 vss) n12 w=1.6u l=0.13u
MN10842 (n10840 n10836 vss vss) n12 w=1.6u l=0.13u
MP10843 (n10839 arm vdd vdd) p12 w=2.4u l=0.13u
MP10844 (n10839 n10836 vdd vdd) p12 w=2.4u l=0.13u
MN10846 (n10845 n10839 vss vss) n12 w=0.8u l=0.13u
MP10847 (n10845 n10839 vdd vdd) p12 w=2.4u l=0.13u
MN10850 (n10848 n10845 vss vss) n12 w=0.8u l=0.13u
MN10851 (n10848 n8361 vss vss) n12 w=0.8u l=0.13u
MP10852 (n10848 n10845 n10849 vdd) p12 w=4.8u l=0.13u
MP10853 (n10849 n8361 vdd vdd) p12 w=4.8u l=0.13u
MN10855 (n10854 n10848 vss vss) n12 w=0.8u l=0.13u
MP10856 (n10854 n10848 vdd vdd) p12 w=2.4u l=0.13u
MN10859 (n10857 n10854 n10858 vss) n12 w=1.6u l=0.13u
MN10860 (n10858 n9581 vss vss) n12 w=1.6u l=0.13u
MP10861 (n10857 n10854 vdd vdd) p12 w=2.4u l=0.13u
MP10862 (n10857 n9581 vdd vdd) p12 w=2.4u l=0.13u
MN10864 (n10863 n10857 vss vss) n12 w=0.8u l=0.13u
MP10865 (n10863 n10857 vdd vdd) p12 w=2.4u l=0.13u
MN10870 (n10863 clk_low108 storage10869 vss) n12 w=1.2u l=0.13u
MP10871 (n10863 clk_lowb109 storage10869 vdd) p12 w=3.6u l=0.13u
MN10872 (qm10866 clk_high110 storage10869 vss) n12 w=1.2u l=0.13u
MP10873 (qm10866 clk_highb111 storage10869 vdd) p12 w=3.6u l=0.13u
MN10874 (qmb10867 storage10869 vss vss) n12 w=0.5u l=0.13u
MP10875 (qmb10867 storage10869 vdd vdd) p12 w=1.5u l=0.13u
MN10876 (qm10866 qmb10867 vss vss) n12 w=0.5u l=0.13u
MP10877 (qm10866 qmb10867 vdd vdd) p12 w=1.5u l=0.13u
MN10878 (storage10869 rst vss vss) n12 w=2u l=0.13u
MN10880 (qm10866 clk_high110 storage10879 vss) n12 w=1.2u l=0.13u
MP10881 (qm10866 clk_highb111 storage10879 vdd) p12 w=3.6u l=0.13u
MN10882 (arm clk_low108 storage10879 vss) n12 w=1.2u l=0.13u
MP10883 (arm clk_lowb109 storage10879 vdd) p12 w=3.6u l=0.13u
MN10884 (qb10868 storage10879 vss vss) n12 w=0.5u l=0.13u
MP10885 (qb10868 storage10879 vdd vdd) p12 w=1.5u l=0.13u
MN10886 (arm qb10868 vss vss) n12 w=0.5u l=0.13u
MP10887 (arm qb10868 vdd vdd) p12 w=1.5u l=0.13u
MN10888 (storage10879 rst vss vss) n12 w=2u l=0.13u
MN10891 (n10889 measure n10890 vss) n12 w=1.6u l=0.13u
MN10892 (n10890 n9611 vss vss) n12 w=1.6u l=0.13u
MP10893 (n10889 measure vdd vdd) p12 w=2.4u l=0.13u
MP10894 (n10889 n9611 vdd vdd) p12 w=2.4u l=0.13u
MN10896 (n10895 n10889 vss vss) n12 w=0.8u l=0.13u
MP10897 (n10895 n10889 vdd vdd) p12 w=2.4u l=0.13u
MN10900 (n10898 n10895 vss vss) n12 w=0.8u l=0.13u
MN10901 (n10898 n8697 vss vss) n12 w=0.8u l=0.13u
MP10902 (n10898 n10895 n10899 vdd) p12 w=4.8u l=0.13u
MP10903 (n10899 n8697 vdd vdd) p12 w=4.8u l=0.13u
MN10905 (n10904 n10898 vss vss) n12 w=0.8u l=0.13u
MP10906 (n10904 n10898 vdd vdd) p12 w=2.4u l=0.13u
MN10909 (n10907 n10904 n10908 vss) n12 w=1.6u l=0.13u
MN10910 (n10908 n9581 vss vss) n12 w=1.6u l=0.13u
MP10911 (n10907 n10904 vdd vdd) p12 w=2.4u l=0.13u
MP10912 (n10907 n9581 vdd vdd) p12 w=2.4u l=0.13u
MN10914 (n10913 n10907 vss vss) n12 w=0.8u l=0.13u
MP10915 (n10913 n10907 vdd vdd) p12 w=2.4u l=0.13u
MN10920 (n10913 clk_low108 storage10919 vss) n12 w=1.2u l=0.13u
MP10921 (n10913 clk_lowb109 storage10919 vdd) p12 w=3.6u l=0.13u
MN10922 (qm10916 clk_high110 storage10919 vss) n12 w=1.2u l=0.13u
MP10923 (qm10916 clk_highb111 storage10919 vdd) p12 w=3.6u l=0.13u
MN10924 (qmb10917 storage10919 vss vss) n12 w=0.5u l=0.13u
MP10925 (qmb10917 storage10919 vdd vdd) p12 w=1.5u l=0.13u
MN10926 (qm10916 qmb10917 vss vss) n12 w=0.5u l=0.13u
MP10927 (qm10916 qmb10917 vdd vdd) p12 w=1.5u l=0.13u
MN10928 (storage10919 rst vss vss) n12 w=2u l=0.13u
MN10930 (qm10916 clk_high110 storage10929 vss) n12 w=1.2u l=0.13u
MP10931 (qm10916 clk_highb111 storage10929 vdd) p12 w=3.6u l=0.13u
MN10932 (measure clk_low108 storage10929 vss) n12 w=1.2u l=0.13u
MP10933 (measure clk_lowb109 storage10929 vdd) p12 w=3.6u l=0.13u
MN10934 (qb10918 storage10929 vss vss) n12 w=0.5u l=0.13u
MP10935 (qb10918 storage10929 vdd vdd) p12 w=1.5u l=0.13u
MN10936 (measure qb10918 vss vss) n12 w=0.5u l=0.13u
MP10937 (measure qb10918 vdd vdd) p12 w=1.5u l=0.13u
MN10938 (storage10929 rst vss vss) n12 w=2u l=0.13u
MN10940 (n10939 n8854 vss vss) n12 w=0.8u l=0.13u
MP10941 (n10939 n8854 vdd vdd) p12 w=2.4u l=0.13u
MN10944 (n10942 drain n10943 vss) n12 w=1.6u l=0.13u
MN10945 (n10943 n10939 vss vss) n12 w=1.6u l=0.13u
MP10946 (n10942 drain vdd vdd) p12 w=2.4u l=0.13u
MP10947 (n10942 n10939 vdd vdd) p12 w=2.4u l=0.13u
MN10949 (n10948 n10942 vss vss) n12 w=0.8u l=0.13u
MP10950 (n10948 n10942 vdd vdd) p12 w=2.4u l=0.13u
MN10953 (n10951 n10948 vss vss) n12 w=0.8u l=0.13u
MN10954 (n10951 n6901 vss vss) n12 w=0.8u l=0.13u
MP10955 (n10951 n10948 n10952 vdd) p12 w=4.8u l=0.13u
MP10956 (n10952 n6901 vdd vdd) p12 w=4.8u l=0.13u
MN10958 (n10957 n10951 vss vss) n12 w=0.8u l=0.13u
MP10959 (n10957 n10951 vdd vdd) p12 w=2.4u l=0.13u
MN10962 (n10960 n10957 n10961 vss) n12 w=1.6u l=0.13u
MN10963 (n10961 n9581 vss vss) n12 w=1.6u l=0.13u
MP10964 (n10960 n10957 vdd vdd) p12 w=2.4u l=0.13u
MP10965 (n10960 n9581 vdd vdd) p12 w=2.4u l=0.13u
MN10967 (n10966 n10960 vss vss) n12 w=0.8u l=0.13u
MP10968 (n10966 n10960 vdd vdd) p12 w=2.4u l=0.13u
MN10973 (n10966 clk_low108 storage10972 vss) n12 w=1.2u l=0.13u
MP10974 (n10966 clk_lowb109 storage10972 vdd) p12 w=3.6u l=0.13u
MN10975 (qm10969 clk_high110 storage10972 vss) n12 w=1.2u l=0.13u
MP10976 (qm10969 clk_highb111 storage10972 vdd) p12 w=3.6u l=0.13u
MN10977 (qmb10970 storage10972 vss vss) n12 w=0.5u l=0.13u
MP10978 (qmb10970 storage10972 vdd vdd) p12 w=1.5u l=0.13u
MN10979 (qm10969 qmb10970 vss vss) n12 w=0.5u l=0.13u
MP10980 (qm10969 qmb10970 vdd vdd) p12 w=1.5u l=0.13u
MN10981 (storage10972 rst vss vss) n12 w=2u l=0.13u
MN10983 (qm10969 clk_high110 storage10982 vss) n12 w=1.2u l=0.13u
MP10984 (qm10969 clk_highb111 storage10982 vdd) p12 w=3.6u l=0.13u
MN10985 (drain clk_low108 storage10982 vss) n12 w=1.2u l=0.13u
MP10986 (drain clk_lowb109 storage10982 vdd) p12 w=3.6u l=0.13u
MN10987 (qb10971 storage10982 vss vss) n12 w=0.5u l=0.13u
MP10988 (qb10971 storage10982 vdd vdd) p12 w=1.5u l=0.13u
MN10989 (drain qb10971 vss vss) n12 w=0.5u l=0.13u
MP10990 (drain qb10971 vdd vdd) p12 w=1.5u l=0.13u
MN10991 (storage10982 rst vss vss) n12 w=2u l=0.13u
MN10996 (done clk_low108 storage10995 vss) n12 w=1.2u l=0.13u
MP10997 (done clk_lowb109 storage10995 vdd) p12 w=3.6u l=0.13u
MN10998 (qm10992 clk_high110 storage10995 vss) n12 w=1.2u l=0.13u
MP10999 (qm10992 clk_highb111 storage10995 vdd) p12 w=3.6u l=0.13u
MN11000 (qmb10993 storage10995 vss vss) n12 w=0.5u l=0.13u
MP11001 (qmb10993 storage10995 vdd vdd) p12 w=1.5u l=0.13u
MN11002 (qm10992 qmb10993 vss vss) n12 w=0.5u l=0.13u
MP11003 (qm10992 qmb10993 vdd vdd) p12 w=1.5u l=0.13u
MN11004 (storage10995 rst vss vss) n12 w=2u l=0.13u
MN11006 (qm10992 clk_high110 storage11005 vss) n12 w=1.2u l=0.13u
MP11007 (qm10992 clk_highb111 storage11005 vdd) p12 w=3.6u l=0.13u
MN11008 (done_delay1 clk_low108 storage11005 vss) n12 w=1.2u l=0.13u
MP11009 (done_delay1 clk_lowb109 storage11005 vdd) p12 w=3.6u l=0.13u
MN11010 (qb10994 storage11005 vss vss) n12 w=0.5u l=0.13u
MP11011 (qb10994 storage11005 vdd vdd) p12 w=1.5u l=0.13u
MN11012 (done_delay1 qb10994 vss vss) n12 w=0.5u l=0.13u
MP11013 (done_delay1 qb10994 vdd vdd) p12 w=1.5u l=0.13u
MN11014 (storage11005 rst vss vss) n12 w=2u l=0.13u
MN11017 (n11015 done_delay1 n11016 vss) n12 w=1.6u l=0.13u
MN11018 (n11016 n39 vss vss) n12 w=1.6u l=0.13u
MP11019 (n11015 done_delay1 vdd vdd) p12 w=2.4u l=0.13u
MP11020 (n11015 n39 vdd vdd) p12 w=2.4u l=0.13u
MN11022 (n11021 n11015 vss vss) n12 w=0.8u l=0.13u
MP11023 (n11021 n11015 vdd vdd) p12 w=2.4u l=0.13u
MN11028 (n11021 clk_low108 storage11027 vss) n12 w=1.2u l=0.13u
MP11029 (n11021 clk_lowb109 storage11027 vdd) p12 w=3.6u l=0.13u
MN11030 (qm11024 clk_high110 storage11027 vss) n12 w=1.2u l=0.13u
MP11031 (qm11024 clk_highb111 storage11027 vdd) p12 w=3.6u l=0.13u
MN11032 (qmb11025 storage11027 vss vss) n12 w=0.5u l=0.13u
MP11033 (qmb11025 storage11027 vdd vdd) p12 w=1.5u l=0.13u
MN11034 (qm11024 qmb11025 vss vss) n12 w=0.5u l=0.13u
MP11035 (qm11024 qmb11025 vdd vdd) p12 w=1.5u l=0.13u
MN11036 (storage11027 rst vss vss) n12 w=2u l=0.13u
MN11038 (qm11024 clk_high110 storage11037 vss) n12 w=1.2u l=0.13u
MP11039 (qm11024 clk_highb111 storage11037 vdd) p12 w=3.6u l=0.13u
MN11040 (fine_enable clk_low108 storage11037 vss) n12 w=1.2u l=0.13u
MP11041 (fine_enable clk_lowb109 storage11037 vdd) p12 w=3.6u l=0.13u
MN11042 (qb11026 storage11037 vss vss) n12 w=0.5u l=0.13u
MP11043 (qb11026 storage11037 vdd vdd) p12 w=1.5u l=0.13u
MN11044 (fine_enable qb11026 vss vss) n12 w=0.5u l=0.13u
MP11045 (fine_enable qb11026 vdd vdd) p12 w=1.5u l=0.13u
MN11046 (storage11037 rst vss vss) n12 w=2u l=0.13u
MN11048 (n11047 fine_enable vss vss) n12 w=0.8u l=0.13u
MP11049 (n11047 fine_enable vdd vdd) p12 w=2.4u l=0.13u
MN11051 (n11050 n11047 vss vss) n12 w=0.8u l=0.13u
MP11052 (n11050 n11047 vdd vdd) p12 w=2.4u l=0.13u
MN11054 (n11053 n11050 vss vss) n12 w=0.8u l=0.13u
MP11055 (n11053 n11050 vdd vdd) p12 w=2.4u l=0.13u
MN11057 (n11056 n11053 vss vss) n12 w=0.8u l=0.13u
MP11058 (n11056 n11053 vdd vdd) p12 w=2.4u l=0.13u
MN11059 (hold n11056 vss vss) n12 w=0.8u l=0.13u
MP11060 (hold n11056 vdd vdd) p12 w=2.4u l=0.13u
MN11063 (n11061 n11047 vss vss) n12 w=0.8u l=0.13u
MN11064 (n11061 rst vss vss) n12 w=0.8u l=0.13u
MP11065 (n11061 n11047 n11062 vdd) p12 w=4.8u l=0.13u
MP11066 (n11062 rst vdd vdd) p12 w=4.8u l=0.13u
MN11068 (n11067 n11061 vss vss) n12 w=0.8u l=0.13u
MP11069 (n11067 n11061 vdd vdd) p12 w=2.4u l=0.13u
MN11071 (n11070 n11067 vss vss) n12 w=0.8u l=0.13u
MP11072 (n11070 n11067 vdd vdd) p12 w=2.4u l=0.13u
MN11074 (n11073 n11070 vss vss) n12 w=0.8u l=0.13u
MP11075 (n11073 n11070 vdd vdd) p12 w=2.4u l=0.13u
MN11077 (n11076 n11073 vss vss) n12 w=0.8u l=0.13u
MP11078 (n11076 n11073 vdd vdd) p12 w=2.4u l=0.13u
MN11079 (pfd_reset n11076 vss vss) n12 w=0.8u l=0.13u
MP11080 (pfd_reset n11076 vdd vdd) p12 w=2.4u l=0.13u
ends afc2009_mos
