// GENERATED transistor-only static-CMOS AFC: Jeong2009-inspired first-edge phase bracket.
// R1 NEW130nm non-overlap interlocked clock controls and frozen-DRAIN counters.
// source design unverified until electrical units pass.
// All state physical TG DFFs, all compare/control staticMOS gates, no VA.
// REF100MHz, FB=VCO/32, positive frequency/code polarity; vdd=1.2V.
// VDD/VSS body rails; n12/p12 ordinary tt models required in top-level.
// Phase selector reset-release16physicalINV guard is not timing-signoff.
simulator lang=spectre
subckt afc2009_mos (vdd vss ref fb rst start s0 s1 s2 s3 s4 done fail hold fine_enable pfd_reset active)
MN3 (n1 fail vss vss) n12 w=0.8u l=0.13u
MN4 (n1 fine_enable vss vss) n12 w=0.8u l=0.13u
MP5 (n1 fail n2 vdd) p12 w=4.8u l=0.13u
MP6 (n2 fine_enable vdd vdd) p12 w=4.8u l=0.13u
MN8 (n7 n1 vss vss) n12 w=0.8u l=0.13u
MP9 (n7 n1 vdd vdd) p12 w=2.4u l=0.13u
MN11 (n10 n7 vss vss) n12 w=0.8u l=0.13u
MP12 (n10 n7 vdd vdd) p12 w=2.4u l=0.13u
MN15 (n13 n10 n14 vss) n12 w=1.6u l=0.13u
MN16 (n14 ref vss vss) n12 w=1.6u l=0.13u
MP17 (n13 n10 vdd vdd) p12 w=2.4u l=0.13u
MP18 (n13 ref vdd vdd) p12 w=2.4u l=0.13u
MN20 (n19 n13 vss vss) n12 w=0.8u l=0.13u
MP21 (n19 n13 vdd vdd) p12 w=2.4u l=0.13u
MN23 (n22 n19 vss vss) n12 w=0.8u l=0.13u
MP24 (n22 n19 vdd vdd) p12 w=2.4u l=0.13u
MN26 (n25 n22 vss vss) n12 w=0.8u l=0.13u
MP27 (n25 n22 vdd vdd) p12 w=2.4u l=0.13u
MN29 (n28 n25 vss vss) n12 w=0.8u l=0.13u
MP30 (n28 n25 vdd vdd) p12 w=2.4u l=0.13u
MN31 (control_clock n28 vss vss) n12 w=0.8u l=0.13u
MP32 (control_clock n28 vdd vdd) p12 w=2.4u l=0.13u
MN34 (n33 started vss vss) n12 w=0.8u l=0.13u
MP35 (n33 started vdd vdd) p12 w=2.4u l=0.13u
MN37 (n36 done vss vss) n12 w=0.8u l=0.13u
MP38 (n36 done vdd vdd) p12 w=2.4u l=0.13u
MN40 (n39 fail vss vss) n12 w=0.8u l=0.13u
MP41 (n39 fail vdd vdd) p12 w=2.4u l=0.13u
MN44 (n42 n33 n43 vss) n12 w=1.6u l=0.13u
MN45 (n43 start vss vss) n12 w=1.6u l=0.13u
MP46 (n42 n33 vdd vdd) p12 w=2.4u l=0.13u
MP47 (n42 start vdd vdd) p12 w=2.4u l=0.13u
MN49 (n48 n42 vss vss) n12 w=0.8u l=0.13u
MP50 (n48 n42 vdd vdd) p12 w=2.4u l=0.13u
MN53 (n51 n36 n52 vss) n12 w=1.6u l=0.13u
MN54 (n52 n39 vss vss) n12 w=1.6u l=0.13u
MP55 (n51 n36 vdd vdd) p12 w=2.4u l=0.13u
MP56 (n51 n39 vdd vdd) p12 w=2.4u l=0.13u
MN58 (n57 n51 vss vss) n12 w=0.8u l=0.13u
MP59 (n57 n51 vdd vdd) p12 w=2.4u l=0.13u
MN62 (n60 n48 n61 vss) n12 w=1.6u l=0.13u
MN63 (n61 n57 vss vss) n12 w=1.6u l=0.13u
MP64 (n60 n48 vdd vdd) p12 w=2.4u l=0.13u
MP65 (n60 n57 vdd vdd) p12 w=2.4u l=0.13u
MN67 (n66 n60 vss vss) n12 w=0.8u l=0.13u
MP68 (n66 n60 vdd vdd) p12 w=2.4u l=0.13u
MN70 (n69 n66 vss vss) n12 w=0.8u l=0.13u
MP71 (n69 n66 vdd vdd) p12 w=2.4u l=0.13u
MN74 (n72 n69 n73 vss) n12 w=1.6u l=0.13u
MN75 (n73 started vss vss) n12 w=1.6u l=0.13u
MP76 (n72 n69 vdd vdd) p12 w=2.4u l=0.13u
MP77 (n72 started vdd vdd) p12 w=2.4u l=0.13u
MN80 (n78 n69 n79 vss) n12 w=1.6u l=0.13u
MN81 (n79 n72 vss vss) n12 w=1.6u l=0.13u
MP82 (n78 n69 vdd vdd) p12 w=2.4u l=0.13u
MP83 (n78 n72 vdd vdd) p12 w=2.4u l=0.13u
MN85 (delay84 n19 vss vss) n12 w=0.8u l=0.13u
MP86 (delay84 n19 vdd vdd) p12 w=2.4u l=0.13u
MN88 (delay87 delay84 vss vss) n12 w=0.8u l=0.13u
MP89 (delay87 delay84 vdd vdd) p12 w=2.4u l=0.13u
MN91 (delay90 delay87 vss vss) n12 w=0.8u l=0.13u
MP92 (delay90 delay87 vdd vdd) p12 w=2.4u l=0.13u
MN94 (delay93 delay90 vss vss) n12 w=0.8u l=0.13u
MP95 (delay93 delay90 vdd vdd) p12 w=2.4u l=0.13u
MN97 (delay96 delay93 vss vss) n12 w=0.8u l=0.13u
MP98 (delay96 delay93 vdd vdd) p12 w=2.4u l=0.13u
MN100 (delay99 delay96 vss vss) n12 w=0.8u l=0.13u
MP101 (delay99 delay96 vdd vdd) p12 w=2.4u l=0.13u
MN103 (n102 delay99 vss vss) n12 w=0.8u l=0.13u
MP104 (n102 delay99 vdd vdd) p12 w=2.4u l=0.13u
MN106 (n105 rst vss vss) n12 w=0.8u l=0.13u
MP107 (n105 rst vdd vdd) p12 w=2.4u l=0.13u
MN116 (n112 n22 n113 vss) n12 w=3.2u l=0.13u
MP117 (n112 n22 vdd vdd) p12 w=2.4u l=0.13u
MN118 (n113 n102 n114 vss) n12 w=3.2u l=0.13u
MP119 (n112 n102 vdd vdd) p12 w=2.4u l=0.13u
MN120 (n114 clk_highb111 n115 vss) n12 w=3.2u l=0.13u
MP121 (n112 clk_highb111 vdd vdd) p12 w=2.4u l=0.13u
MN122 (n115 n105 vss vss) n12 w=3.2u l=0.13u
MP123 (n112 n105 vdd vdd) p12 w=2.4u l=0.13u
MN128 (n124 n19 n125 vss) n12 w=3.2u l=0.13u
MP129 (n124 n19 vdd vdd) p12 w=2.4u l=0.13u
MN130 (n125 delay99 n126 vss) n12 w=3.2u l=0.13u
MP131 (n124 delay99 vdd vdd) p12 w=2.4u l=0.13u
MN132 (n126 clk_lowb109 n127 vss) n12 w=3.2u l=0.13u
MP133 (n124 clk_lowb109 vdd vdd) p12 w=2.4u l=0.13u
MN134 (n127 n105 vss vss) n12 w=3.2u l=0.13u
MP135 (n124 n105 vdd vdd) p12 w=2.4u l=0.13u
MN136 (clk_low108 n112 vss vss) n12 w=8u l=0.13u
MP137 (clk_low108 n112 vdd vdd) p12 w=24u l=0.13u
MN138 (clk_lowb109 clk_low108 vss vss) n12 w=8u l=0.13u
MP139 (clk_lowb109 clk_low108 vdd vdd) p12 w=24u l=0.13u
MN140 (clk_high110 n124 vss vss) n12 w=8u l=0.13u
MP141 (clk_high110 n124 vdd vdd) p12 w=24u l=0.13u
MN142 (clk_highb111 clk_high110 vss vss) n12 w=8u l=0.13u
MP143 (clk_highb111 clk_high110 vdd vdd) p12 w=24u l=0.13u
MN148 (n78 clk_low108 storage147 vss) n12 w=1.2u l=0.13u
MP149 (n78 clk_lowb109 storage147 vdd) p12 w=3.6u l=0.13u
MN150 (qm144 clk_high110 storage147 vss) n12 w=1.2u l=0.13u
MP151 (qm144 clk_highb111 storage147 vdd) p12 w=3.6u l=0.13u
MN152 (qmb145 storage147 vss vss) n12 w=0.5u l=0.13u
MP153 (qmb145 storage147 vdd vdd) p12 w=1.5u l=0.13u
MN154 (qm144 qmb145 vss vss) n12 w=0.5u l=0.13u
MP155 (qm144 qmb145 vdd vdd) p12 w=1.5u l=0.13u
MN156 (storage147 rst vss vss) n12 w=2u l=0.13u
MN158 (qm144 clk_high110 storage157 vss) n12 w=1.2u l=0.13u
MP159 (qm144 clk_highb111 storage157 vdd) p12 w=3.6u l=0.13u
MN160 (started clk_low108 storage157 vss) n12 w=1.2u l=0.13u
MP161 (started clk_lowb109 storage157 vdd) p12 w=3.6u l=0.13u
MN162 (qb146 storage157 vss vss) n12 w=0.5u l=0.13u
MP163 (qb146 storage157 vdd vdd) p12 w=1.5u l=0.13u
MN164 (started qb146 vss vss) n12 w=0.5u l=0.13u
MP165 (started qb146 vdd vdd) p12 w=1.5u l=0.13u
MN166 (storage157 rst vss vss) n12 w=2u l=0.13u
MN169 (n167 arm vss vss) n12 w=0.8u l=0.13u
MN170 (n167 settle vss vss) n12 w=0.8u l=0.13u
MP171 (n167 arm n168 vdd) p12 w=4.8u l=0.13u
MP172 (n168 settle vdd vdd) p12 w=4.8u l=0.13u
MN174 (n173 n167 vss vss) n12 w=0.8u l=0.13u
MP175 (n173 n167 vdd vdd) p12 w=2.4u l=0.13u
MN178 (n176 drain vss vss) n12 w=0.8u l=0.13u
MN179 (n176 measure vss vss) n12 w=0.8u l=0.13u
MP180 (n176 drain n177 vdd) p12 w=4.8u l=0.13u
MP181 (n177 measure vdd vdd) p12 w=4.8u l=0.13u
MN183 (n182 n176 vss vss) n12 w=0.8u l=0.13u
MP184 (n182 n176 vdd vdd) p12 w=2.4u l=0.13u
MN187 (n185 n173 vss vss) n12 w=0.8u l=0.13u
MN188 (n185 n182 vss vss) n12 w=0.8u l=0.13u
MP189 (n185 n173 n186 vdd) p12 w=4.8u l=0.13u
MP190 (n186 n182 vdd vdd) p12 w=4.8u l=0.13u
MN192 (n191 n185 vss vss) n12 w=0.8u l=0.13u
MP193 (n191 n185 vdd vdd) p12 w=2.4u l=0.13u
MN196 (n194 done vss vss) n12 w=0.8u l=0.13u
MN197 (n194 fail vss vss) n12 w=0.8u l=0.13u
MP198 (n194 done n195 vdd) p12 w=4.8u l=0.13u
MP199 (n195 fail vdd vdd) p12 w=4.8u l=0.13u
MN201 (n200 n194 vss vss) n12 w=0.8u l=0.13u
MP202 (n200 n194 vdd vdd) p12 w=2.4u l=0.13u
MN204 (n203 n200 vss vss) n12 w=0.8u l=0.13u
MP205 (n203 n200 vdd vdd) p12 w=2.4u l=0.13u
MN208 (n206 n203 n207 vss) n12 w=1.6u l=0.13u
MN209 (n207 started vss vss) n12 w=1.6u l=0.13u
MP210 (n206 n203 vdd vdd) p12 w=2.4u l=0.13u
MP211 (n206 started vdd vdd) p12 w=2.4u l=0.13u
MN213 (n212 n206 vss vss) n12 w=0.8u l=0.13u
MP214 (n212 n206 vdd vdd) p12 w=2.4u l=0.13u
MN216 (n215 n212 vss vss) n12 w=0.8u l=0.13u
MP217 (n215 n212 vdd vdd) p12 w=2.4u l=0.13u
MN219 (n218 n215 vss vss) n12 w=0.8u l=0.13u
MP220 (n218 n215 vdd vdd) p12 w=2.4u l=0.13u
MN222 (n221 n218 vss vss) n12 w=0.8u l=0.13u
MP223 (n221 n218 vdd vdd) p12 w=2.4u l=0.13u
MN224 (active n221 vss vss) n12 w=0.8u l=0.13u
MP225 (active n221 vdd vdd) p12 w=2.4u l=0.13u
MN227 (delay226 fb vss vss) n12 w=0.8u l=0.13u
MP228 (delay226 fb vdd vdd) p12 w=2.4u l=0.13u
MN230 (delay229 delay226 vss vss) n12 w=0.8u l=0.13u
MP231 (delay229 delay226 vdd vdd) p12 w=2.4u l=0.13u
MN233 (delay232 delay229 vss vss) n12 w=0.8u l=0.13u
MP234 (delay232 delay229 vdd vdd) p12 w=2.4u l=0.13u
MN236 (delay235 delay232 vss vss) n12 w=0.8u l=0.13u
MP237 (delay235 delay232 vdd vdd) p12 w=2.4u l=0.13u
MN239 (delay238 delay235 vss vss) n12 w=0.8u l=0.13u
MP240 (delay238 delay235 vdd vdd) p12 w=2.4u l=0.13u
MN242 (delay241 delay238 vss vss) n12 w=0.8u l=0.13u
MP243 (delay241 delay238 vdd vdd) p12 w=2.4u l=0.13u
MN245 (n244 fb vss vss) n12 w=0.8u l=0.13u
MP246 (n244 fb vdd vdd) p12 w=2.4u l=0.13u
MN248 (n247 delay241 vss vss) n12 w=0.8u l=0.13u
MP249 (n247 delay241 vdd vdd) p12 w=2.4u l=0.13u
MN258 (n254 n244 n255 vss) n12 w=3.2u l=0.13u
MP259 (n254 n244 vdd vdd) p12 w=2.4u l=0.13u
MN260 (n255 n247 n256 vss) n12 w=3.2u l=0.13u
MP261 (n254 n247 vdd vdd) p12 w=2.4u l=0.13u
MN262 (n256 clk_highb253 n257 vss) n12 w=3.2u l=0.13u
MP263 (n254 clk_highb253 vdd vdd) p12 w=2.4u l=0.13u
MN264 (n257 n105 vss vss) n12 w=3.2u l=0.13u
MP265 (n254 n105 vdd vdd) p12 w=2.4u l=0.13u
MN270 (n266 fb n267 vss) n12 w=3.2u l=0.13u
MP271 (n266 fb vdd vdd) p12 w=2.4u l=0.13u
MN272 (n267 delay241 n268 vss) n12 w=3.2u l=0.13u
MP273 (n266 delay241 vdd vdd) p12 w=2.4u l=0.13u
MN274 (n268 clk_lowb251 n269 vss) n12 w=3.2u l=0.13u
MP275 (n266 clk_lowb251 vdd vdd) p12 w=2.4u l=0.13u
MN276 (n269 n105 vss vss) n12 w=3.2u l=0.13u
MP277 (n266 n105 vdd vdd) p12 w=2.4u l=0.13u
MN278 (clk_low250 n254 vss vss) n12 w=8u l=0.13u
MP279 (clk_low250 n254 vdd vdd) p12 w=24u l=0.13u
MN280 (clk_lowb251 clk_low250 vss vss) n12 w=8u l=0.13u
MP281 (clk_lowb251 clk_low250 vdd vdd) p12 w=24u l=0.13u
MN282 (clk_high252 n266 vss vss) n12 w=8u l=0.13u
MP283 (clk_high252 n266 vdd vdd) p12 w=24u l=0.13u
MN284 (clk_highb253 clk_high252 vss vss) n12 w=8u l=0.13u
MP285 (clk_highb253 clk_high252 vdd vdd) p12 w=24u l=0.13u
MN287 (count_run clk_low250 storage286 vss) n12 w=1.2u l=0.13u
MP288 (count_run clk_lowb251 storage286 vdd) p12 w=3.6u l=0.13u
MN289 (fb_clock_enable clk_high252 storage286 vss) n12 w=1.2u l=0.13u
MP290 (fb_clock_enable clk_highb253 storage286 vdd) p12 w=3.6u l=0.13u
MN291 (fb_clock_enableb storage286 vss vss) n12 w=0.5u l=0.13u
MP292 (fb_clock_enableb storage286 vdd vdd) p12 w=1.5u l=0.13u
MN293 (fb_clock_enable fb_clock_enableb vss vss) n12 w=0.5u l=0.13u
MP294 (fb_clock_enable fb_clock_enableb vdd vdd) p12 w=1.5u l=0.13u
MN295 (storage286 rst vss vss) n12 w=2u l=0.13u
MN298 (n296 fb n297 vss) n12 w=1.6u l=0.13u
MN299 (n297 fb_clock_enable vss vss) n12 w=1.6u l=0.13u
MP300 (n296 fb vdd vdd) p12 w=2.4u l=0.13u
MP301 (n296 fb_clock_enable vdd vdd) p12 w=2.4u l=0.13u
MN303 (n302 n296 vss vss) n12 w=0.8u l=0.13u
MP304 (n302 n296 vdd vdd) p12 w=2.4u l=0.13u
MN306 (n305 n302 vss vss) n12 w=0.8u l=0.13u
MP307 (n305 n302 vdd vdd) p12 w=2.4u l=0.13u
MN309 (n308 n305 vss vss) n12 w=0.8u l=0.13u
MP310 (n308 n305 vdd vdd) p12 w=2.4u l=0.13u
MN312 (n311 n308 vss vss) n12 w=0.8u l=0.13u
MP313 (n311 n308 vdd vdd) p12 w=2.4u l=0.13u
MN314 (counter_fb_clock n311 vss vss) n12 w=0.8u l=0.13u
MP315 (counter_fb_clock n311 vdd vdd) p12 w=2.4u l=0.13u
MN317 (delay316 n302 vss vss) n12 w=0.8u l=0.13u
MP318 (delay316 n302 vdd vdd) p12 w=2.4u l=0.13u
MN320 (delay319 delay316 vss vss) n12 w=0.8u l=0.13u
MP321 (delay319 delay316 vdd vdd) p12 w=2.4u l=0.13u
MN323 (delay322 delay319 vss vss) n12 w=0.8u l=0.13u
MP324 (delay322 delay319 vdd vdd) p12 w=2.4u l=0.13u
MN326 (delay325 delay322 vss vss) n12 w=0.8u l=0.13u
MP327 (delay325 delay322 vdd vdd) p12 w=2.4u l=0.13u
MN329 (delay328 delay325 vss vss) n12 w=0.8u l=0.13u
MP330 (delay328 delay325 vdd vdd) p12 w=2.4u l=0.13u
MN332 (delay331 delay328 vss vss) n12 w=0.8u l=0.13u
MP333 (delay331 delay328 vdd vdd) p12 w=2.4u l=0.13u
MN335 (n334 delay331 vss vss) n12 w=0.8u l=0.13u
MP336 (n334 delay331 vdd vdd) p12 w=2.4u l=0.13u
MN338 (n337 count_rst vss vss) n12 w=0.8u l=0.13u
MP339 (n337 count_rst vdd vdd) p12 w=2.4u l=0.13u
MN348 (n344 n305 n345 vss) n12 w=3.2u l=0.13u
MP349 (n344 n305 vdd vdd) p12 w=2.4u l=0.13u
MN350 (n345 n334 n346 vss) n12 w=3.2u l=0.13u
MP351 (n344 n334 vdd vdd) p12 w=2.4u l=0.13u
MN352 (n346 clk_highb343 n347 vss) n12 w=3.2u l=0.13u
MP353 (n344 clk_highb343 vdd vdd) p12 w=2.4u l=0.13u
MN354 (n347 n337 vss vss) n12 w=3.2u l=0.13u
MP355 (n344 n337 vdd vdd) p12 w=2.4u l=0.13u
MN360 (n356 n302 n357 vss) n12 w=3.2u l=0.13u
MP361 (n356 n302 vdd vdd) p12 w=2.4u l=0.13u
MN362 (n357 delay331 n358 vss) n12 w=3.2u l=0.13u
MP363 (n356 delay331 vdd vdd) p12 w=2.4u l=0.13u
MN364 (n358 clk_lowb341 n359 vss) n12 w=3.2u l=0.13u
MP365 (n356 clk_lowb341 vdd vdd) p12 w=2.4u l=0.13u
MN366 (n359 n337 vss vss) n12 w=3.2u l=0.13u
MP367 (n356 n337 vdd vdd) p12 w=2.4u l=0.13u
MN368 (clk_low340 n344 vss vss) n12 w=8u l=0.13u
MP369 (clk_low340 n344 vdd vdd) p12 w=24u l=0.13u
MN370 (clk_lowb341 clk_low340 vss vss) n12 w=8u l=0.13u
MP371 (clk_lowb341 clk_low340 vdd vdd) p12 w=24u l=0.13u
MN372 (clk_high342 n356 vss vss) n12 w=8u l=0.13u
MP373 (clk_high342 n356 vdd vdd) p12 w=24u l=0.13u
MN374 (clk_highb343 clk_high342 vss vss) n12 w=8u l=0.13u
MP375 (clk_highb343 clk_high342 vdd vdd) p12 w=24u l=0.13u
MN380 (vdd clk_low340 storage379 vss) n12 w=1.2u l=0.13u
MP381 (vdd clk_lowb341 storage379 vdd) p12 w=3.6u l=0.13u
MN382 (qm376 clk_high342 storage379 vss) n12 w=1.2u l=0.13u
MP383 (qm376 clk_highb343 storage379 vdd) p12 w=3.6u l=0.13u
MN384 (qmb377 storage379 vss vss) n12 w=0.5u l=0.13u
MP385 (qmb377 storage379 vdd vdd) p12 w=1.5u l=0.13u
MN386 (qm376 qmb377 vss vss) n12 w=0.5u l=0.13u
MP387 (qm376 qmb377 vdd vdd) p12 w=1.5u l=0.13u
MN388 (storage379 count_rst vss vss) n12 w=2u l=0.13u
MN390 (qm376 clk_high342 storage389 vss) n12 w=1.2u l=0.13u
MP391 (qm376 clk_highb343 storage389 vdd) p12 w=3.6u l=0.13u
MN392 (seen clk_low340 storage389 vss) n12 w=1.2u l=0.13u
MP393 (seen clk_lowb341 storage389 vdd) p12 w=3.6u l=0.13u
MN394 (qb378 storage389 vss vss) n12 w=0.5u l=0.13u
MP395 (qb378 storage389 vdd vdd) p12 w=1.5u l=0.13u
MN396 (seen qb378 vss vss) n12 w=0.5u l=0.13u
MP397 (seen qb378 vdd vdd) p12 w=1.5u l=0.13u
MN398 (storage389 count_rst vss vss) n12 w=2u l=0.13u
MN400 (n399 seen vss vss) n12 w=0.8u l=0.13u
MP401 (n399 seen vdd vdd) p12 w=2.4u l=0.13u
MN404 (n402 n399 n403 vss) n12 w=1.6u l=0.13u
MN405 (n403 ref vss vss) n12 w=1.6u l=0.13u
MP406 (n402 n399 vdd vdd) p12 w=2.4u l=0.13u
MP407 (n402 ref vdd vdd) p12 w=2.4u l=0.13u
MN409 (n408 n399 vss vss) n12 w=0.8u l=0.13u
MP410 (n408 n399 vdd vdd) p12 w=2.4u l=0.13u
MN413 (n411 n408 n412 vss) n12 w=1.6u l=0.13u
MN414 (n412 phase vss vss) n12 w=1.6u l=0.13u
MP415 (n411 n408 vdd vdd) p12 w=2.4u l=0.13u
MP416 (n411 phase vdd vdd) p12 w=2.4u l=0.13u
MN419 (n417 n402 n418 vss) n12 w=1.6u l=0.13u
MN420 (n418 n411 vss vss) n12 w=1.6u l=0.13u
MP421 (n417 n402 vdd vdd) p12 w=2.4u l=0.13u
MP422 (n417 n411 vdd vdd) p12 w=2.4u l=0.13u
MN427 (n417 clk_low340 storage426 vss) n12 w=1.2u l=0.13u
MP428 (n417 clk_lowb341 storage426 vdd) p12 w=3.6u l=0.13u
MN429 (qm423 clk_high342 storage426 vss) n12 w=1.2u l=0.13u
MP430 (qm423 clk_highb343 storage426 vdd) p12 w=3.6u l=0.13u
MN431 (qmb424 storage426 vss vss) n12 w=0.5u l=0.13u
MP432 (qmb424 storage426 vdd vdd) p12 w=1.5u l=0.13u
MN433 (qm423 qmb424 vss vss) n12 w=0.5u l=0.13u
MP434 (qm423 qmb424 vdd vdd) p12 w=1.5u l=0.13u
MN435 (storage426 count_rst vss vss) n12 w=2u l=0.13u
MN437 (qm423 clk_high342 storage436 vss) n12 w=1.2u l=0.13u
MP438 (qm423 clk_highb343 storage436 vdd) p12 w=3.6u l=0.13u
MN439 (phase clk_low340 storage436 vss) n12 w=1.2u l=0.13u
MP440 (phase clk_lowb341 storage436 vdd) p12 w=3.6u l=0.13u
MN441 (qb425 storage436 vss vss) n12 w=0.5u l=0.13u
MP442 (qb425 storage436 vdd vdd) p12 w=1.5u l=0.13u
MN443 (phase qb425 vss vss) n12 w=0.5u l=0.13u
MP444 (phase qb425 vdd vdd) p12 w=1.5u l=0.13u
MN445 (storage436 count_rst vss vss) n12 w=2u l=0.13u
MN447 (delay446 seen vss vss) n12 w=0.8u l=0.13u
MP448 (delay446 seen vdd vdd) p12 w=2.4u l=0.13u
MN450 (delay449 delay446 vss vss) n12 w=0.8u l=0.13u
MP451 (delay449 delay446 vdd vdd) p12 w=2.4u l=0.13u
MN453 (delay452 delay449 vss vss) n12 w=0.8u l=0.13u
MP454 (delay452 delay449 vdd vdd) p12 w=2.4u l=0.13u
MN456 (delay455 delay452 vss vss) n12 w=0.8u l=0.13u
MP457 (delay455 delay452 vdd vdd) p12 w=2.4u l=0.13u
MN459 (delay458 delay455 vss vss) n12 w=0.8u l=0.13u
MP460 (delay458 delay455 vdd vdd) p12 w=2.4u l=0.13u
MN462 (delay461 delay458 vss vss) n12 w=0.8u l=0.13u
MP463 (delay461 delay458 vdd vdd) p12 w=2.4u l=0.13u
MN465 (delay464 delay461 vss vss) n12 w=0.8u l=0.13u
MP466 (delay464 delay461 vdd vdd) p12 w=2.4u l=0.13u
MN468 (delay467 delay464 vss vss) n12 w=0.8u l=0.13u
MP469 (delay467 delay464 vdd vdd) p12 w=2.4u l=0.13u
MN471 (delay470 delay467 vss vss) n12 w=0.8u l=0.13u
MP472 (delay470 delay467 vdd vdd) p12 w=2.4u l=0.13u
MN474 (delay473 delay470 vss vss) n12 w=0.8u l=0.13u
MP475 (delay473 delay470 vdd vdd) p12 w=2.4u l=0.13u
MN477 (delay476 delay473 vss vss) n12 w=0.8u l=0.13u
MP478 (delay476 delay473 vdd vdd) p12 w=2.4u l=0.13u
MN480 (delay479 delay476 vss vss) n12 w=0.8u l=0.13u
MP481 (delay479 delay476 vdd vdd) p12 w=2.4u l=0.13u
MN483 (delay482 delay479 vss vss) n12 w=0.8u l=0.13u
MP484 (delay482 delay479 vdd vdd) p12 w=2.4u l=0.13u
MN486 (delay485 delay482 vss vss) n12 w=0.8u l=0.13u
MP487 (delay485 delay482 vdd vdd) p12 w=2.4u l=0.13u
MN489 (delay488 delay485 vss vss) n12 w=0.8u l=0.13u
MP490 (delay488 delay485 vdd vdd) p12 w=2.4u l=0.13u
MN492 (delay491 delay488 vss vss) n12 w=0.8u l=0.13u
MP493 (delay491 delay488 vdd vdd) p12 w=2.4u l=0.13u
MN495 (n494 delay491 vss vss) n12 w=0.8u l=0.13u
MP496 (n494 delay491 vdd vdd) p12 w=2.4u l=0.13u
MN499 (n497 count_rst vss vss) n12 w=0.8u l=0.13u
MN500 (n497 n494 vss vss) n12 w=0.8u l=0.13u
MP501 (n497 count_rst n498 vdd) p12 w=4.8u l=0.13u
MP502 (n498 n494 vdd vdd) p12 w=4.8u l=0.13u
MN504 (n503 n497 vss vss) n12 w=0.8u l=0.13u
MP505 (n503 n497 vdd vdd) p12 w=2.4u l=0.13u
MN507 (n506 n503 vss vss) n12 w=0.8u l=0.13u
MP508 (n506 n503 vdd vdd) p12 w=2.4u l=0.13u
MN510 (n509 n506 vss vss) n12 w=0.8u l=0.13u
MP511 (n509 n506 vdd vdd) p12 w=2.4u l=0.13u
MN513 (n512 n509 vss vss) n12 w=0.8u l=0.13u
MP514 (n512 n509 vdd vdd) p12 w=2.4u l=0.13u
MN515 (reference_count_rst n512 vss vss) n12 w=0.8u l=0.13u
MP516 (reference_count_rst n512 vdd vdd) p12 w=2.4u l=0.13u
MN518 (n517 ref vss vss) n12 w=0.8u l=0.13u
MP519 (n517 ref vdd vdd) p12 w=2.4u l=0.13u
MN522 (n520 phase n521 vss) n12 w=1.6u l=0.13u
MN523 (n521 ref vss vss) n12 w=1.6u l=0.13u
MP524 (n520 phase vdd vdd) p12 w=2.4u l=0.13u
MP525 (n520 ref vdd vdd) p12 w=2.4u l=0.13u
MN527 (n526 phase vss vss) n12 w=0.8u l=0.13u
MP528 (n526 phase vdd vdd) p12 w=2.4u l=0.13u
MN531 (n529 n517 n530 vss) n12 w=1.6u l=0.13u
MN532 (n530 n526 vss vss) n12 w=1.6u l=0.13u
MP533 (n529 n517 vdd vdd) p12 w=2.4u l=0.13u
MP534 (n529 n526 vdd vdd) p12 w=2.4u l=0.13u
MN537 (n535 n520 n536 vss) n12 w=1.6u l=0.13u
MN538 (n536 n529 vss vss) n12 w=1.6u l=0.13u
MP539 (n535 n520 vdd vdd) p12 w=2.4u l=0.13u
MP540 (n535 n529 vdd vdd) p12 w=2.4u l=0.13u
MN543 (n541 n517 n542 vss) n12 w=1.6u l=0.13u
MN544 (n542 phase vss vss) n12 w=1.6u l=0.13u
MP545 (n541 n517 vdd vdd) p12 w=2.4u l=0.13u
MP546 (n541 phase vdd vdd) p12 w=2.4u l=0.13u
MN549 (n547 n526 n548 vss) n12 w=1.6u l=0.13u
MN550 (n548 ref vss vss) n12 w=1.6u l=0.13u
MP551 (n547 n526 vdd vdd) p12 w=2.4u l=0.13u
MP552 (n547 ref vdd vdd) p12 w=2.4u l=0.13u
MN555 (n553 n541 n554 vss) n12 w=1.6u l=0.13u
MN556 (n554 n547 vss vss) n12 w=1.6u l=0.13u
MP557 (n553 n541 vdd vdd) p12 w=2.4u l=0.13u
MP558 (n553 n547 vdd vdd) p12 w=2.4u l=0.13u
MN560 (n559 n535 vss vss) n12 w=0.8u l=0.13u
MP561 (n559 n535 vdd vdd) p12 w=2.4u l=0.13u
MN563 (n562 n559 vss vss) n12 w=0.8u l=0.13u
MP564 (n562 n559 vdd vdd) p12 w=2.4u l=0.13u
MN566 (n565 n562 vss vss) n12 w=0.8u l=0.13u
MP567 (n565 n562 vdd vdd) p12 w=2.4u l=0.13u
MN568 (lead_clock n565 vss vss) n12 w=0.8u l=0.13u
MP569 (lead_clock n565 vdd vdd) p12 w=2.4u l=0.13u
MN571 (n570 n553 vss vss) n12 w=0.8u l=0.13u
MP572 (n570 n553 vdd vdd) p12 w=2.4u l=0.13u
MN574 (n573 n570 vss vss) n12 w=0.8u l=0.13u
MP575 (n573 n570 vdd vdd) p12 w=2.4u l=0.13u
MN577 (n576 n573 vss vss) n12 w=0.8u l=0.13u
MP578 (n576 n573 vdd vdd) p12 w=2.4u l=0.13u
MN579 (lag_clock n576 vss vss) n12 w=0.8u l=0.13u
MP580 (lag_clock n576 vdd vdd) p12 w=2.4u l=0.13u
MN583 (n581 count_run n582 vss) n12 w=1.6u l=0.13u
MN584 (n582 n535 vss vss) n12 w=1.6u l=0.13u
MP585 (n581 count_run vdd vdd) p12 w=2.4u l=0.13u
MP586 (n581 n535 vdd vdd) p12 w=2.4u l=0.13u
MN588 (n587 n581 vss vss) n12 w=0.8u l=0.13u
MP589 (n587 n581 vdd vdd) p12 w=2.4u l=0.13u
MN592 (n590 count_run n591 vss) n12 w=1.6u l=0.13u
MN593 (n591 n553 vss vss) n12 w=1.6u l=0.13u
MP594 (n590 count_run vdd vdd) p12 w=2.4u l=0.13u
MP595 (n590 n553 vdd vdd) p12 w=2.4u l=0.13u
MN597 (n596 n590 vss vss) n12 w=0.8u l=0.13u
MP598 (n596 n590 vdd vdd) p12 w=2.4u l=0.13u
MN601 (n599 lead_g6 n600 vss) n12 w=1.6u l=0.13u
MN602 (n600 lead_g7 vss vss) n12 w=1.6u l=0.13u
MP603 (n599 lead_g6 vdd vdd) p12 w=2.4u l=0.13u
MP604 (n599 lead_g7 vdd vdd) p12 w=2.4u l=0.13u
MN607 (n605 lead_g6 n606 vss) n12 w=1.6u l=0.13u
MN608 (n606 n599 vss vss) n12 w=1.6u l=0.13u
MP609 (n605 lead_g6 vdd vdd) p12 w=2.4u l=0.13u
MP610 (n605 n599 vdd vdd) p12 w=2.4u l=0.13u
MN613 (n611 lead_g7 n612 vss) n12 w=1.6u l=0.13u
MN614 (n612 n599 vss vss) n12 w=1.6u l=0.13u
MP615 (n611 lead_g7 vdd vdd) p12 w=2.4u l=0.13u
MP616 (n611 n599 vdd vdd) p12 w=2.4u l=0.13u
MN619 (n617 n605 n618 vss) n12 w=1.6u l=0.13u
MN620 (n618 n611 vss vss) n12 w=1.6u l=0.13u
MP621 (n617 n605 vdd vdd) p12 w=2.4u l=0.13u
MP622 (n617 n611 vdd vdd) p12 w=2.4u l=0.13u
MN625 (n623 lead_g5 n624 vss) n12 w=1.6u l=0.13u
MN626 (n624 n617 vss vss) n12 w=1.6u l=0.13u
MP627 (n623 lead_g5 vdd vdd) p12 w=2.4u l=0.13u
MP628 (n623 n617 vdd vdd) p12 w=2.4u l=0.13u
MN631 (n629 lead_g5 n630 vss) n12 w=1.6u l=0.13u
MN632 (n630 n623 vss vss) n12 w=1.6u l=0.13u
MP633 (n629 lead_g5 vdd vdd) p12 w=2.4u l=0.13u
MP634 (n629 n623 vdd vdd) p12 w=2.4u l=0.13u
MN637 (n635 n617 n636 vss) n12 w=1.6u l=0.13u
MN638 (n636 n623 vss vss) n12 w=1.6u l=0.13u
MP639 (n635 n617 vdd vdd) p12 w=2.4u l=0.13u
MP640 (n635 n623 vdd vdd) p12 w=2.4u l=0.13u
MN643 (n641 n629 n642 vss) n12 w=1.6u l=0.13u
MN644 (n642 n635 vss vss) n12 w=1.6u l=0.13u
MP645 (n641 n629 vdd vdd) p12 w=2.4u l=0.13u
MP646 (n641 n635 vdd vdd) p12 w=2.4u l=0.13u
MN649 (n647 lead_g4 n648 vss) n12 w=1.6u l=0.13u
MN650 (n648 n641 vss vss) n12 w=1.6u l=0.13u
MP651 (n647 lead_g4 vdd vdd) p12 w=2.4u l=0.13u
MP652 (n647 n641 vdd vdd) p12 w=2.4u l=0.13u
MN655 (n653 lead_g4 n654 vss) n12 w=1.6u l=0.13u
MN656 (n654 n647 vss vss) n12 w=1.6u l=0.13u
MP657 (n653 lead_g4 vdd vdd) p12 w=2.4u l=0.13u
MP658 (n653 n647 vdd vdd) p12 w=2.4u l=0.13u
MN661 (n659 n641 n660 vss) n12 w=1.6u l=0.13u
MN662 (n660 n647 vss vss) n12 w=1.6u l=0.13u
MP663 (n659 n641 vdd vdd) p12 w=2.4u l=0.13u
MP664 (n659 n647 vdd vdd) p12 w=2.4u l=0.13u
MN667 (n665 n653 n666 vss) n12 w=1.6u l=0.13u
MN668 (n666 n659 vss vss) n12 w=1.6u l=0.13u
MP669 (n665 n653 vdd vdd) p12 w=2.4u l=0.13u
MP670 (n665 n659 vdd vdd) p12 w=2.4u l=0.13u
MN673 (n671 lead_g3 n672 vss) n12 w=1.6u l=0.13u
MN674 (n672 n665 vss vss) n12 w=1.6u l=0.13u
MP675 (n671 lead_g3 vdd vdd) p12 w=2.4u l=0.13u
MP676 (n671 n665 vdd vdd) p12 w=2.4u l=0.13u
MN679 (n677 lead_g3 n678 vss) n12 w=1.6u l=0.13u
MN680 (n678 n671 vss vss) n12 w=1.6u l=0.13u
MP681 (n677 lead_g3 vdd vdd) p12 w=2.4u l=0.13u
MP682 (n677 n671 vdd vdd) p12 w=2.4u l=0.13u
MN685 (n683 n665 n684 vss) n12 w=1.6u l=0.13u
MN686 (n684 n671 vss vss) n12 w=1.6u l=0.13u
MP687 (n683 n665 vdd vdd) p12 w=2.4u l=0.13u
MP688 (n683 n671 vdd vdd) p12 w=2.4u l=0.13u
MN691 (n689 n677 n690 vss) n12 w=1.6u l=0.13u
MN692 (n690 n683 vss vss) n12 w=1.6u l=0.13u
MP693 (n689 n677 vdd vdd) p12 w=2.4u l=0.13u
MP694 (n689 n683 vdd vdd) p12 w=2.4u l=0.13u
MN697 (n695 lead_g2 n696 vss) n12 w=1.6u l=0.13u
MN698 (n696 n689 vss vss) n12 w=1.6u l=0.13u
MP699 (n695 lead_g2 vdd vdd) p12 w=2.4u l=0.13u
MP700 (n695 n689 vdd vdd) p12 w=2.4u l=0.13u
MN703 (n701 lead_g2 n702 vss) n12 w=1.6u l=0.13u
MN704 (n702 n695 vss vss) n12 w=1.6u l=0.13u
MP705 (n701 lead_g2 vdd vdd) p12 w=2.4u l=0.13u
MP706 (n701 n695 vdd vdd) p12 w=2.4u l=0.13u
MN709 (n707 n689 n708 vss) n12 w=1.6u l=0.13u
MN710 (n708 n695 vss vss) n12 w=1.6u l=0.13u
MP711 (n707 n689 vdd vdd) p12 w=2.4u l=0.13u
MP712 (n707 n695 vdd vdd) p12 w=2.4u l=0.13u
MN715 (n713 n701 n714 vss) n12 w=1.6u l=0.13u
MN716 (n714 n707 vss vss) n12 w=1.6u l=0.13u
MP717 (n713 n701 vdd vdd) p12 w=2.4u l=0.13u
MP718 (n713 n707 vdd vdd) p12 w=2.4u l=0.13u
MN721 (n719 lead_g1 n720 vss) n12 w=1.6u l=0.13u
MN722 (n720 n713 vss vss) n12 w=1.6u l=0.13u
MP723 (n719 lead_g1 vdd vdd) p12 w=2.4u l=0.13u
MP724 (n719 n713 vdd vdd) p12 w=2.4u l=0.13u
MN727 (n725 lead_g1 n726 vss) n12 w=1.6u l=0.13u
MN728 (n726 n719 vss vss) n12 w=1.6u l=0.13u
MP729 (n725 lead_g1 vdd vdd) p12 w=2.4u l=0.13u
MP730 (n725 n719 vdd vdd) p12 w=2.4u l=0.13u
MN733 (n731 n713 n732 vss) n12 w=1.6u l=0.13u
MN734 (n732 n719 vss vss) n12 w=1.6u l=0.13u
MP735 (n731 n713 vdd vdd) p12 w=2.4u l=0.13u
MP736 (n731 n719 vdd vdd) p12 w=2.4u l=0.13u
MN739 (n737 n725 n738 vss) n12 w=1.6u l=0.13u
MN740 (n738 n731 vss vss) n12 w=1.6u l=0.13u
MP741 (n737 n725 vdd vdd) p12 w=2.4u l=0.13u
MP742 (n737 n731 vdd vdd) p12 w=2.4u l=0.13u
MN745 (n743 lead_g0 n744 vss) n12 w=1.6u l=0.13u
MN746 (n744 n737 vss vss) n12 w=1.6u l=0.13u
MP747 (n743 lead_g0 vdd vdd) p12 w=2.4u l=0.13u
MP748 (n743 n737 vdd vdd) p12 w=2.4u l=0.13u
MN751 (n749 lead_g0 n750 vss) n12 w=1.6u l=0.13u
MN752 (n750 n743 vss vss) n12 w=1.6u l=0.13u
MP753 (n749 lead_g0 vdd vdd) p12 w=2.4u l=0.13u
MP754 (n749 n743 vdd vdd) p12 w=2.4u l=0.13u
MN757 (n755 n737 n756 vss) n12 w=1.6u l=0.13u
MN758 (n756 n743 vss vss) n12 w=1.6u l=0.13u
MP759 (n755 n737 vdd vdd) p12 w=2.4u l=0.13u
MP760 (n755 n743 vdd vdd) p12 w=2.4u l=0.13u
MN763 (n761 n749 n762 vss) n12 w=1.6u l=0.13u
MN764 (n762 n755 vss vss) n12 w=1.6u l=0.13u
MP765 (n761 n749 vdd vdd) p12 w=2.4u l=0.13u
MP766 (n761 n755 vdd vdd) p12 w=2.4u l=0.13u
MN768 (n767 n761 vss vss) n12 w=0.8u l=0.13u
MP769 (n767 n761 vdd vdd) p12 w=2.4u l=0.13u
MN772 (n770 n737 n771 vss) n12 w=1.6u l=0.13u
MN773 (n771 n761 vss vss) n12 w=1.6u l=0.13u
MP774 (n770 n737 vdd vdd) p12 w=2.4u l=0.13u
MP775 (n770 n761 vdd vdd) p12 w=2.4u l=0.13u
MN778 (n776 n737 n777 vss) n12 w=1.6u l=0.13u
MN779 (n777 n770 vss vss) n12 w=1.6u l=0.13u
MP780 (n776 n737 vdd vdd) p12 w=2.4u l=0.13u
MP781 (n776 n770 vdd vdd) p12 w=2.4u l=0.13u
MN784 (n782 n761 n783 vss) n12 w=1.6u l=0.13u
MN785 (n783 n770 vss vss) n12 w=1.6u l=0.13u
MP786 (n782 n761 vdd vdd) p12 w=2.4u l=0.13u
MP787 (n782 n770 vdd vdd) p12 w=2.4u l=0.13u
MN790 (n788 n776 n789 vss) n12 w=1.6u l=0.13u
MN791 (n789 n782 vss vss) n12 w=1.6u l=0.13u
MP792 (n788 n776 vdd vdd) p12 w=2.4u l=0.13u
MP793 (n788 n782 vdd vdd) p12 w=2.4u l=0.13u
MN795 (n794 n770 vss vss) n12 w=0.8u l=0.13u
MP796 (n794 n770 vdd vdd) p12 w=2.4u l=0.13u
MN799 (n797 n713 n798 vss) n12 w=1.6u l=0.13u
MN800 (n798 n794 vss vss) n12 w=1.6u l=0.13u
MP801 (n797 n713 vdd vdd) p12 w=2.4u l=0.13u
MP802 (n797 n794 vdd vdd) p12 w=2.4u l=0.13u
MN805 (n803 n713 n804 vss) n12 w=1.6u l=0.13u
MN806 (n804 n797 vss vss) n12 w=1.6u l=0.13u
MP807 (n803 n713 vdd vdd) p12 w=2.4u l=0.13u
MP808 (n803 n797 vdd vdd) p12 w=2.4u l=0.13u
MN811 (n809 n794 n810 vss) n12 w=1.6u l=0.13u
MN812 (n810 n797 vss vss) n12 w=1.6u l=0.13u
MP813 (n809 n794 vdd vdd) p12 w=2.4u l=0.13u
MP814 (n809 n797 vdd vdd) p12 w=2.4u l=0.13u
MN817 (n815 n803 n816 vss) n12 w=1.6u l=0.13u
MN818 (n816 n809 vss vss) n12 w=1.6u l=0.13u
MP819 (n815 n803 vdd vdd) p12 w=2.4u l=0.13u
MP820 (n815 n809 vdd vdd) p12 w=2.4u l=0.13u
MN822 (n821 n797 vss vss) n12 w=0.8u l=0.13u
MP823 (n821 n797 vdd vdd) p12 w=2.4u l=0.13u
MN826 (n824 n689 n825 vss) n12 w=1.6u l=0.13u
MN827 (n825 n821 vss vss) n12 w=1.6u l=0.13u
MP828 (n824 n689 vdd vdd) p12 w=2.4u l=0.13u
MP829 (n824 n821 vdd vdd) p12 w=2.4u l=0.13u
MN832 (n830 n689 n831 vss) n12 w=1.6u l=0.13u
MN833 (n831 n824 vss vss) n12 w=1.6u l=0.13u
MP834 (n830 n689 vdd vdd) p12 w=2.4u l=0.13u
MP835 (n830 n824 vdd vdd) p12 w=2.4u l=0.13u
MN838 (n836 n821 n837 vss) n12 w=1.6u l=0.13u
MN839 (n837 n824 vss vss) n12 w=1.6u l=0.13u
MP840 (n836 n821 vdd vdd) p12 w=2.4u l=0.13u
MP841 (n836 n824 vdd vdd) p12 w=2.4u l=0.13u
MN844 (n842 n830 n843 vss) n12 w=1.6u l=0.13u
MN845 (n843 n836 vss vss) n12 w=1.6u l=0.13u
MP846 (n842 n830 vdd vdd) p12 w=2.4u l=0.13u
MP847 (n842 n836 vdd vdd) p12 w=2.4u l=0.13u
MN849 (n848 n824 vss vss) n12 w=0.8u l=0.13u
MP850 (n848 n824 vdd vdd) p12 w=2.4u l=0.13u
MN853 (n851 n665 n852 vss) n12 w=1.6u l=0.13u
MN854 (n852 n848 vss vss) n12 w=1.6u l=0.13u
MP855 (n851 n665 vdd vdd) p12 w=2.4u l=0.13u
MP856 (n851 n848 vdd vdd) p12 w=2.4u l=0.13u
MN859 (n857 n665 n858 vss) n12 w=1.6u l=0.13u
MN860 (n858 n851 vss vss) n12 w=1.6u l=0.13u
MP861 (n857 n665 vdd vdd) p12 w=2.4u l=0.13u
MP862 (n857 n851 vdd vdd) p12 w=2.4u l=0.13u
MN865 (n863 n848 n864 vss) n12 w=1.6u l=0.13u
MN866 (n864 n851 vss vss) n12 w=1.6u l=0.13u
MP867 (n863 n848 vdd vdd) p12 w=2.4u l=0.13u
MP868 (n863 n851 vdd vdd) p12 w=2.4u l=0.13u
MN871 (n869 n857 n870 vss) n12 w=1.6u l=0.13u
MN872 (n870 n863 vss vss) n12 w=1.6u l=0.13u
MP873 (n869 n857 vdd vdd) p12 w=2.4u l=0.13u
MP874 (n869 n863 vdd vdd) p12 w=2.4u l=0.13u
MN876 (n875 n851 vss vss) n12 w=0.8u l=0.13u
MP877 (n875 n851 vdd vdd) p12 w=2.4u l=0.13u
MN880 (n878 n641 n879 vss) n12 w=1.6u l=0.13u
MN881 (n879 n875 vss vss) n12 w=1.6u l=0.13u
MP882 (n878 n641 vdd vdd) p12 w=2.4u l=0.13u
MP883 (n878 n875 vdd vdd) p12 w=2.4u l=0.13u
MN886 (n884 n641 n885 vss) n12 w=1.6u l=0.13u
MN887 (n885 n878 vss vss) n12 w=1.6u l=0.13u
MP888 (n884 n641 vdd vdd) p12 w=2.4u l=0.13u
MP889 (n884 n878 vdd vdd) p12 w=2.4u l=0.13u
MN892 (n890 n875 n891 vss) n12 w=1.6u l=0.13u
MN893 (n891 n878 vss vss) n12 w=1.6u l=0.13u
MP894 (n890 n875 vdd vdd) p12 w=2.4u l=0.13u
MP895 (n890 n878 vdd vdd) p12 w=2.4u l=0.13u
MN898 (n896 n884 n897 vss) n12 w=1.6u l=0.13u
MN899 (n897 n890 vss vss) n12 w=1.6u l=0.13u
MP900 (n896 n884 vdd vdd) p12 w=2.4u l=0.13u
MP901 (n896 n890 vdd vdd) p12 w=2.4u l=0.13u
MN903 (n902 n878 vss vss) n12 w=0.8u l=0.13u
MP904 (n902 n878 vdd vdd) p12 w=2.4u l=0.13u
MN907 (n905 n617 n906 vss) n12 w=1.6u l=0.13u
MN908 (n906 n902 vss vss) n12 w=1.6u l=0.13u
MP909 (n905 n617 vdd vdd) p12 w=2.4u l=0.13u
MP910 (n905 n902 vdd vdd) p12 w=2.4u l=0.13u
MN913 (n911 n617 n912 vss) n12 w=1.6u l=0.13u
MN914 (n912 n905 vss vss) n12 w=1.6u l=0.13u
MP915 (n911 n617 vdd vdd) p12 w=2.4u l=0.13u
MP916 (n911 n905 vdd vdd) p12 w=2.4u l=0.13u
MN919 (n917 n902 n918 vss) n12 w=1.6u l=0.13u
MN920 (n918 n905 vss vss) n12 w=1.6u l=0.13u
MP921 (n917 n902 vdd vdd) p12 w=2.4u l=0.13u
MP922 (n917 n905 vdd vdd) p12 w=2.4u l=0.13u
MN925 (n923 n911 n924 vss) n12 w=1.6u l=0.13u
MN926 (n924 n917 vss vss) n12 w=1.6u l=0.13u
MP927 (n923 n911 vdd vdd) p12 w=2.4u l=0.13u
MP928 (n923 n917 vdd vdd) p12 w=2.4u l=0.13u
MN930 (n929 n905 vss vss) n12 w=0.8u l=0.13u
MP931 (n929 n905 vdd vdd) p12 w=2.4u l=0.13u
MN934 (n932 lead_g7 n933 vss) n12 w=1.6u l=0.13u
MN935 (n933 n929 vss vss) n12 w=1.6u l=0.13u
MP936 (n932 lead_g7 vdd vdd) p12 w=2.4u l=0.13u
MP937 (n932 n929 vdd vdd) p12 w=2.4u l=0.13u
MN940 (n938 lead_g7 n939 vss) n12 w=1.6u l=0.13u
MN941 (n939 n932 vss vss) n12 w=1.6u l=0.13u
MP942 (n938 lead_g7 vdd vdd) p12 w=2.4u l=0.13u
MP943 (n938 n932 vdd vdd) p12 w=2.4u l=0.13u
MN946 (n944 n929 n945 vss) n12 w=1.6u l=0.13u
MN947 (n945 n932 vss vss) n12 w=1.6u l=0.13u
MP948 (n944 n929 vdd vdd) p12 w=2.4u l=0.13u
MP949 (n944 n932 vdd vdd) p12 w=2.4u l=0.13u
MN952 (n950 n938 n951 vss) n12 w=1.6u l=0.13u
MN953 (n951 n944 vss vss) n12 w=1.6u l=0.13u
MP954 (n950 n938 vdd vdd) p12 w=2.4u l=0.13u
MP955 (n950 n944 vdd vdd) p12 w=2.4u l=0.13u
MN957 (n956 n932 vss vss) n12 w=0.8u l=0.13u
MP958 (n956 n932 vdd vdd) p12 w=2.4u l=0.13u
MN961 (n959 n767 n960 vss) n12 w=1.6u l=0.13u
MN962 (n960 n788 vss vss) n12 w=1.6u l=0.13u
MP963 (n959 n767 vdd vdd) p12 w=2.4u l=0.13u
MP964 (n959 n788 vdd vdd) p12 w=2.4u l=0.13u
MN967 (n965 n767 n966 vss) n12 w=1.6u l=0.13u
MN968 (n966 n959 vss vss) n12 w=1.6u l=0.13u
MP969 (n965 n767 vdd vdd) p12 w=2.4u l=0.13u
MP970 (n965 n959 vdd vdd) p12 w=2.4u l=0.13u
MN973 (n971 n788 n972 vss) n12 w=1.6u l=0.13u
MN974 (n972 n959 vss vss) n12 w=1.6u l=0.13u
MP975 (n971 n788 vdd vdd) p12 w=2.4u l=0.13u
MP976 (n971 n959 vdd vdd) p12 w=2.4u l=0.13u
MN979 (n977 n965 n978 vss) n12 w=1.6u l=0.13u
MN980 (n978 n971 vss vss) n12 w=1.6u l=0.13u
MP981 (n977 n965 vdd vdd) p12 w=2.4u l=0.13u
MP982 (n977 n971 vdd vdd) p12 w=2.4u l=0.13u
MN985 (n983 n788 n984 vss) n12 w=1.6u l=0.13u
MN986 (n984 n815 vss vss) n12 w=1.6u l=0.13u
MP987 (n983 n788 vdd vdd) p12 w=2.4u l=0.13u
MP988 (n983 n815 vdd vdd) p12 w=2.4u l=0.13u
MN991 (n989 n788 n990 vss) n12 w=1.6u l=0.13u
MN992 (n990 n983 vss vss) n12 w=1.6u l=0.13u
MP993 (n989 n788 vdd vdd) p12 w=2.4u l=0.13u
MP994 (n989 n983 vdd vdd) p12 w=2.4u l=0.13u
MN997 (n995 n815 n996 vss) n12 w=1.6u l=0.13u
MN998 (n996 n983 vss vss) n12 w=1.6u l=0.13u
MP999 (n995 n815 vdd vdd) p12 w=2.4u l=0.13u
MP1000 (n995 n983 vdd vdd) p12 w=2.4u l=0.13u
MN1003 (n1001 n989 n1002 vss) n12 w=1.6u l=0.13u
MN1004 (n1002 n995 vss vss) n12 w=1.6u l=0.13u
MP1005 (n1001 n989 vdd vdd) p12 w=2.4u l=0.13u
MP1006 (n1001 n995 vdd vdd) p12 w=2.4u l=0.13u
MN1009 (n1007 n815 n1008 vss) n12 w=1.6u l=0.13u
MN1010 (n1008 n842 vss vss) n12 w=1.6u l=0.13u
MP1011 (n1007 n815 vdd vdd) p12 w=2.4u l=0.13u
MP1012 (n1007 n842 vdd vdd) p12 w=2.4u l=0.13u
MN1015 (n1013 n1007 n1014 vss) n12 w=1.6u l=0.13u
MN1016 (n1014 n815 vss vss) n12 w=1.6u l=0.13u
MP1017 (n1013 n1007 vdd vdd) p12 w=2.4u l=0.13u
MP1018 (n1013 n815 vdd vdd) p12 w=2.4u l=0.13u
MN1021 (n1019 n1007 n1020 vss) n12 w=1.6u l=0.13u
MN1022 (n1020 n842 vss vss) n12 w=1.6u l=0.13u
MP1023 (n1019 n1007 vdd vdd) p12 w=2.4u l=0.13u
MP1024 (n1019 n842 vdd vdd) p12 w=2.4u l=0.13u
MN1027 (n1025 n1013 n1026 vss) n12 w=1.6u l=0.13u
MN1028 (n1026 n1019 vss vss) n12 w=1.6u l=0.13u
MP1029 (n1025 n1013 vdd vdd) p12 w=2.4u l=0.13u
MP1030 (n1025 n1019 vdd vdd) p12 w=2.4u l=0.13u
MN1033 (n1031 n842 n1032 vss) n12 w=1.6u l=0.13u
MN1034 (n1032 n869 vss vss) n12 w=1.6u l=0.13u
MP1035 (n1031 n842 vdd vdd) p12 w=2.4u l=0.13u
MP1036 (n1031 n869 vdd vdd) p12 w=2.4u l=0.13u
MN1039 (n1037 n1031 n1038 vss) n12 w=1.6u l=0.13u
MN1040 (n1038 n842 vss vss) n12 w=1.6u l=0.13u
MP1041 (n1037 n1031 vdd vdd) p12 w=2.4u l=0.13u
MP1042 (n1037 n842 vdd vdd) p12 w=2.4u l=0.13u
MN1045 (n1043 n1031 n1044 vss) n12 w=1.6u l=0.13u
MN1046 (n1044 n869 vss vss) n12 w=1.6u l=0.13u
MP1047 (n1043 n1031 vdd vdd) p12 w=2.4u l=0.13u
MP1048 (n1043 n869 vdd vdd) p12 w=2.4u l=0.13u
MN1051 (n1049 n1037 n1050 vss) n12 w=1.6u l=0.13u
MN1052 (n1050 n1043 vss vss) n12 w=1.6u l=0.13u
MP1053 (n1049 n1037 vdd vdd) p12 w=2.4u l=0.13u
MP1054 (n1049 n1043 vdd vdd) p12 w=2.4u l=0.13u
MN1057 (n1055 n869 n1056 vss) n12 w=1.6u l=0.13u
MN1058 (n1056 n896 vss vss) n12 w=1.6u l=0.13u
MP1059 (n1055 n869 vdd vdd) p12 w=2.4u l=0.13u
MP1060 (n1055 n896 vdd vdd) p12 w=2.4u l=0.13u
MN1063 (n1061 n1055 n1062 vss) n12 w=1.6u l=0.13u
MN1064 (n1062 n869 vss vss) n12 w=1.6u l=0.13u
MP1065 (n1061 n1055 vdd vdd) p12 w=2.4u l=0.13u
MP1066 (n1061 n869 vdd vdd) p12 w=2.4u l=0.13u
MN1069 (n1067 n1055 n1068 vss) n12 w=1.6u l=0.13u
MN1070 (n1068 n896 vss vss) n12 w=1.6u l=0.13u
MP1071 (n1067 n1055 vdd vdd) p12 w=2.4u l=0.13u
MP1072 (n1067 n896 vdd vdd) p12 w=2.4u l=0.13u
MN1075 (n1073 n1061 n1074 vss) n12 w=1.6u l=0.13u
MN1076 (n1074 n1067 vss vss) n12 w=1.6u l=0.13u
MP1077 (n1073 n1061 vdd vdd) p12 w=2.4u l=0.13u
MP1078 (n1073 n1067 vdd vdd) p12 w=2.4u l=0.13u
MN1081 (n1079 n896 n1080 vss) n12 w=1.6u l=0.13u
MN1082 (n1080 n923 vss vss) n12 w=1.6u l=0.13u
MP1083 (n1079 n896 vdd vdd) p12 w=2.4u l=0.13u
MP1084 (n1079 n923 vdd vdd) p12 w=2.4u l=0.13u
MN1087 (n1085 n1079 n1086 vss) n12 w=1.6u l=0.13u
MN1088 (n1086 n896 vss vss) n12 w=1.6u l=0.13u
MP1089 (n1085 n1079 vdd vdd) p12 w=2.4u l=0.13u
MP1090 (n1085 n896 vdd vdd) p12 w=2.4u l=0.13u
MN1093 (n1091 n1079 n1092 vss) n12 w=1.6u l=0.13u
MN1094 (n1092 n923 vss vss) n12 w=1.6u l=0.13u
MP1095 (n1091 n1079 vdd vdd) p12 w=2.4u l=0.13u
MP1096 (n1091 n923 vdd vdd) p12 w=2.4u l=0.13u
MN1099 (n1097 n1085 n1098 vss) n12 w=1.6u l=0.13u
MN1100 (n1098 n1091 vss vss) n12 w=1.6u l=0.13u
MP1101 (n1097 n1085 vdd vdd) p12 w=2.4u l=0.13u
MP1102 (n1097 n1091 vdd vdd) p12 w=2.4u l=0.13u
MN1105 (n1103 n923 n1104 vss) n12 w=1.6u l=0.13u
MN1106 (n1104 n950 vss vss) n12 w=1.6u l=0.13u
MP1107 (n1103 n923 vdd vdd) p12 w=2.4u l=0.13u
MP1108 (n1103 n950 vdd vdd) p12 w=2.4u l=0.13u
MN1111 (n1109 n1103 n1110 vss) n12 w=1.6u l=0.13u
MN1112 (n1110 n923 vss vss) n12 w=1.6u l=0.13u
MP1113 (n1109 n1103 vdd vdd) p12 w=2.4u l=0.13u
MP1114 (n1109 n923 vdd vdd) p12 w=2.4u l=0.13u
MN1117 (n1115 n1103 n1116 vss) n12 w=1.6u l=0.13u
MN1118 (n1116 n950 vss vss) n12 w=1.6u l=0.13u
MP1119 (n1115 n1103 vdd vdd) p12 w=2.4u l=0.13u
MP1120 (n1115 n950 vdd vdd) p12 w=2.4u l=0.13u
MN1123 (n1121 n1109 n1122 vss) n12 w=1.6u l=0.13u
MN1124 (n1122 n1115 vss vss) n12 w=1.6u l=0.13u
MP1125 (n1121 n1109 vdd vdd) p12 w=2.4u l=0.13u
MP1126 (n1121 n1115 vdd vdd) p12 w=2.4u l=0.13u
MN1128 (delay1127 n587 vss vss) n12 w=0.8u l=0.13u
MP1129 (delay1127 n587 vdd vdd) p12 w=2.4u l=0.13u
MN1131 (delay1130 delay1127 vss vss) n12 w=0.8u l=0.13u
MP1132 (delay1130 delay1127 vdd vdd) p12 w=2.4u l=0.13u
MN1134 (delay1133 delay1130 vss vss) n12 w=0.8u l=0.13u
MP1135 (delay1133 delay1130 vdd vdd) p12 w=2.4u l=0.13u
MN1137 (delay1136 delay1133 vss vss) n12 w=0.8u l=0.13u
MP1138 (delay1136 delay1133 vdd vdd) p12 w=2.4u l=0.13u
MN1140 (delay1139 delay1136 vss vss) n12 w=0.8u l=0.13u
MP1141 (delay1139 delay1136 vdd vdd) p12 w=2.4u l=0.13u
MN1143 (delay1142 delay1139 vss vss) n12 w=0.8u l=0.13u
MP1144 (delay1142 delay1139 vdd vdd) p12 w=2.4u l=0.13u
MN1146 (n1145 n587 vss vss) n12 w=0.8u l=0.13u
MP1147 (n1145 n587 vdd vdd) p12 w=2.4u l=0.13u
MN1149 (n1148 delay1142 vss vss) n12 w=0.8u l=0.13u
MP1150 (n1148 delay1142 vdd vdd) p12 w=2.4u l=0.13u
MN1152 (n1151 reference_count_rst vss vss) n12 w=0.8u l=0.13u
MP1153 (n1151 reference_count_rst vdd vdd) p12 w=2.4u l=0.13u
MN1162 (n1158 n1145 n1159 vss) n12 w=3.2u l=0.13u
MP1163 (n1158 n1145 vdd vdd) p12 w=2.4u l=0.13u
MN1164 (n1159 n1148 n1160 vss) n12 w=3.2u l=0.13u
MP1165 (n1158 n1148 vdd vdd) p12 w=2.4u l=0.13u
MN1166 (n1160 clk_highb1157 n1161 vss) n12 w=3.2u l=0.13u
MP1167 (n1158 clk_highb1157 vdd vdd) p12 w=2.4u l=0.13u
MN1168 (n1161 n1151 vss vss) n12 w=3.2u l=0.13u
MP1169 (n1158 n1151 vdd vdd) p12 w=2.4u l=0.13u
MN1174 (n1170 n587 n1171 vss) n12 w=3.2u l=0.13u
MP1175 (n1170 n587 vdd vdd) p12 w=2.4u l=0.13u
MN1176 (n1171 delay1142 n1172 vss) n12 w=3.2u l=0.13u
MP1177 (n1170 delay1142 vdd vdd) p12 w=2.4u l=0.13u
MN1178 (n1172 clk_lowb1155 n1173 vss) n12 w=3.2u l=0.13u
MP1179 (n1170 clk_lowb1155 vdd vdd) p12 w=2.4u l=0.13u
MN1180 (n1173 n1151 vss vss) n12 w=3.2u l=0.13u
MP1181 (n1170 n1151 vdd vdd) p12 w=2.4u l=0.13u
MN1182 (clk_low1154 n1158 vss vss) n12 w=8u l=0.13u
MP1183 (clk_low1154 n1158 vdd vdd) p12 w=24u l=0.13u
MN1184 (clk_lowb1155 clk_low1154 vss vss) n12 w=8u l=0.13u
MP1185 (clk_lowb1155 clk_low1154 vdd vdd) p12 w=24u l=0.13u
MN1186 (clk_high1156 n1170 vss vss) n12 w=8u l=0.13u
MP1187 (clk_high1156 n1170 vdd vdd) p12 w=24u l=0.13u
MN1188 (clk_highb1157 clk_high1156 vss vss) n12 w=8u l=0.13u
MP1189 (clk_highb1157 clk_high1156 vdd vdd) p12 w=24u l=0.13u
MN1193 (n1192 n977 vss vss) n12 w=0.8u l=0.13u
MP1194 (n1192 n977 vdd vdd) p12 w=2.4u l=0.13u
MN1197 (n1192 clk_low1154 storage1196 vss) n12 w=1.2u l=0.13u
MP1198 (n1192 clk_lowb1155 storage1196 vdd) p12 w=3.6u l=0.13u
MN1199 (qm1190 clk_high1156 storage1196 vss) n12 w=1.2u l=0.13u
MP1200 (qm1190 clk_highb1157 storage1196 vdd) p12 w=3.6u l=0.13u
MN1201 (qmb1191 storage1196 vss vss) n12 w=0.5u l=0.13u
MP1202 (qmb1191 storage1196 vdd vdd) p12 w=1.5u l=0.13u
MN1203 (qm1190 qmb1191 vss vss) n12 w=0.5u l=0.13u
MP1204 (qm1190 qmb1191 vdd vdd) p12 w=1.5u l=0.13u
MN1205 (storage1196 reference_count_rst vss vss) n12 w=2u l=0.13u
MN1207 (qm1190 clk_high1156 storage1206 vss) n12 w=1.2u l=0.13u
MP1208 (qm1190 clk_highb1157 storage1206 vdd) p12 w=3.6u l=0.13u
MN1209 (qneg1195 clk_low1154 storage1206 vss) n12 w=1.2u l=0.13u
MP1210 (qneg1195 clk_lowb1155 storage1206 vdd) p12 w=3.6u l=0.13u
MN1211 (lead_g0 storage1206 vss vss) n12 w=0.5u l=0.13u
MP1212 (lead_g0 storage1206 vdd vdd) p12 w=1.5u l=0.13u
MN1213 (qneg1195 lead_g0 vss vss) n12 w=0.5u l=0.13u
MP1214 (qneg1195 lead_g0 vdd vdd) p12 w=1.5u l=0.13u
MN1215 (storage1206 reference_count_rst vss vss) n12 w=2u l=0.13u
MN1220 (n1001 clk_low1154 storage1219 vss) n12 w=1.2u l=0.13u
MP1221 (n1001 clk_lowb1155 storage1219 vdd) p12 w=3.6u l=0.13u
MN1222 (qm1216 clk_high1156 storage1219 vss) n12 w=1.2u l=0.13u
MP1223 (qm1216 clk_highb1157 storage1219 vdd) p12 w=3.6u l=0.13u
MN1224 (qmb1217 storage1219 vss vss) n12 w=0.5u l=0.13u
MP1225 (qmb1217 storage1219 vdd vdd) p12 w=1.5u l=0.13u
MN1226 (qm1216 qmb1217 vss vss) n12 w=0.5u l=0.13u
MP1227 (qm1216 qmb1217 vdd vdd) p12 w=1.5u l=0.13u
MN1228 (storage1219 reference_count_rst vss vss) n12 w=2u l=0.13u
MN1230 (qm1216 clk_high1156 storage1229 vss) n12 w=1.2u l=0.13u
MP1231 (qm1216 clk_highb1157 storage1229 vdd) p12 w=3.6u l=0.13u
MN1232 (lead_g1 clk_low1154 storage1229 vss) n12 w=1.2u l=0.13u
MP1233 (lead_g1 clk_lowb1155 storage1229 vdd) p12 w=3.6u l=0.13u
MN1234 (qb1218 storage1229 vss vss) n12 w=0.5u l=0.13u
MP1235 (qb1218 storage1229 vdd vdd) p12 w=1.5u l=0.13u
MN1236 (lead_g1 qb1218 vss vss) n12 w=0.5u l=0.13u
MP1237 (lead_g1 qb1218 vdd vdd) p12 w=1.5u l=0.13u
MN1238 (storage1229 reference_count_rst vss vss) n12 w=2u l=0.13u
MN1243 (n1025 clk_low1154 storage1242 vss) n12 w=1.2u l=0.13u
MP1244 (n1025 clk_lowb1155 storage1242 vdd) p12 w=3.6u l=0.13u
MN1245 (qm1239 clk_high1156 storage1242 vss) n12 w=1.2u l=0.13u
MP1246 (qm1239 clk_highb1157 storage1242 vdd) p12 w=3.6u l=0.13u
MN1247 (qmb1240 storage1242 vss vss) n12 w=0.5u l=0.13u
MP1248 (qmb1240 storage1242 vdd vdd) p12 w=1.5u l=0.13u
MN1249 (qm1239 qmb1240 vss vss) n12 w=0.5u l=0.13u
MP1250 (qm1239 qmb1240 vdd vdd) p12 w=1.5u l=0.13u
MN1251 (storage1242 reference_count_rst vss vss) n12 w=2u l=0.13u
MN1253 (qm1239 clk_high1156 storage1252 vss) n12 w=1.2u l=0.13u
MP1254 (qm1239 clk_highb1157 storage1252 vdd) p12 w=3.6u l=0.13u
MN1255 (lead_g2 clk_low1154 storage1252 vss) n12 w=1.2u l=0.13u
MP1256 (lead_g2 clk_lowb1155 storage1252 vdd) p12 w=3.6u l=0.13u
MN1257 (qb1241 storage1252 vss vss) n12 w=0.5u l=0.13u
MP1258 (qb1241 storage1252 vdd vdd) p12 w=1.5u l=0.13u
MN1259 (lead_g2 qb1241 vss vss) n12 w=0.5u l=0.13u
MP1260 (lead_g2 qb1241 vdd vdd) p12 w=1.5u l=0.13u
MN1261 (storage1252 reference_count_rst vss vss) n12 w=2u l=0.13u
MN1266 (n1049 clk_low1154 storage1265 vss) n12 w=1.2u l=0.13u
MP1267 (n1049 clk_lowb1155 storage1265 vdd) p12 w=3.6u l=0.13u
MN1268 (qm1262 clk_high1156 storage1265 vss) n12 w=1.2u l=0.13u
MP1269 (qm1262 clk_highb1157 storage1265 vdd) p12 w=3.6u l=0.13u
MN1270 (qmb1263 storage1265 vss vss) n12 w=0.5u l=0.13u
MP1271 (qmb1263 storage1265 vdd vdd) p12 w=1.5u l=0.13u
MN1272 (qm1262 qmb1263 vss vss) n12 w=0.5u l=0.13u
MP1273 (qm1262 qmb1263 vdd vdd) p12 w=1.5u l=0.13u
MN1274 (storage1265 reference_count_rst vss vss) n12 w=2u l=0.13u
MN1276 (qm1262 clk_high1156 storage1275 vss) n12 w=1.2u l=0.13u
MP1277 (qm1262 clk_highb1157 storage1275 vdd) p12 w=3.6u l=0.13u
MN1278 (lead_g3 clk_low1154 storage1275 vss) n12 w=1.2u l=0.13u
MP1279 (lead_g3 clk_lowb1155 storage1275 vdd) p12 w=3.6u l=0.13u
MN1280 (qb1264 storage1275 vss vss) n12 w=0.5u l=0.13u
MP1281 (qb1264 storage1275 vdd vdd) p12 w=1.5u l=0.13u
MN1282 (lead_g3 qb1264 vss vss) n12 w=0.5u l=0.13u
MP1283 (lead_g3 qb1264 vdd vdd) p12 w=1.5u l=0.13u
MN1284 (storage1275 reference_count_rst vss vss) n12 w=2u l=0.13u
MN1289 (n1073 clk_low1154 storage1288 vss) n12 w=1.2u l=0.13u
MP1290 (n1073 clk_lowb1155 storage1288 vdd) p12 w=3.6u l=0.13u
MN1291 (qm1285 clk_high1156 storage1288 vss) n12 w=1.2u l=0.13u
MP1292 (qm1285 clk_highb1157 storage1288 vdd) p12 w=3.6u l=0.13u
MN1293 (qmb1286 storage1288 vss vss) n12 w=0.5u l=0.13u
MP1294 (qmb1286 storage1288 vdd vdd) p12 w=1.5u l=0.13u
MN1295 (qm1285 qmb1286 vss vss) n12 w=0.5u l=0.13u
MP1296 (qm1285 qmb1286 vdd vdd) p12 w=1.5u l=0.13u
MN1297 (storage1288 reference_count_rst vss vss) n12 w=2u l=0.13u
MN1299 (qm1285 clk_high1156 storage1298 vss) n12 w=1.2u l=0.13u
MP1300 (qm1285 clk_highb1157 storage1298 vdd) p12 w=3.6u l=0.13u
MN1301 (lead_g4 clk_low1154 storage1298 vss) n12 w=1.2u l=0.13u
MP1302 (lead_g4 clk_lowb1155 storage1298 vdd) p12 w=3.6u l=0.13u
MN1303 (qb1287 storage1298 vss vss) n12 w=0.5u l=0.13u
MP1304 (qb1287 storage1298 vdd vdd) p12 w=1.5u l=0.13u
MN1305 (lead_g4 qb1287 vss vss) n12 w=0.5u l=0.13u
MP1306 (lead_g4 qb1287 vdd vdd) p12 w=1.5u l=0.13u
MN1307 (storage1298 reference_count_rst vss vss) n12 w=2u l=0.13u
MN1312 (n1097 clk_low1154 storage1311 vss) n12 w=1.2u l=0.13u
MP1313 (n1097 clk_lowb1155 storage1311 vdd) p12 w=3.6u l=0.13u
MN1314 (qm1308 clk_high1156 storage1311 vss) n12 w=1.2u l=0.13u
MP1315 (qm1308 clk_highb1157 storage1311 vdd) p12 w=3.6u l=0.13u
MN1316 (qmb1309 storage1311 vss vss) n12 w=0.5u l=0.13u
MP1317 (qmb1309 storage1311 vdd vdd) p12 w=1.5u l=0.13u
MN1318 (qm1308 qmb1309 vss vss) n12 w=0.5u l=0.13u
MP1319 (qm1308 qmb1309 vdd vdd) p12 w=1.5u l=0.13u
MN1320 (storage1311 reference_count_rst vss vss) n12 w=2u l=0.13u
MN1322 (qm1308 clk_high1156 storage1321 vss) n12 w=1.2u l=0.13u
MP1323 (qm1308 clk_highb1157 storage1321 vdd) p12 w=3.6u l=0.13u
MN1324 (lead_g5 clk_low1154 storage1321 vss) n12 w=1.2u l=0.13u
MP1325 (lead_g5 clk_lowb1155 storage1321 vdd) p12 w=3.6u l=0.13u
MN1326 (qb1310 storage1321 vss vss) n12 w=0.5u l=0.13u
MP1327 (qb1310 storage1321 vdd vdd) p12 w=1.5u l=0.13u
MN1328 (lead_g5 qb1310 vss vss) n12 w=0.5u l=0.13u
MP1329 (lead_g5 qb1310 vdd vdd) p12 w=1.5u l=0.13u
MN1330 (storage1321 reference_count_rst vss vss) n12 w=2u l=0.13u
MN1335 (n1121 clk_low1154 storage1334 vss) n12 w=1.2u l=0.13u
MP1336 (n1121 clk_lowb1155 storage1334 vdd) p12 w=3.6u l=0.13u
MN1337 (qm1331 clk_high1156 storage1334 vss) n12 w=1.2u l=0.13u
MP1338 (qm1331 clk_highb1157 storage1334 vdd) p12 w=3.6u l=0.13u
MN1339 (qmb1332 storage1334 vss vss) n12 w=0.5u l=0.13u
MP1340 (qmb1332 storage1334 vdd vdd) p12 w=1.5u l=0.13u
MN1341 (qm1331 qmb1332 vss vss) n12 w=0.5u l=0.13u
MP1342 (qm1331 qmb1332 vdd vdd) p12 w=1.5u l=0.13u
MN1343 (storage1334 reference_count_rst vss vss) n12 w=2u l=0.13u
MN1345 (qm1331 clk_high1156 storage1344 vss) n12 w=1.2u l=0.13u
MP1346 (qm1331 clk_highb1157 storage1344 vdd) p12 w=3.6u l=0.13u
MN1347 (lead_g6 clk_low1154 storage1344 vss) n12 w=1.2u l=0.13u
MP1348 (lead_g6 clk_lowb1155 storage1344 vdd) p12 w=3.6u l=0.13u
MN1349 (qb1333 storage1344 vss vss) n12 w=0.5u l=0.13u
MP1350 (qb1333 storage1344 vdd vdd) p12 w=1.5u l=0.13u
MN1351 (lead_g6 qb1333 vss vss) n12 w=0.5u l=0.13u
MP1352 (lead_g6 qb1333 vdd vdd) p12 w=1.5u l=0.13u
MN1353 (storage1344 reference_count_rst vss vss) n12 w=2u l=0.13u
MN1358 (n950 clk_low1154 storage1357 vss) n12 w=1.2u l=0.13u
MP1359 (n950 clk_lowb1155 storage1357 vdd) p12 w=3.6u l=0.13u
MN1360 (qm1354 clk_high1156 storage1357 vss) n12 w=1.2u l=0.13u
MP1361 (qm1354 clk_highb1157 storage1357 vdd) p12 w=3.6u l=0.13u
MN1362 (qmb1355 storage1357 vss vss) n12 w=0.5u l=0.13u
MP1363 (qmb1355 storage1357 vdd vdd) p12 w=1.5u l=0.13u
MN1364 (qm1354 qmb1355 vss vss) n12 w=0.5u l=0.13u
MP1365 (qm1354 qmb1355 vdd vdd) p12 w=1.5u l=0.13u
MN1366 (storage1357 reference_count_rst vss vss) n12 w=2u l=0.13u
MN1368 (qm1354 clk_high1156 storage1367 vss) n12 w=1.2u l=0.13u
MP1369 (qm1354 clk_highb1157 storage1367 vdd) p12 w=3.6u l=0.13u
MN1370 (lead_g7 clk_low1154 storage1367 vss) n12 w=1.2u l=0.13u
MP1371 (lead_g7 clk_lowb1155 storage1367 vdd) p12 w=3.6u l=0.13u
MN1372 (qb1356 storage1367 vss vss) n12 w=0.5u l=0.13u
MP1373 (qb1356 storage1367 vdd vdd) p12 w=1.5u l=0.13u
MN1374 (lead_g7 qb1356 vss vss) n12 w=0.5u l=0.13u
MP1375 (lead_g7 qb1356 vdd vdd) p12 w=1.5u l=0.13u
MN1376 (storage1367 reference_count_rst vss vss) n12 w=2u l=0.13u
MN1379 (n1377 lag_g6 n1378 vss) n12 w=1.6u l=0.13u
MN1380 (n1378 lag_g7 vss vss) n12 w=1.6u l=0.13u
MP1381 (n1377 lag_g6 vdd vdd) p12 w=2.4u l=0.13u
MP1382 (n1377 lag_g7 vdd vdd) p12 w=2.4u l=0.13u
MN1385 (n1383 lag_g6 n1384 vss) n12 w=1.6u l=0.13u
MN1386 (n1384 n1377 vss vss) n12 w=1.6u l=0.13u
MP1387 (n1383 lag_g6 vdd vdd) p12 w=2.4u l=0.13u
MP1388 (n1383 n1377 vdd vdd) p12 w=2.4u l=0.13u
MN1391 (n1389 lag_g7 n1390 vss) n12 w=1.6u l=0.13u
MN1392 (n1390 n1377 vss vss) n12 w=1.6u l=0.13u
MP1393 (n1389 lag_g7 vdd vdd) p12 w=2.4u l=0.13u
MP1394 (n1389 n1377 vdd vdd) p12 w=2.4u l=0.13u
MN1397 (n1395 n1383 n1396 vss) n12 w=1.6u l=0.13u
MN1398 (n1396 n1389 vss vss) n12 w=1.6u l=0.13u
MP1399 (n1395 n1383 vdd vdd) p12 w=2.4u l=0.13u
MP1400 (n1395 n1389 vdd vdd) p12 w=2.4u l=0.13u
MN1403 (n1401 lag_g5 n1402 vss) n12 w=1.6u l=0.13u
MN1404 (n1402 n1395 vss vss) n12 w=1.6u l=0.13u
MP1405 (n1401 lag_g5 vdd vdd) p12 w=2.4u l=0.13u
MP1406 (n1401 n1395 vdd vdd) p12 w=2.4u l=0.13u
MN1409 (n1407 lag_g5 n1408 vss) n12 w=1.6u l=0.13u
MN1410 (n1408 n1401 vss vss) n12 w=1.6u l=0.13u
MP1411 (n1407 lag_g5 vdd vdd) p12 w=2.4u l=0.13u
MP1412 (n1407 n1401 vdd vdd) p12 w=2.4u l=0.13u
MN1415 (n1413 n1395 n1414 vss) n12 w=1.6u l=0.13u
MN1416 (n1414 n1401 vss vss) n12 w=1.6u l=0.13u
MP1417 (n1413 n1395 vdd vdd) p12 w=2.4u l=0.13u
MP1418 (n1413 n1401 vdd vdd) p12 w=2.4u l=0.13u
MN1421 (n1419 n1407 n1420 vss) n12 w=1.6u l=0.13u
MN1422 (n1420 n1413 vss vss) n12 w=1.6u l=0.13u
MP1423 (n1419 n1407 vdd vdd) p12 w=2.4u l=0.13u
MP1424 (n1419 n1413 vdd vdd) p12 w=2.4u l=0.13u
MN1427 (n1425 lag_g4 n1426 vss) n12 w=1.6u l=0.13u
MN1428 (n1426 n1419 vss vss) n12 w=1.6u l=0.13u
MP1429 (n1425 lag_g4 vdd vdd) p12 w=2.4u l=0.13u
MP1430 (n1425 n1419 vdd vdd) p12 w=2.4u l=0.13u
MN1433 (n1431 lag_g4 n1432 vss) n12 w=1.6u l=0.13u
MN1434 (n1432 n1425 vss vss) n12 w=1.6u l=0.13u
MP1435 (n1431 lag_g4 vdd vdd) p12 w=2.4u l=0.13u
MP1436 (n1431 n1425 vdd vdd) p12 w=2.4u l=0.13u
MN1439 (n1437 n1419 n1438 vss) n12 w=1.6u l=0.13u
MN1440 (n1438 n1425 vss vss) n12 w=1.6u l=0.13u
MP1441 (n1437 n1419 vdd vdd) p12 w=2.4u l=0.13u
MP1442 (n1437 n1425 vdd vdd) p12 w=2.4u l=0.13u
MN1445 (n1443 n1431 n1444 vss) n12 w=1.6u l=0.13u
MN1446 (n1444 n1437 vss vss) n12 w=1.6u l=0.13u
MP1447 (n1443 n1431 vdd vdd) p12 w=2.4u l=0.13u
MP1448 (n1443 n1437 vdd vdd) p12 w=2.4u l=0.13u
MN1451 (n1449 lag_g3 n1450 vss) n12 w=1.6u l=0.13u
MN1452 (n1450 n1443 vss vss) n12 w=1.6u l=0.13u
MP1453 (n1449 lag_g3 vdd vdd) p12 w=2.4u l=0.13u
MP1454 (n1449 n1443 vdd vdd) p12 w=2.4u l=0.13u
MN1457 (n1455 lag_g3 n1456 vss) n12 w=1.6u l=0.13u
MN1458 (n1456 n1449 vss vss) n12 w=1.6u l=0.13u
MP1459 (n1455 lag_g3 vdd vdd) p12 w=2.4u l=0.13u
MP1460 (n1455 n1449 vdd vdd) p12 w=2.4u l=0.13u
MN1463 (n1461 n1443 n1462 vss) n12 w=1.6u l=0.13u
MN1464 (n1462 n1449 vss vss) n12 w=1.6u l=0.13u
MP1465 (n1461 n1443 vdd vdd) p12 w=2.4u l=0.13u
MP1466 (n1461 n1449 vdd vdd) p12 w=2.4u l=0.13u
MN1469 (n1467 n1455 n1468 vss) n12 w=1.6u l=0.13u
MN1470 (n1468 n1461 vss vss) n12 w=1.6u l=0.13u
MP1471 (n1467 n1455 vdd vdd) p12 w=2.4u l=0.13u
MP1472 (n1467 n1461 vdd vdd) p12 w=2.4u l=0.13u
MN1475 (n1473 lag_g2 n1474 vss) n12 w=1.6u l=0.13u
MN1476 (n1474 n1467 vss vss) n12 w=1.6u l=0.13u
MP1477 (n1473 lag_g2 vdd vdd) p12 w=2.4u l=0.13u
MP1478 (n1473 n1467 vdd vdd) p12 w=2.4u l=0.13u
MN1481 (n1479 lag_g2 n1480 vss) n12 w=1.6u l=0.13u
MN1482 (n1480 n1473 vss vss) n12 w=1.6u l=0.13u
MP1483 (n1479 lag_g2 vdd vdd) p12 w=2.4u l=0.13u
MP1484 (n1479 n1473 vdd vdd) p12 w=2.4u l=0.13u
MN1487 (n1485 n1467 n1486 vss) n12 w=1.6u l=0.13u
MN1488 (n1486 n1473 vss vss) n12 w=1.6u l=0.13u
MP1489 (n1485 n1467 vdd vdd) p12 w=2.4u l=0.13u
MP1490 (n1485 n1473 vdd vdd) p12 w=2.4u l=0.13u
MN1493 (n1491 n1479 n1492 vss) n12 w=1.6u l=0.13u
MN1494 (n1492 n1485 vss vss) n12 w=1.6u l=0.13u
MP1495 (n1491 n1479 vdd vdd) p12 w=2.4u l=0.13u
MP1496 (n1491 n1485 vdd vdd) p12 w=2.4u l=0.13u
MN1499 (n1497 lag_g1 n1498 vss) n12 w=1.6u l=0.13u
MN1500 (n1498 n1491 vss vss) n12 w=1.6u l=0.13u
MP1501 (n1497 lag_g1 vdd vdd) p12 w=2.4u l=0.13u
MP1502 (n1497 n1491 vdd vdd) p12 w=2.4u l=0.13u
MN1505 (n1503 lag_g1 n1504 vss) n12 w=1.6u l=0.13u
MN1506 (n1504 n1497 vss vss) n12 w=1.6u l=0.13u
MP1507 (n1503 lag_g1 vdd vdd) p12 w=2.4u l=0.13u
MP1508 (n1503 n1497 vdd vdd) p12 w=2.4u l=0.13u
MN1511 (n1509 n1491 n1510 vss) n12 w=1.6u l=0.13u
MN1512 (n1510 n1497 vss vss) n12 w=1.6u l=0.13u
MP1513 (n1509 n1491 vdd vdd) p12 w=2.4u l=0.13u
MP1514 (n1509 n1497 vdd vdd) p12 w=2.4u l=0.13u
MN1517 (n1515 n1503 n1516 vss) n12 w=1.6u l=0.13u
MN1518 (n1516 n1509 vss vss) n12 w=1.6u l=0.13u
MP1519 (n1515 n1503 vdd vdd) p12 w=2.4u l=0.13u
MP1520 (n1515 n1509 vdd vdd) p12 w=2.4u l=0.13u
MN1523 (n1521 lag_g0 n1522 vss) n12 w=1.6u l=0.13u
MN1524 (n1522 n1515 vss vss) n12 w=1.6u l=0.13u
MP1525 (n1521 lag_g0 vdd vdd) p12 w=2.4u l=0.13u
MP1526 (n1521 n1515 vdd vdd) p12 w=2.4u l=0.13u
MN1529 (n1527 lag_g0 n1528 vss) n12 w=1.6u l=0.13u
MN1530 (n1528 n1521 vss vss) n12 w=1.6u l=0.13u
MP1531 (n1527 lag_g0 vdd vdd) p12 w=2.4u l=0.13u
MP1532 (n1527 n1521 vdd vdd) p12 w=2.4u l=0.13u
MN1535 (n1533 n1515 n1534 vss) n12 w=1.6u l=0.13u
MN1536 (n1534 n1521 vss vss) n12 w=1.6u l=0.13u
MP1537 (n1533 n1515 vdd vdd) p12 w=2.4u l=0.13u
MP1538 (n1533 n1521 vdd vdd) p12 w=2.4u l=0.13u
MN1541 (n1539 n1527 n1540 vss) n12 w=1.6u l=0.13u
MN1542 (n1540 n1533 vss vss) n12 w=1.6u l=0.13u
MP1543 (n1539 n1527 vdd vdd) p12 w=2.4u l=0.13u
MP1544 (n1539 n1533 vdd vdd) p12 w=2.4u l=0.13u
MN1546 (n1545 n1539 vss vss) n12 w=0.8u l=0.13u
MP1547 (n1545 n1539 vdd vdd) p12 w=2.4u l=0.13u
MN1550 (n1548 n1515 n1549 vss) n12 w=1.6u l=0.13u
MN1551 (n1549 n1539 vss vss) n12 w=1.6u l=0.13u
MP1552 (n1548 n1515 vdd vdd) p12 w=2.4u l=0.13u
MP1553 (n1548 n1539 vdd vdd) p12 w=2.4u l=0.13u
MN1556 (n1554 n1515 n1555 vss) n12 w=1.6u l=0.13u
MN1557 (n1555 n1548 vss vss) n12 w=1.6u l=0.13u
MP1558 (n1554 n1515 vdd vdd) p12 w=2.4u l=0.13u
MP1559 (n1554 n1548 vdd vdd) p12 w=2.4u l=0.13u
MN1562 (n1560 n1539 n1561 vss) n12 w=1.6u l=0.13u
MN1563 (n1561 n1548 vss vss) n12 w=1.6u l=0.13u
MP1564 (n1560 n1539 vdd vdd) p12 w=2.4u l=0.13u
MP1565 (n1560 n1548 vdd vdd) p12 w=2.4u l=0.13u
MN1568 (n1566 n1554 n1567 vss) n12 w=1.6u l=0.13u
MN1569 (n1567 n1560 vss vss) n12 w=1.6u l=0.13u
MP1570 (n1566 n1554 vdd vdd) p12 w=2.4u l=0.13u
MP1571 (n1566 n1560 vdd vdd) p12 w=2.4u l=0.13u
MN1573 (n1572 n1548 vss vss) n12 w=0.8u l=0.13u
MP1574 (n1572 n1548 vdd vdd) p12 w=2.4u l=0.13u
MN1577 (n1575 n1491 n1576 vss) n12 w=1.6u l=0.13u
MN1578 (n1576 n1572 vss vss) n12 w=1.6u l=0.13u
MP1579 (n1575 n1491 vdd vdd) p12 w=2.4u l=0.13u
MP1580 (n1575 n1572 vdd vdd) p12 w=2.4u l=0.13u
MN1583 (n1581 n1491 n1582 vss) n12 w=1.6u l=0.13u
MN1584 (n1582 n1575 vss vss) n12 w=1.6u l=0.13u
MP1585 (n1581 n1491 vdd vdd) p12 w=2.4u l=0.13u
MP1586 (n1581 n1575 vdd vdd) p12 w=2.4u l=0.13u
MN1589 (n1587 n1572 n1588 vss) n12 w=1.6u l=0.13u
MN1590 (n1588 n1575 vss vss) n12 w=1.6u l=0.13u
MP1591 (n1587 n1572 vdd vdd) p12 w=2.4u l=0.13u
MP1592 (n1587 n1575 vdd vdd) p12 w=2.4u l=0.13u
MN1595 (n1593 n1581 n1594 vss) n12 w=1.6u l=0.13u
MN1596 (n1594 n1587 vss vss) n12 w=1.6u l=0.13u
MP1597 (n1593 n1581 vdd vdd) p12 w=2.4u l=0.13u
MP1598 (n1593 n1587 vdd vdd) p12 w=2.4u l=0.13u
MN1600 (n1599 n1575 vss vss) n12 w=0.8u l=0.13u
MP1601 (n1599 n1575 vdd vdd) p12 w=2.4u l=0.13u
MN1604 (n1602 n1467 n1603 vss) n12 w=1.6u l=0.13u
MN1605 (n1603 n1599 vss vss) n12 w=1.6u l=0.13u
MP1606 (n1602 n1467 vdd vdd) p12 w=2.4u l=0.13u
MP1607 (n1602 n1599 vdd vdd) p12 w=2.4u l=0.13u
MN1610 (n1608 n1467 n1609 vss) n12 w=1.6u l=0.13u
MN1611 (n1609 n1602 vss vss) n12 w=1.6u l=0.13u
MP1612 (n1608 n1467 vdd vdd) p12 w=2.4u l=0.13u
MP1613 (n1608 n1602 vdd vdd) p12 w=2.4u l=0.13u
MN1616 (n1614 n1599 n1615 vss) n12 w=1.6u l=0.13u
MN1617 (n1615 n1602 vss vss) n12 w=1.6u l=0.13u
MP1618 (n1614 n1599 vdd vdd) p12 w=2.4u l=0.13u
MP1619 (n1614 n1602 vdd vdd) p12 w=2.4u l=0.13u
MN1622 (n1620 n1608 n1621 vss) n12 w=1.6u l=0.13u
MN1623 (n1621 n1614 vss vss) n12 w=1.6u l=0.13u
MP1624 (n1620 n1608 vdd vdd) p12 w=2.4u l=0.13u
MP1625 (n1620 n1614 vdd vdd) p12 w=2.4u l=0.13u
MN1627 (n1626 n1602 vss vss) n12 w=0.8u l=0.13u
MP1628 (n1626 n1602 vdd vdd) p12 w=2.4u l=0.13u
MN1631 (n1629 n1443 n1630 vss) n12 w=1.6u l=0.13u
MN1632 (n1630 n1626 vss vss) n12 w=1.6u l=0.13u
MP1633 (n1629 n1443 vdd vdd) p12 w=2.4u l=0.13u
MP1634 (n1629 n1626 vdd vdd) p12 w=2.4u l=0.13u
MN1637 (n1635 n1443 n1636 vss) n12 w=1.6u l=0.13u
MN1638 (n1636 n1629 vss vss) n12 w=1.6u l=0.13u
MP1639 (n1635 n1443 vdd vdd) p12 w=2.4u l=0.13u
MP1640 (n1635 n1629 vdd vdd) p12 w=2.4u l=0.13u
MN1643 (n1641 n1626 n1642 vss) n12 w=1.6u l=0.13u
MN1644 (n1642 n1629 vss vss) n12 w=1.6u l=0.13u
MP1645 (n1641 n1626 vdd vdd) p12 w=2.4u l=0.13u
MP1646 (n1641 n1629 vdd vdd) p12 w=2.4u l=0.13u
MN1649 (n1647 n1635 n1648 vss) n12 w=1.6u l=0.13u
MN1650 (n1648 n1641 vss vss) n12 w=1.6u l=0.13u
MP1651 (n1647 n1635 vdd vdd) p12 w=2.4u l=0.13u
MP1652 (n1647 n1641 vdd vdd) p12 w=2.4u l=0.13u
MN1654 (n1653 n1629 vss vss) n12 w=0.8u l=0.13u
MP1655 (n1653 n1629 vdd vdd) p12 w=2.4u l=0.13u
MN1658 (n1656 n1419 n1657 vss) n12 w=1.6u l=0.13u
MN1659 (n1657 n1653 vss vss) n12 w=1.6u l=0.13u
MP1660 (n1656 n1419 vdd vdd) p12 w=2.4u l=0.13u
MP1661 (n1656 n1653 vdd vdd) p12 w=2.4u l=0.13u
MN1664 (n1662 n1419 n1663 vss) n12 w=1.6u l=0.13u
MN1665 (n1663 n1656 vss vss) n12 w=1.6u l=0.13u
MP1666 (n1662 n1419 vdd vdd) p12 w=2.4u l=0.13u
MP1667 (n1662 n1656 vdd vdd) p12 w=2.4u l=0.13u
MN1670 (n1668 n1653 n1669 vss) n12 w=1.6u l=0.13u
MN1671 (n1669 n1656 vss vss) n12 w=1.6u l=0.13u
MP1672 (n1668 n1653 vdd vdd) p12 w=2.4u l=0.13u
MP1673 (n1668 n1656 vdd vdd) p12 w=2.4u l=0.13u
MN1676 (n1674 n1662 n1675 vss) n12 w=1.6u l=0.13u
MN1677 (n1675 n1668 vss vss) n12 w=1.6u l=0.13u
MP1678 (n1674 n1662 vdd vdd) p12 w=2.4u l=0.13u
MP1679 (n1674 n1668 vdd vdd) p12 w=2.4u l=0.13u
MN1681 (n1680 n1656 vss vss) n12 w=0.8u l=0.13u
MP1682 (n1680 n1656 vdd vdd) p12 w=2.4u l=0.13u
MN1685 (n1683 n1395 n1684 vss) n12 w=1.6u l=0.13u
MN1686 (n1684 n1680 vss vss) n12 w=1.6u l=0.13u
MP1687 (n1683 n1395 vdd vdd) p12 w=2.4u l=0.13u
MP1688 (n1683 n1680 vdd vdd) p12 w=2.4u l=0.13u
MN1691 (n1689 n1395 n1690 vss) n12 w=1.6u l=0.13u
MN1692 (n1690 n1683 vss vss) n12 w=1.6u l=0.13u
MP1693 (n1689 n1395 vdd vdd) p12 w=2.4u l=0.13u
MP1694 (n1689 n1683 vdd vdd) p12 w=2.4u l=0.13u
MN1697 (n1695 n1680 n1696 vss) n12 w=1.6u l=0.13u
MN1698 (n1696 n1683 vss vss) n12 w=1.6u l=0.13u
MP1699 (n1695 n1680 vdd vdd) p12 w=2.4u l=0.13u
MP1700 (n1695 n1683 vdd vdd) p12 w=2.4u l=0.13u
MN1703 (n1701 n1689 n1702 vss) n12 w=1.6u l=0.13u
MN1704 (n1702 n1695 vss vss) n12 w=1.6u l=0.13u
MP1705 (n1701 n1689 vdd vdd) p12 w=2.4u l=0.13u
MP1706 (n1701 n1695 vdd vdd) p12 w=2.4u l=0.13u
MN1708 (n1707 n1683 vss vss) n12 w=0.8u l=0.13u
MP1709 (n1707 n1683 vdd vdd) p12 w=2.4u l=0.13u
MN1712 (n1710 lag_g7 n1711 vss) n12 w=1.6u l=0.13u
MN1713 (n1711 n1707 vss vss) n12 w=1.6u l=0.13u
MP1714 (n1710 lag_g7 vdd vdd) p12 w=2.4u l=0.13u
MP1715 (n1710 n1707 vdd vdd) p12 w=2.4u l=0.13u
MN1718 (n1716 lag_g7 n1717 vss) n12 w=1.6u l=0.13u
MN1719 (n1717 n1710 vss vss) n12 w=1.6u l=0.13u
MP1720 (n1716 lag_g7 vdd vdd) p12 w=2.4u l=0.13u
MP1721 (n1716 n1710 vdd vdd) p12 w=2.4u l=0.13u
MN1724 (n1722 n1707 n1723 vss) n12 w=1.6u l=0.13u
MN1725 (n1723 n1710 vss vss) n12 w=1.6u l=0.13u
MP1726 (n1722 n1707 vdd vdd) p12 w=2.4u l=0.13u
MP1727 (n1722 n1710 vdd vdd) p12 w=2.4u l=0.13u
MN1730 (n1728 n1716 n1729 vss) n12 w=1.6u l=0.13u
MN1731 (n1729 n1722 vss vss) n12 w=1.6u l=0.13u
MP1732 (n1728 n1716 vdd vdd) p12 w=2.4u l=0.13u
MP1733 (n1728 n1722 vdd vdd) p12 w=2.4u l=0.13u
MN1735 (n1734 n1710 vss vss) n12 w=0.8u l=0.13u
MP1736 (n1734 n1710 vdd vdd) p12 w=2.4u l=0.13u
MN1739 (n1737 n1545 n1738 vss) n12 w=1.6u l=0.13u
MN1740 (n1738 n1566 vss vss) n12 w=1.6u l=0.13u
MP1741 (n1737 n1545 vdd vdd) p12 w=2.4u l=0.13u
MP1742 (n1737 n1566 vdd vdd) p12 w=2.4u l=0.13u
MN1745 (n1743 n1545 n1744 vss) n12 w=1.6u l=0.13u
MN1746 (n1744 n1737 vss vss) n12 w=1.6u l=0.13u
MP1747 (n1743 n1545 vdd vdd) p12 w=2.4u l=0.13u
MP1748 (n1743 n1737 vdd vdd) p12 w=2.4u l=0.13u
MN1751 (n1749 n1566 n1750 vss) n12 w=1.6u l=0.13u
MN1752 (n1750 n1737 vss vss) n12 w=1.6u l=0.13u
MP1753 (n1749 n1566 vdd vdd) p12 w=2.4u l=0.13u
MP1754 (n1749 n1737 vdd vdd) p12 w=2.4u l=0.13u
MN1757 (n1755 n1743 n1756 vss) n12 w=1.6u l=0.13u
MN1758 (n1756 n1749 vss vss) n12 w=1.6u l=0.13u
MP1759 (n1755 n1743 vdd vdd) p12 w=2.4u l=0.13u
MP1760 (n1755 n1749 vdd vdd) p12 w=2.4u l=0.13u
MN1763 (n1761 n1566 n1762 vss) n12 w=1.6u l=0.13u
MN1764 (n1762 n1593 vss vss) n12 w=1.6u l=0.13u
MP1765 (n1761 n1566 vdd vdd) p12 w=2.4u l=0.13u
MP1766 (n1761 n1593 vdd vdd) p12 w=2.4u l=0.13u
MN1769 (n1767 n1566 n1768 vss) n12 w=1.6u l=0.13u
MN1770 (n1768 n1761 vss vss) n12 w=1.6u l=0.13u
MP1771 (n1767 n1566 vdd vdd) p12 w=2.4u l=0.13u
MP1772 (n1767 n1761 vdd vdd) p12 w=2.4u l=0.13u
MN1775 (n1773 n1593 n1774 vss) n12 w=1.6u l=0.13u
MN1776 (n1774 n1761 vss vss) n12 w=1.6u l=0.13u
MP1777 (n1773 n1593 vdd vdd) p12 w=2.4u l=0.13u
MP1778 (n1773 n1761 vdd vdd) p12 w=2.4u l=0.13u
MN1781 (n1779 n1767 n1780 vss) n12 w=1.6u l=0.13u
MN1782 (n1780 n1773 vss vss) n12 w=1.6u l=0.13u
MP1783 (n1779 n1767 vdd vdd) p12 w=2.4u l=0.13u
MP1784 (n1779 n1773 vdd vdd) p12 w=2.4u l=0.13u
MN1787 (n1785 n1593 n1786 vss) n12 w=1.6u l=0.13u
MN1788 (n1786 n1620 vss vss) n12 w=1.6u l=0.13u
MP1789 (n1785 n1593 vdd vdd) p12 w=2.4u l=0.13u
MP1790 (n1785 n1620 vdd vdd) p12 w=2.4u l=0.13u
MN1793 (n1791 n1593 n1792 vss) n12 w=1.6u l=0.13u
MN1794 (n1792 n1785 vss vss) n12 w=1.6u l=0.13u
MP1795 (n1791 n1593 vdd vdd) p12 w=2.4u l=0.13u
MP1796 (n1791 n1785 vdd vdd) p12 w=2.4u l=0.13u
MN1799 (n1797 n1620 n1798 vss) n12 w=1.6u l=0.13u
MN1800 (n1798 n1785 vss vss) n12 w=1.6u l=0.13u
MP1801 (n1797 n1620 vdd vdd) p12 w=2.4u l=0.13u
MP1802 (n1797 n1785 vdd vdd) p12 w=2.4u l=0.13u
MN1805 (n1803 n1791 n1804 vss) n12 w=1.6u l=0.13u
MN1806 (n1804 n1797 vss vss) n12 w=1.6u l=0.13u
MP1807 (n1803 n1791 vdd vdd) p12 w=2.4u l=0.13u
MP1808 (n1803 n1797 vdd vdd) p12 w=2.4u l=0.13u
MN1811 (n1809 n1620 n1810 vss) n12 w=1.6u l=0.13u
MN1812 (n1810 n1647 vss vss) n12 w=1.6u l=0.13u
MP1813 (n1809 n1620 vdd vdd) p12 w=2.4u l=0.13u
MP1814 (n1809 n1647 vdd vdd) p12 w=2.4u l=0.13u
MN1817 (n1815 n1620 n1816 vss) n12 w=1.6u l=0.13u
MN1818 (n1816 n1809 vss vss) n12 w=1.6u l=0.13u
MP1819 (n1815 n1620 vdd vdd) p12 w=2.4u l=0.13u
MP1820 (n1815 n1809 vdd vdd) p12 w=2.4u l=0.13u
MN1823 (n1821 n1647 n1822 vss) n12 w=1.6u l=0.13u
MN1824 (n1822 n1809 vss vss) n12 w=1.6u l=0.13u
MP1825 (n1821 n1647 vdd vdd) p12 w=2.4u l=0.13u
MP1826 (n1821 n1809 vdd vdd) p12 w=2.4u l=0.13u
MN1829 (n1827 n1815 n1828 vss) n12 w=1.6u l=0.13u
MN1830 (n1828 n1821 vss vss) n12 w=1.6u l=0.13u
MP1831 (n1827 n1815 vdd vdd) p12 w=2.4u l=0.13u
MP1832 (n1827 n1821 vdd vdd) p12 w=2.4u l=0.13u
MN1835 (n1833 n1647 n1834 vss) n12 w=1.6u l=0.13u
MN1836 (n1834 n1674 vss vss) n12 w=1.6u l=0.13u
MP1837 (n1833 n1647 vdd vdd) p12 w=2.4u l=0.13u
MP1838 (n1833 n1674 vdd vdd) p12 w=2.4u l=0.13u
MN1841 (n1839 n1647 n1840 vss) n12 w=1.6u l=0.13u
MN1842 (n1840 n1833 vss vss) n12 w=1.6u l=0.13u
MP1843 (n1839 n1647 vdd vdd) p12 w=2.4u l=0.13u
MP1844 (n1839 n1833 vdd vdd) p12 w=2.4u l=0.13u
MN1847 (n1845 n1674 n1846 vss) n12 w=1.6u l=0.13u
MN1848 (n1846 n1833 vss vss) n12 w=1.6u l=0.13u
MP1849 (n1845 n1674 vdd vdd) p12 w=2.4u l=0.13u
MP1850 (n1845 n1833 vdd vdd) p12 w=2.4u l=0.13u
MN1853 (n1851 n1839 n1852 vss) n12 w=1.6u l=0.13u
MN1854 (n1852 n1845 vss vss) n12 w=1.6u l=0.13u
MP1855 (n1851 n1839 vdd vdd) p12 w=2.4u l=0.13u
MP1856 (n1851 n1845 vdd vdd) p12 w=2.4u l=0.13u
MN1859 (n1857 n1674 n1858 vss) n12 w=1.6u l=0.13u
MN1860 (n1858 n1701 vss vss) n12 w=1.6u l=0.13u
MP1861 (n1857 n1674 vdd vdd) p12 w=2.4u l=0.13u
MP1862 (n1857 n1701 vdd vdd) p12 w=2.4u l=0.13u
MN1865 (n1863 n1674 n1864 vss) n12 w=1.6u l=0.13u
MN1866 (n1864 n1857 vss vss) n12 w=1.6u l=0.13u
MP1867 (n1863 n1674 vdd vdd) p12 w=2.4u l=0.13u
MP1868 (n1863 n1857 vdd vdd) p12 w=2.4u l=0.13u
MN1871 (n1869 n1701 n1870 vss) n12 w=1.6u l=0.13u
MN1872 (n1870 n1857 vss vss) n12 w=1.6u l=0.13u
MP1873 (n1869 n1701 vdd vdd) p12 w=2.4u l=0.13u
MP1874 (n1869 n1857 vdd vdd) p12 w=2.4u l=0.13u
MN1877 (n1875 n1863 n1876 vss) n12 w=1.6u l=0.13u
MN1878 (n1876 n1869 vss vss) n12 w=1.6u l=0.13u
MP1879 (n1875 n1863 vdd vdd) p12 w=2.4u l=0.13u
MP1880 (n1875 n1869 vdd vdd) p12 w=2.4u l=0.13u
MN1883 (n1881 n1701 n1882 vss) n12 w=1.6u l=0.13u
MN1884 (n1882 n1728 vss vss) n12 w=1.6u l=0.13u
MP1885 (n1881 n1701 vdd vdd) p12 w=2.4u l=0.13u
MP1886 (n1881 n1728 vdd vdd) p12 w=2.4u l=0.13u
MN1889 (n1887 n1701 n1888 vss) n12 w=1.6u l=0.13u
MN1890 (n1888 n1881 vss vss) n12 w=1.6u l=0.13u
MP1891 (n1887 n1701 vdd vdd) p12 w=2.4u l=0.13u
MP1892 (n1887 n1881 vdd vdd) p12 w=2.4u l=0.13u
MN1895 (n1893 n1728 n1894 vss) n12 w=1.6u l=0.13u
MN1896 (n1894 n1881 vss vss) n12 w=1.6u l=0.13u
MP1897 (n1893 n1728 vdd vdd) p12 w=2.4u l=0.13u
MP1898 (n1893 n1881 vdd vdd) p12 w=2.4u l=0.13u
MN1901 (n1899 n1887 n1900 vss) n12 w=1.6u l=0.13u
MN1902 (n1900 n1893 vss vss) n12 w=1.6u l=0.13u
MP1903 (n1899 n1887 vdd vdd) p12 w=2.4u l=0.13u
MP1904 (n1899 n1893 vdd vdd) p12 w=2.4u l=0.13u
MN1906 (delay1905 n596 vss vss) n12 w=0.8u l=0.13u
MP1907 (delay1905 n596 vdd vdd) p12 w=2.4u l=0.13u
MN1909 (delay1908 delay1905 vss vss) n12 w=0.8u l=0.13u
MP1910 (delay1908 delay1905 vdd vdd) p12 w=2.4u l=0.13u
MN1912 (delay1911 delay1908 vss vss) n12 w=0.8u l=0.13u
MP1913 (delay1911 delay1908 vdd vdd) p12 w=2.4u l=0.13u
MN1915 (delay1914 delay1911 vss vss) n12 w=0.8u l=0.13u
MP1916 (delay1914 delay1911 vdd vdd) p12 w=2.4u l=0.13u
MN1918 (delay1917 delay1914 vss vss) n12 w=0.8u l=0.13u
MP1919 (delay1917 delay1914 vdd vdd) p12 w=2.4u l=0.13u
MN1921 (delay1920 delay1917 vss vss) n12 w=0.8u l=0.13u
MP1922 (delay1920 delay1917 vdd vdd) p12 w=2.4u l=0.13u
MN1924 (n1923 n596 vss vss) n12 w=0.8u l=0.13u
MP1925 (n1923 n596 vdd vdd) p12 w=2.4u l=0.13u
MN1927 (n1926 delay1920 vss vss) n12 w=0.8u l=0.13u
MP1928 (n1926 delay1920 vdd vdd) p12 w=2.4u l=0.13u
MN1937 (n1933 n1923 n1934 vss) n12 w=3.2u l=0.13u
MP1938 (n1933 n1923 vdd vdd) p12 w=2.4u l=0.13u
MN1939 (n1934 n1926 n1935 vss) n12 w=3.2u l=0.13u
MP1940 (n1933 n1926 vdd vdd) p12 w=2.4u l=0.13u
MN1941 (n1935 clk_highb1932 n1936 vss) n12 w=3.2u l=0.13u
MP1942 (n1933 clk_highb1932 vdd vdd) p12 w=2.4u l=0.13u
MN1943 (n1936 n1151 vss vss) n12 w=3.2u l=0.13u
MP1944 (n1933 n1151 vdd vdd) p12 w=2.4u l=0.13u
MN1949 (n1945 n596 n1946 vss) n12 w=3.2u l=0.13u
MP1950 (n1945 n596 vdd vdd) p12 w=2.4u l=0.13u
MN1951 (n1946 delay1920 n1947 vss) n12 w=3.2u l=0.13u
MP1952 (n1945 delay1920 vdd vdd) p12 w=2.4u l=0.13u
MN1953 (n1947 clk_lowb1930 n1948 vss) n12 w=3.2u l=0.13u
MP1954 (n1945 clk_lowb1930 vdd vdd) p12 w=2.4u l=0.13u
MN1955 (n1948 n1151 vss vss) n12 w=3.2u l=0.13u
MP1956 (n1945 n1151 vdd vdd) p12 w=2.4u l=0.13u
MN1957 (clk_low1929 n1933 vss vss) n12 w=8u l=0.13u
MP1958 (clk_low1929 n1933 vdd vdd) p12 w=24u l=0.13u
MN1959 (clk_lowb1930 clk_low1929 vss vss) n12 w=8u l=0.13u
MP1960 (clk_lowb1930 clk_low1929 vdd vdd) p12 w=24u l=0.13u
MN1961 (clk_high1931 n1945 vss vss) n12 w=8u l=0.13u
MP1962 (clk_high1931 n1945 vdd vdd) p12 w=24u l=0.13u
MN1963 (clk_highb1932 clk_high1931 vss vss) n12 w=8u l=0.13u
MP1964 (clk_highb1932 clk_high1931 vdd vdd) p12 w=24u l=0.13u
MN1969 (n1755 clk_low1929 storage1968 vss) n12 w=1.2u l=0.13u
MP1970 (n1755 clk_lowb1930 storage1968 vdd) p12 w=3.6u l=0.13u
MN1971 (qm1965 clk_high1931 storage1968 vss) n12 w=1.2u l=0.13u
MP1972 (qm1965 clk_highb1932 storage1968 vdd) p12 w=3.6u l=0.13u
MN1973 (qmb1966 storage1968 vss vss) n12 w=0.5u l=0.13u
MP1974 (qmb1966 storage1968 vdd vdd) p12 w=1.5u l=0.13u
MN1975 (qm1965 qmb1966 vss vss) n12 w=0.5u l=0.13u
MP1976 (qm1965 qmb1966 vdd vdd) p12 w=1.5u l=0.13u
MN1977 (storage1968 reference_count_rst vss vss) n12 w=2u l=0.13u
MN1979 (qm1965 clk_high1931 storage1978 vss) n12 w=1.2u l=0.13u
MP1980 (qm1965 clk_highb1932 storage1978 vdd) p12 w=3.6u l=0.13u
MN1981 (lag_g0 clk_low1929 storage1978 vss) n12 w=1.2u l=0.13u
MP1982 (lag_g0 clk_lowb1930 storage1978 vdd) p12 w=3.6u l=0.13u
MN1983 (qb1967 storage1978 vss vss) n12 w=0.5u l=0.13u
MP1984 (qb1967 storage1978 vdd vdd) p12 w=1.5u l=0.13u
MN1985 (lag_g0 qb1967 vss vss) n12 w=0.5u l=0.13u
MP1986 (lag_g0 qb1967 vdd vdd) p12 w=1.5u l=0.13u
MN1987 (storage1978 reference_count_rst vss vss) n12 w=2u l=0.13u
MN1992 (n1779 clk_low1929 storage1991 vss) n12 w=1.2u l=0.13u
MP1993 (n1779 clk_lowb1930 storage1991 vdd) p12 w=3.6u l=0.13u
MN1994 (qm1988 clk_high1931 storage1991 vss) n12 w=1.2u l=0.13u
MP1995 (qm1988 clk_highb1932 storage1991 vdd) p12 w=3.6u l=0.13u
MN1996 (qmb1989 storage1991 vss vss) n12 w=0.5u l=0.13u
MP1997 (qmb1989 storage1991 vdd vdd) p12 w=1.5u l=0.13u
MN1998 (qm1988 qmb1989 vss vss) n12 w=0.5u l=0.13u
MP1999 (qm1988 qmb1989 vdd vdd) p12 w=1.5u l=0.13u
MN2000 (storage1991 reference_count_rst vss vss) n12 w=2u l=0.13u
MN2002 (qm1988 clk_high1931 storage2001 vss) n12 w=1.2u l=0.13u
MP2003 (qm1988 clk_highb1932 storage2001 vdd) p12 w=3.6u l=0.13u
MN2004 (lag_g1 clk_low1929 storage2001 vss) n12 w=1.2u l=0.13u
MP2005 (lag_g1 clk_lowb1930 storage2001 vdd) p12 w=3.6u l=0.13u
MN2006 (qb1990 storage2001 vss vss) n12 w=0.5u l=0.13u
MP2007 (qb1990 storage2001 vdd vdd) p12 w=1.5u l=0.13u
MN2008 (lag_g1 qb1990 vss vss) n12 w=0.5u l=0.13u
MP2009 (lag_g1 qb1990 vdd vdd) p12 w=1.5u l=0.13u
MN2010 (storage2001 reference_count_rst vss vss) n12 w=2u l=0.13u
MN2015 (n1803 clk_low1929 storage2014 vss) n12 w=1.2u l=0.13u
MP2016 (n1803 clk_lowb1930 storage2014 vdd) p12 w=3.6u l=0.13u
MN2017 (qm2011 clk_high1931 storage2014 vss) n12 w=1.2u l=0.13u
MP2018 (qm2011 clk_highb1932 storage2014 vdd) p12 w=3.6u l=0.13u
MN2019 (qmb2012 storage2014 vss vss) n12 w=0.5u l=0.13u
MP2020 (qmb2012 storage2014 vdd vdd) p12 w=1.5u l=0.13u
MN2021 (qm2011 qmb2012 vss vss) n12 w=0.5u l=0.13u
MP2022 (qm2011 qmb2012 vdd vdd) p12 w=1.5u l=0.13u
MN2023 (storage2014 reference_count_rst vss vss) n12 w=2u l=0.13u
MN2025 (qm2011 clk_high1931 storage2024 vss) n12 w=1.2u l=0.13u
MP2026 (qm2011 clk_highb1932 storage2024 vdd) p12 w=3.6u l=0.13u
MN2027 (lag_g2 clk_low1929 storage2024 vss) n12 w=1.2u l=0.13u
MP2028 (lag_g2 clk_lowb1930 storage2024 vdd) p12 w=3.6u l=0.13u
MN2029 (qb2013 storage2024 vss vss) n12 w=0.5u l=0.13u
MP2030 (qb2013 storage2024 vdd vdd) p12 w=1.5u l=0.13u
MN2031 (lag_g2 qb2013 vss vss) n12 w=0.5u l=0.13u
MP2032 (lag_g2 qb2013 vdd vdd) p12 w=1.5u l=0.13u
MN2033 (storage2024 reference_count_rst vss vss) n12 w=2u l=0.13u
MN2038 (n1827 clk_low1929 storage2037 vss) n12 w=1.2u l=0.13u
MP2039 (n1827 clk_lowb1930 storage2037 vdd) p12 w=3.6u l=0.13u
MN2040 (qm2034 clk_high1931 storage2037 vss) n12 w=1.2u l=0.13u
MP2041 (qm2034 clk_highb1932 storage2037 vdd) p12 w=3.6u l=0.13u
MN2042 (qmb2035 storage2037 vss vss) n12 w=0.5u l=0.13u
MP2043 (qmb2035 storage2037 vdd vdd) p12 w=1.5u l=0.13u
MN2044 (qm2034 qmb2035 vss vss) n12 w=0.5u l=0.13u
MP2045 (qm2034 qmb2035 vdd vdd) p12 w=1.5u l=0.13u
MN2046 (storage2037 reference_count_rst vss vss) n12 w=2u l=0.13u
MN2048 (qm2034 clk_high1931 storage2047 vss) n12 w=1.2u l=0.13u
MP2049 (qm2034 clk_highb1932 storage2047 vdd) p12 w=3.6u l=0.13u
MN2050 (lag_g3 clk_low1929 storage2047 vss) n12 w=1.2u l=0.13u
MP2051 (lag_g3 clk_lowb1930 storage2047 vdd) p12 w=3.6u l=0.13u
MN2052 (qb2036 storage2047 vss vss) n12 w=0.5u l=0.13u
MP2053 (qb2036 storage2047 vdd vdd) p12 w=1.5u l=0.13u
MN2054 (lag_g3 qb2036 vss vss) n12 w=0.5u l=0.13u
MP2055 (lag_g3 qb2036 vdd vdd) p12 w=1.5u l=0.13u
MN2056 (storage2047 reference_count_rst vss vss) n12 w=2u l=0.13u
MN2061 (n1851 clk_low1929 storage2060 vss) n12 w=1.2u l=0.13u
MP2062 (n1851 clk_lowb1930 storage2060 vdd) p12 w=3.6u l=0.13u
MN2063 (qm2057 clk_high1931 storage2060 vss) n12 w=1.2u l=0.13u
MP2064 (qm2057 clk_highb1932 storage2060 vdd) p12 w=3.6u l=0.13u
MN2065 (qmb2058 storage2060 vss vss) n12 w=0.5u l=0.13u
MP2066 (qmb2058 storage2060 vdd vdd) p12 w=1.5u l=0.13u
MN2067 (qm2057 qmb2058 vss vss) n12 w=0.5u l=0.13u
MP2068 (qm2057 qmb2058 vdd vdd) p12 w=1.5u l=0.13u
MN2069 (storage2060 reference_count_rst vss vss) n12 w=2u l=0.13u
MN2071 (qm2057 clk_high1931 storage2070 vss) n12 w=1.2u l=0.13u
MP2072 (qm2057 clk_highb1932 storage2070 vdd) p12 w=3.6u l=0.13u
MN2073 (lag_g4 clk_low1929 storage2070 vss) n12 w=1.2u l=0.13u
MP2074 (lag_g4 clk_lowb1930 storage2070 vdd) p12 w=3.6u l=0.13u
MN2075 (qb2059 storage2070 vss vss) n12 w=0.5u l=0.13u
MP2076 (qb2059 storage2070 vdd vdd) p12 w=1.5u l=0.13u
MN2077 (lag_g4 qb2059 vss vss) n12 w=0.5u l=0.13u
MP2078 (lag_g4 qb2059 vdd vdd) p12 w=1.5u l=0.13u
MN2079 (storage2070 reference_count_rst vss vss) n12 w=2u l=0.13u
MN2084 (n1875 clk_low1929 storage2083 vss) n12 w=1.2u l=0.13u
MP2085 (n1875 clk_lowb1930 storage2083 vdd) p12 w=3.6u l=0.13u
MN2086 (qm2080 clk_high1931 storage2083 vss) n12 w=1.2u l=0.13u
MP2087 (qm2080 clk_highb1932 storage2083 vdd) p12 w=3.6u l=0.13u
MN2088 (qmb2081 storage2083 vss vss) n12 w=0.5u l=0.13u
MP2089 (qmb2081 storage2083 vdd vdd) p12 w=1.5u l=0.13u
MN2090 (qm2080 qmb2081 vss vss) n12 w=0.5u l=0.13u
MP2091 (qm2080 qmb2081 vdd vdd) p12 w=1.5u l=0.13u
MN2092 (storage2083 reference_count_rst vss vss) n12 w=2u l=0.13u
MN2094 (qm2080 clk_high1931 storage2093 vss) n12 w=1.2u l=0.13u
MP2095 (qm2080 clk_highb1932 storage2093 vdd) p12 w=3.6u l=0.13u
MN2096 (lag_g5 clk_low1929 storage2093 vss) n12 w=1.2u l=0.13u
MP2097 (lag_g5 clk_lowb1930 storage2093 vdd) p12 w=3.6u l=0.13u
MN2098 (qb2082 storage2093 vss vss) n12 w=0.5u l=0.13u
MP2099 (qb2082 storage2093 vdd vdd) p12 w=1.5u l=0.13u
MN2100 (lag_g5 qb2082 vss vss) n12 w=0.5u l=0.13u
MP2101 (lag_g5 qb2082 vdd vdd) p12 w=1.5u l=0.13u
MN2102 (storage2093 reference_count_rst vss vss) n12 w=2u l=0.13u
MN2107 (n1899 clk_low1929 storage2106 vss) n12 w=1.2u l=0.13u
MP2108 (n1899 clk_lowb1930 storage2106 vdd) p12 w=3.6u l=0.13u
MN2109 (qm2103 clk_high1931 storage2106 vss) n12 w=1.2u l=0.13u
MP2110 (qm2103 clk_highb1932 storage2106 vdd) p12 w=3.6u l=0.13u
MN2111 (qmb2104 storage2106 vss vss) n12 w=0.5u l=0.13u
MP2112 (qmb2104 storage2106 vdd vdd) p12 w=1.5u l=0.13u
MN2113 (qm2103 qmb2104 vss vss) n12 w=0.5u l=0.13u
MP2114 (qm2103 qmb2104 vdd vdd) p12 w=1.5u l=0.13u
MN2115 (storage2106 reference_count_rst vss vss) n12 w=2u l=0.13u
MN2117 (qm2103 clk_high1931 storage2116 vss) n12 w=1.2u l=0.13u
MP2118 (qm2103 clk_highb1932 storage2116 vdd) p12 w=3.6u l=0.13u
MN2119 (lag_g6 clk_low1929 storage2116 vss) n12 w=1.2u l=0.13u
MP2120 (lag_g6 clk_lowb1930 storage2116 vdd) p12 w=3.6u l=0.13u
MN2121 (qb2105 storage2116 vss vss) n12 w=0.5u l=0.13u
MP2122 (qb2105 storage2116 vdd vdd) p12 w=1.5u l=0.13u
MN2123 (lag_g6 qb2105 vss vss) n12 w=0.5u l=0.13u
MP2124 (lag_g6 qb2105 vdd vdd) p12 w=1.5u l=0.13u
MN2125 (storage2116 reference_count_rst vss vss) n12 w=2u l=0.13u
MN2130 (n1728 clk_low1929 storage2129 vss) n12 w=1.2u l=0.13u
MP2131 (n1728 clk_lowb1930 storage2129 vdd) p12 w=3.6u l=0.13u
MN2132 (qm2126 clk_high1931 storage2129 vss) n12 w=1.2u l=0.13u
MP2133 (qm2126 clk_highb1932 storage2129 vdd) p12 w=3.6u l=0.13u
MN2134 (qmb2127 storage2129 vss vss) n12 w=0.5u l=0.13u
MP2135 (qmb2127 storage2129 vdd vdd) p12 w=1.5u l=0.13u
MN2136 (qm2126 qmb2127 vss vss) n12 w=0.5u l=0.13u
MP2137 (qm2126 qmb2127 vdd vdd) p12 w=1.5u l=0.13u
MN2138 (storage2129 reference_count_rst vss vss) n12 w=2u l=0.13u
MN2140 (qm2126 clk_high1931 storage2139 vss) n12 w=1.2u l=0.13u
MP2141 (qm2126 clk_highb1932 storage2139 vdd) p12 w=3.6u l=0.13u
MN2142 (lag_g7 clk_low1929 storage2139 vss) n12 w=1.2u l=0.13u
MP2143 (lag_g7 clk_lowb1930 storage2139 vdd) p12 w=3.6u l=0.13u
MN2144 (qb2128 storage2139 vss vss) n12 w=0.5u l=0.13u
MP2145 (qb2128 storage2139 vdd vdd) p12 w=1.5u l=0.13u
MN2146 (lag_g7 qb2128 vss vss) n12 w=0.5u l=0.13u
MP2147 (lag_g7 qb2128 vdd vdd) p12 w=1.5u l=0.13u
MN2148 (storage2139 reference_count_rst vss vss) n12 w=2u l=0.13u
MN2151 (n2149 div_g6 n2150 vss) n12 w=1.6u l=0.13u
MN2152 (n2150 div_g7 vss vss) n12 w=1.6u l=0.13u
MP2153 (n2149 div_g6 vdd vdd) p12 w=2.4u l=0.13u
MP2154 (n2149 div_g7 vdd vdd) p12 w=2.4u l=0.13u
MN2157 (n2155 div_g6 n2156 vss) n12 w=1.6u l=0.13u
MN2158 (n2156 n2149 vss vss) n12 w=1.6u l=0.13u
MP2159 (n2155 div_g6 vdd vdd) p12 w=2.4u l=0.13u
MP2160 (n2155 n2149 vdd vdd) p12 w=2.4u l=0.13u
MN2163 (n2161 div_g7 n2162 vss) n12 w=1.6u l=0.13u
MN2164 (n2162 n2149 vss vss) n12 w=1.6u l=0.13u
MP2165 (n2161 div_g7 vdd vdd) p12 w=2.4u l=0.13u
MP2166 (n2161 n2149 vdd vdd) p12 w=2.4u l=0.13u
MN2169 (n2167 n2155 n2168 vss) n12 w=1.6u l=0.13u
MN2170 (n2168 n2161 vss vss) n12 w=1.6u l=0.13u
MP2171 (n2167 n2155 vdd vdd) p12 w=2.4u l=0.13u
MP2172 (n2167 n2161 vdd vdd) p12 w=2.4u l=0.13u
MN2175 (n2173 div_g5 n2174 vss) n12 w=1.6u l=0.13u
MN2176 (n2174 n2167 vss vss) n12 w=1.6u l=0.13u
MP2177 (n2173 div_g5 vdd vdd) p12 w=2.4u l=0.13u
MP2178 (n2173 n2167 vdd vdd) p12 w=2.4u l=0.13u
MN2181 (n2179 div_g5 n2180 vss) n12 w=1.6u l=0.13u
MN2182 (n2180 n2173 vss vss) n12 w=1.6u l=0.13u
MP2183 (n2179 div_g5 vdd vdd) p12 w=2.4u l=0.13u
MP2184 (n2179 n2173 vdd vdd) p12 w=2.4u l=0.13u
MN2187 (n2185 n2167 n2186 vss) n12 w=1.6u l=0.13u
MN2188 (n2186 n2173 vss vss) n12 w=1.6u l=0.13u
MP2189 (n2185 n2167 vdd vdd) p12 w=2.4u l=0.13u
MP2190 (n2185 n2173 vdd vdd) p12 w=2.4u l=0.13u
MN2193 (n2191 n2179 n2192 vss) n12 w=1.6u l=0.13u
MN2194 (n2192 n2185 vss vss) n12 w=1.6u l=0.13u
MP2195 (n2191 n2179 vdd vdd) p12 w=2.4u l=0.13u
MP2196 (n2191 n2185 vdd vdd) p12 w=2.4u l=0.13u
MN2199 (n2197 div_g4 n2198 vss) n12 w=1.6u l=0.13u
MN2200 (n2198 n2191 vss vss) n12 w=1.6u l=0.13u
MP2201 (n2197 div_g4 vdd vdd) p12 w=2.4u l=0.13u
MP2202 (n2197 n2191 vdd vdd) p12 w=2.4u l=0.13u
MN2205 (n2203 div_g4 n2204 vss) n12 w=1.6u l=0.13u
MN2206 (n2204 n2197 vss vss) n12 w=1.6u l=0.13u
MP2207 (n2203 div_g4 vdd vdd) p12 w=2.4u l=0.13u
MP2208 (n2203 n2197 vdd vdd) p12 w=2.4u l=0.13u
MN2211 (n2209 n2191 n2210 vss) n12 w=1.6u l=0.13u
MN2212 (n2210 n2197 vss vss) n12 w=1.6u l=0.13u
MP2213 (n2209 n2191 vdd vdd) p12 w=2.4u l=0.13u
MP2214 (n2209 n2197 vdd vdd) p12 w=2.4u l=0.13u
MN2217 (n2215 n2203 n2216 vss) n12 w=1.6u l=0.13u
MN2218 (n2216 n2209 vss vss) n12 w=1.6u l=0.13u
MP2219 (n2215 n2203 vdd vdd) p12 w=2.4u l=0.13u
MP2220 (n2215 n2209 vdd vdd) p12 w=2.4u l=0.13u
MN2223 (n2221 div_g3 n2222 vss) n12 w=1.6u l=0.13u
MN2224 (n2222 n2215 vss vss) n12 w=1.6u l=0.13u
MP2225 (n2221 div_g3 vdd vdd) p12 w=2.4u l=0.13u
MP2226 (n2221 n2215 vdd vdd) p12 w=2.4u l=0.13u
MN2229 (n2227 div_g3 n2228 vss) n12 w=1.6u l=0.13u
MN2230 (n2228 n2221 vss vss) n12 w=1.6u l=0.13u
MP2231 (n2227 div_g3 vdd vdd) p12 w=2.4u l=0.13u
MP2232 (n2227 n2221 vdd vdd) p12 w=2.4u l=0.13u
MN2235 (n2233 n2215 n2234 vss) n12 w=1.6u l=0.13u
MN2236 (n2234 n2221 vss vss) n12 w=1.6u l=0.13u
MP2237 (n2233 n2215 vdd vdd) p12 w=2.4u l=0.13u
MP2238 (n2233 n2221 vdd vdd) p12 w=2.4u l=0.13u
MN2241 (n2239 n2227 n2240 vss) n12 w=1.6u l=0.13u
MN2242 (n2240 n2233 vss vss) n12 w=1.6u l=0.13u
MP2243 (n2239 n2227 vdd vdd) p12 w=2.4u l=0.13u
MP2244 (n2239 n2233 vdd vdd) p12 w=2.4u l=0.13u
MN2247 (n2245 div_g2 n2246 vss) n12 w=1.6u l=0.13u
MN2248 (n2246 n2239 vss vss) n12 w=1.6u l=0.13u
MP2249 (n2245 div_g2 vdd vdd) p12 w=2.4u l=0.13u
MP2250 (n2245 n2239 vdd vdd) p12 w=2.4u l=0.13u
MN2253 (n2251 div_g2 n2252 vss) n12 w=1.6u l=0.13u
MN2254 (n2252 n2245 vss vss) n12 w=1.6u l=0.13u
MP2255 (n2251 div_g2 vdd vdd) p12 w=2.4u l=0.13u
MP2256 (n2251 n2245 vdd vdd) p12 w=2.4u l=0.13u
MN2259 (n2257 n2239 n2258 vss) n12 w=1.6u l=0.13u
MN2260 (n2258 n2245 vss vss) n12 w=1.6u l=0.13u
MP2261 (n2257 n2239 vdd vdd) p12 w=2.4u l=0.13u
MP2262 (n2257 n2245 vdd vdd) p12 w=2.4u l=0.13u
MN2265 (n2263 n2251 n2264 vss) n12 w=1.6u l=0.13u
MN2266 (n2264 n2257 vss vss) n12 w=1.6u l=0.13u
MP2267 (n2263 n2251 vdd vdd) p12 w=2.4u l=0.13u
MP2268 (n2263 n2257 vdd vdd) p12 w=2.4u l=0.13u
MN2271 (n2269 div_g1 n2270 vss) n12 w=1.6u l=0.13u
MN2272 (n2270 n2263 vss vss) n12 w=1.6u l=0.13u
MP2273 (n2269 div_g1 vdd vdd) p12 w=2.4u l=0.13u
MP2274 (n2269 n2263 vdd vdd) p12 w=2.4u l=0.13u
MN2277 (n2275 div_g1 n2276 vss) n12 w=1.6u l=0.13u
MN2278 (n2276 n2269 vss vss) n12 w=1.6u l=0.13u
MP2279 (n2275 div_g1 vdd vdd) p12 w=2.4u l=0.13u
MP2280 (n2275 n2269 vdd vdd) p12 w=2.4u l=0.13u
MN2283 (n2281 n2263 n2282 vss) n12 w=1.6u l=0.13u
MN2284 (n2282 n2269 vss vss) n12 w=1.6u l=0.13u
MP2285 (n2281 n2263 vdd vdd) p12 w=2.4u l=0.13u
MP2286 (n2281 n2269 vdd vdd) p12 w=2.4u l=0.13u
MN2289 (n2287 n2275 n2288 vss) n12 w=1.6u l=0.13u
MN2290 (n2288 n2281 vss vss) n12 w=1.6u l=0.13u
MP2291 (n2287 n2275 vdd vdd) p12 w=2.4u l=0.13u
MP2292 (n2287 n2281 vdd vdd) p12 w=2.4u l=0.13u
MN2295 (n2293 div_g0 n2294 vss) n12 w=1.6u l=0.13u
MN2296 (n2294 n2287 vss vss) n12 w=1.6u l=0.13u
MP2297 (n2293 div_g0 vdd vdd) p12 w=2.4u l=0.13u
MP2298 (n2293 n2287 vdd vdd) p12 w=2.4u l=0.13u
MN2301 (n2299 div_g0 n2300 vss) n12 w=1.6u l=0.13u
MN2302 (n2300 n2293 vss vss) n12 w=1.6u l=0.13u
MP2303 (n2299 div_g0 vdd vdd) p12 w=2.4u l=0.13u
MP2304 (n2299 n2293 vdd vdd) p12 w=2.4u l=0.13u
MN2307 (n2305 n2287 n2306 vss) n12 w=1.6u l=0.13u
MN2308 (n2306 n2293 vss vss) n12 w=1.6u l=0.13u
MP2309 (n2305 n2287 vdd vdd) p12 w=2.4u l=0.13u
MP2310 (n2305 n2293 vdd vdd) p12 w=2.4u l=0.13u
MN2313 (n2311 n2299 n2312 vss) n12 w=1.6u l=0.13u
MN2314 (n2312 n2305 vss vss) n12 w=1.6u l=0.13u
MP2315 (n2311 n2299 vdd vdd) p12 w=2.4u l=0.13u
MP2316 (n2311 n2305 vdd vdd) p12 w=2.4u l=0.13u
MN2318 (n2317 n2311 vss vss) n12 w=0.8u l=0.13u
MP2319 (n2317 n2311 vdd vdd) p12 w=2.4u l=0.13u
MN2322 (n2320 n2287 n2321 vss) n12 w=1.6u l=0.13u
MN2323 (n2321 n2311 vss vss) n12 w=1.6u l=0.13u
MP2324 (n2320 n2287 vdd vdd) p12 w=2.4u l=0.13u
MP2325 (n2320 n2311 vdd vdd) p12 w=2.4u l=0.13u
MN2328 (n2326 n2287 n2327 vss) n12 w=1.6u l=0.13u
MN2329 (n2327 n2320 vss vss) n12 w=1.6u l=0.13u
MP2330 (n2326 n2287 vdd vdd) p12 w=2.4u l=0.13u
MP2331 (n2326 n2320 vdd vdd) p12 w=2.4u l=0.13u
MN2334 (n2332 n2311 n2333 vss) n12 w=1.6u l=0.13u
MN2335 (n2333 n2320 vss vss) n12 w=1.6u l=0.13u
MP2336 (n2332 n2311 vdd vdd) p12 w=2.4u l=0.13u
MP2337 (n2332 n2320 vdd vdd) p12 w=2.4u l=0.13u
MN2340 (n2338 n2326 n2339 vss) n12 w=1.6u l=0.13u
MN2341 (n2339 n2332 vss vss) n12 w=1.6u l=0.13u
MP2342 (n2338 n2326 vdd vdd) p12 w=2.4u l=0.13u
MP2343 (n2338 n2332 vdd vdd) p12 w=2.4u l=0.13u
MN2345 (n2344 n2320 vss vss) n12 w=0.8u l=0.13u
MP2346 (n2344 n2320 vdd vdd) p12 w=2.4u l=0.13u
MN2349 (n2347 n2263 n2348 vss) n12 w=1.6u l=0.13u
MN2350 (n2348 n2344 vss vss) n12 w=1.6u l=0.13u
MP2351 (n2347 n2263 vdd vdd) p12 w=2.4u l=0.13u
MP2352 (n2347 n2344 vdd vdd) p12 w=2.4u l=0.13u
MN2355 (n2353 n2263 n2354 vss) n12 w=1.6u l=0.13u
MN2356 (n2354 n2347 vss vss) n12 w=1.6u l=0.13u
MP2357 (n2353 n2263 vdd vdd) p12 w=2.4u l=0.13u
MP2358 (n2353 n2347 vdd vdd) p12 w=2.4u l=0.13u
MN2361 (n2359 n2344 n2360 vss) n12 w=1.6u l=0.13u
MN2362 (n2360 n2347 vss vss) n12 w=1.6u l=0.13u
MP2363 (n2359 n2344 vdd vdd) p12 w=2.4u l=0.13u
MP2364 (n2359 n2347 vdd vdd) p12 w=2.4u l=0.13u
MN2367 (n2365 n2353 n2366 vss) n12 w=1.6u l=0.13u
MN2368 (n2366 n2359 vss vss) n12 w=1.6u l=0.13u
MP2369 (n2365 n2353 vdd vdd) p12 w=2.4u l=0.13u
MP2370 (n2365 n2359 vdd vdd) p12 w=2.4u l=0.13u
MN2372 (n2371 n2347 vss vss) n12 w=0.8u l=0.13u
MP2373 (n2371 n2347 vdd vdd) p12 w=2.4u l=0.13u
MN2376 (n2374 n2239 n2375 vss) n12 w=1.6u l=0.13u
MN2377 (n2375 n2371 vss vss) n12 w=1.6u l=0.13u
MP2378 (n2374 n2239 vdd vdd) p12 w=2.4u l=0.13u
MP2379 (n2374 n2371 vdd vdd) p12 w=2.4u l=0.13u
MN2382 (n2380 n2239 n2381 vss) n12 w=1.6u l=0.13u
MN2383 (n2381 n2374 vss vss) n12 w=1.6u l=0.13u
MP2384 (n2380 n2239 vdd vdd) p12 w=2.4u l=0.13u
MP2385 (n2380 n2374 vdd vdd) p12 w=2.4u l=0.13u
MN2388 (n2386 n2371 n2387 vss) n12 w=1.6u l=0.13u
MN2389 (n2387 n2374 vss vss) n12 w=1.6u l=0.13u
MP2390 (n2386 n2371 vdd vdd) p12 w=2.4u l=0.13u
MP2391 (n2386 n2374 vdd vdd) p12 w=2.4u l=0.13u
MN2394 (n2392 n2380 n2393 vss) n12 w=1.6u l=0.13u
MN2395 (n2393 n2386 vss vss) n12 w=1.6u l=0.13u
MP2396 (n2392 n2380 vdd vdd) p12 w=2.4u l=0.13u
MP2397 (n2392 n2386 vdd vdd) p12 w=2.4u l=0.13u
MN2399 (n2398 n2374 vss vss) n12 w=0.8u l=0.13u
MP2400 (n2398 n2374 vdd vdd) p12 w=2.4u l=0.13u
MN2403 (n2401 n2215 n2402 vss) n12 w=1.6u l=0.13u
MN2404 (n2402 n2398 vss vss) n12 w=1.6u l=0.13u
MP2405 (n2401 n2215 vdd vdd) p12 w=2.4u l=0.13u
MP2406 (n2401 n2398 vdd vdd) p12 w=2.4u l=0.13u
MN2409 (n2407 n2215 n2408 vss) n12 w=1.6u l=0.13u
MN2410 (n2408 n2401 vss vss) n12 w=1.6u l=0.13u
MP2411 (n2407 n2215 vdd vdd) p12 w=2.4u l=0.13u
MP2412 (n2407 n2401 vdd vdd) p12 w=2.4u l=0.13u
MN2415 (n2413 n2398 n2414 vss) n12 w=1.6u l=0.13u
MN2416 (n2414 n2401 vss vss) n12 w=1.6u l=0.13u
MP2417 (n2413 n2398 vdd vdd) p12 w=2.4u l=0.13u
MP2418 (n2413 n2401 vdd vdd) p12 w=2.4u l=0.13u
MN2421 (n2419 n2407 n2420 vss) n12 w=1.6u l=0.13u
MN2422 (n2420 n2413 vss vss) n12 w=1.6u l=0.13u
MP2423 (n2419 n2407 vdd vdd) p12 w=2.4u l=0.13u
MP2424 (n2419 n2413 vdd vdd) p12 w=2.4u l=0.13u
MN2426 (n2425 n2401 vss vss) n12 w=0.8u l=0.13u
MP2427 (n2425 n2401 vdd vdd) p12 w=2.4u l=0.13u
MN2430 (n2428 n2191 n2429 vss) n12 w=1.6u l=0.13u
MN2431 (n2429 n2425 vss vss) n12 w=1.6u l=0.13u
MP2432 (n2428 n2191 vdd vdd) p12 w=2.4u l=0.13u
MP2433 (n2428 n2425 vdd vdd) p12 w=2.4u l=0.13u
MN2436 (n2434 n2191 n2435 vss) n12 w=1.6u l=0.13u
MN2437 (n2435 n2428 vss vss) n12 w=1.6u l=0.13u
MP2438 (n2434 n2191 vdd vdd) p12 w=2.4u l=0.13u
MP2439 (n2434 n2428 vdd vdd) p12 w=2.4u l=0.13u
MN2442 (n2440 n2425 n2441 vss) n12 w=1.6u l=0.13u
MN2443 (n2441 n2428 vss vss) n12 w=1.6u l=0.13u
MP2444 (n2440 n2425 vdd vdd) p12 w=2.4u l=0.13u
MP2445 (n2440 n2428 vdd vdd) p12 w=2.4u l=0.13u
MN2448 (n2446 n2434 n2447 vss) n12 w=1.6u l=0.13u
MN2449 (n2447 n2440 vss vss) n12 w=1.6u l=0.13u
MP2450 (n2446 n2434 vdd vdd) p12 w=2.4u l=0.13u
MP2451 (n2446 n2440 vdd vdd) p12 w=2.4u l=0.13u
MN2453 (n2452 n2428 vss vss) n12 w=0.8u l=0.13u
MP2454 (n2452 n2428 vdd vdd) p12 w=2.4u l=0.13u
MN2457 (n2455 n2167 n2456 vss) n12 w=1.6u l=0.13u
MN2458 (n2456 n2452 vss vss) n12 w=1.6u l=0.13u
MP2459 (n2455 n2167 vdd vdd) p12 w=2.4u l=0.13u
MP2460 (n2455 n2452 vdd vdd) p12 w=2.4u l=0.13u
MN2463 (n2461 n2167 n2462 vss) n12 w=1.6u l=0.13u
MN2464 (n2462 n2455 vss vss) n12 w=1.6u l=0.13u
MP2465 (n2461 n2167 vdd vdd) p12 w=2.4u l=0.13u
MP2466 (n2461 n2455 vdd vdd) p12 w=2.4u l=0.13u
MN2469 (n2467 n2452 n2468 vss) n12 w=1.6u l=0.13u
MN2470 (n2468 n2455 vss vss) n12 w=1.6u l=0.13u
MP2471 (n2467 n2452 vdd vdd) p12 w=2.4u l=0.13u
MP2472 (n2467 n2455 vdd vdd) p12 w=2.4u l=0.13u
MN2475 (n2473 n2461 n2474 vss) n12 w=1.6u l=0.13u
MN2476 (n2474 n2467 vss vss) n12 w=1.6u l=0.13u
MP2477 (n2473 n2461 vdd vdd) p12 w=2.4u l=0.13u
MP2478 (n2473 n2467 vdd vdd) p12 w=2.4u l=0.13u
MN2480 (n2479 n2455 vss vss) n12 w=0.8u l=0.13u
MP2481 (n2479 n2455 vdd vdd) p12 w=2.4u l=0.13u
MN2484 (n2482 div_g7 n2483 vss) n12 w=1.6u l=0.13u
MN2485 (n2483 n2479 vss vss) n12 w=1.6u l=0.13u
MP2486 (n2482 div_g7 vdd vdd) p12 w=2.4u l=0.13u
MP2487 (n2482 n2479 vdd vdd) p12 w=2.4u l=0.13u
MN2490 (n2488 div_g7 n2489 vss) n12 w=1.6u l=0.13u
MN2491 (n2489 n2482 vss vss) n12 w=1.6u l=0.13u
MP2492 (n2488 div_g7 vdd vdd) p12 w=2.4u l=0.13u
MP2493 (n2488 n2482 vdd vdd) p12 w=2.4u l=0.13u
MN2496 (n2494 n2479 n2495 vss) n12 w=1.6u l=0.13u
MN2497 (n2495 n2482 vss vss) n12 w=1.6u l=0.13u
MP2498 (n2494 n2479 vdd vdd) p12 w=2.4u l=0.13u
MP2499 (n2494 n2482 vdd vdd) p12 w=2.4u l=0.13u
MN2502 (n2500 n2488 n2501 vss) n12 w=1.6u l=0.13u
MN2503 (n2501 n2494 vss vss) n12 w=1.6u l=0.13u
MP2504 (n2500 n2488 vdd vdd) p12 w=2.4u l=0.13u
MP2505 (n2500 n2494 vdd vdd) p12 w=2.4u l=0.13u
MN2507 (n2506 n2482 vss vss) n12 w=0.8u l=0.13u
MP2508 (n2506 n2482 vdd vdd) p12 w=2.4u l=0.13u
MN2511 (n2509 n2317 n2510 vss) n12 w=1.6u l=0.13u
MN2512 (n2510 n2338 vss vss) n12 w=1.6u l=0.13u
MP2513 (n2509 n2317 vdd vdd) p12 w=2.4u l=0.13u
MP2514 (n2509 n2338 vdd vdd) p12 w=2.4u l=0.13u
MN2517 (n2515 n2317 n2516 vss) n12 w=1.6u l=0.13u
MN2518 (n2516 n2509 vss vss) n12 w=1.6u l=0.13u
MP2519 (n2515 n2317 vdd vdd) p12 w=2.4u l=0.13u
MP2520 (n2515 n2509 vdd vdd) p12 w=2.4u l=0.13u
MN2523 (n2521 n2338 n2522 vss) n12 w=1.6u l=0.13u
MN2524 (n2522 n2509 vss vss) n12 w=1.6u l=0.13u
MP2525 (n2521 n2338 vdd vdd) p12 w=2.4u l=0.13u
MP2526 (n2521 n2509 vdd vdd) p12 w=2.4u l=0.13u
MN2529 (n2527 n2515 n2528 vss) n12 w=1.6u l=0.13u
MN2530 (n2528 n2521 vss vss) n12 w=1.6u l=0.13u
MP2531 (n2527 n2515 vdd vdd) p12 w=2.4u l=0.13u
MP2532 (n2527 n2521 vdd vdd) p12 w=2.4u l=0.13u
MN2535 (n2533 n2338 n2534 vss) n12 w=1.6u l=0.13u
MN2536 (n2534 n2365 vss vss) n12 w=1.6u l=0.13u
MP2537 (n2533 n2338 vdd vdd) p12 w=2.4u l=0.13u
MP2538 (n2533 n2365 vdd vdd) p12 w=2.4u l=0.13u
MN2541 (n2539 n2338 n2540 vss) n12 w=1.6u l=0.13u
MN2542 (n2540 n2533 vss vss) n12 w=1.6u l=0.13u
MP2543 (n2539 n2338 vdd vdd) p12 w=2.4u l=0.13u
MP2544 (n2539 n2533 vdd vdd) p12 w=2.4u l=0.13u
MN2547 (n2545 n2365 n2546 vss) n12 w=1.6u l=0.13u
MN2548 (n2546 n2533 vss vss) n12 w=1.6u l=0.13u
MP2549 (n2545 n2365 vdd vdd) p12 w=2.4u l=0.13u
MP2550 (n2545 n2533 vdd vdd) p12 w=2.4u l=0.13u
MN2553 (n2551 n2539 n2552 vss) n12 w=1.6u l=0.13u
MN2554 (n2552 n2545 vss vss) n12 w=1.6u l=0.13u
MP2555 (n2551 n2539 vdd vdd) p12 w=2.4u l=0.13u
MP2556 (n2551 n2545 vdd vdd) p12 w=2.4u l=0.13u
MN2559 (n2557 n2365 n2558 vss) n12 w=1.6u l=0.13u
MN2560 (n2558 n2392 vss vss) n12 w=1.6u l=0.13u
MP2561 (n2557 n2365 vdd vdd) p12 w=2.4u l=0.13u
MP2562 (n2557 n2392 vdd vdd) p12 w=2.4u l=0.13u
MN2565 (n2563 n2365 n2564 vss) n12 w=1.6u l=0.13u
MN2566 (n2564 n2557 vss vss) n12 w=1.6u l=0.13u
MP2567 (n2563 n2365 vdd vdd) p12 w=2.4u l=0.13u
MP2568 (n2563 n2557 vdd vdd) p12 w=2.4u l=0.13u
MN2571 (n2569 n2392 n2570 vss) n12 w=1.6u l=0.13u
MN2572 (n2570 n2557 vss vss) n12 w=1.6u l=0.13u
MP2573 (n2569 n2392 vdd vdd) p12 w=2.4u l=0.13u
MP2574 (n2569 n2557 vdd vdd) p12 w=2.4u l=0.13u
MN2577 (n2575 n2563 n2576 vss) n12 w=1.6u l=0.13u
MN2578 (n2576 n2569 vss vss) n12 w=1.6u l=0.13u
MP2579 (n2575 n2563 vdd vdd) p12 w=2.4u l=0.13u
MP2580 (n2575 n2569 vdd vdd) p12 w=2.4u l=0.13u
MN2583 (n2581 n2392 n2582 vss) n12 w=1.6u l=0.13u
MN2584 (n2582 n2419 vss vss) n12 w=1.6u l=0.13u
MP2585 (n2581 n2392 vdd vdd) p12 w=2.4u l=0.13u
MP2586 (n2581 n2419 vdd vdd) p12 w=2.4u l=0.13u
MN2589 (n2587 n2392 n2588 vss) n12 w=1.6u l=0.13u
MN2590 (n2588 n2581 vss vss) n12 w=1.6u l=0.13u
MP2591 (n2587 n2392 vdd vdd) p12 w=2.4u l=0.13u
MP2592 (n2587 n2581 vdd vdd) p12 w=2.4u l=0.13u
MN2595 (n2593 n2419 n2594 vss) n12 w=1.6u l=0.13u
MN2596 (n2594 n2581 vss vss) n12 w=1.6u l=0.13u
MP2597 (n2593 n2419 vdd vdd) p12 w=2.4u l=0.13u
MP2598 (n2593 n2581 vdd vdd) p12 w=2.4u l=0.13u
MN2601 (n2599 n2587 n2600 vss) n12 w=1.6u l=0.13u
MN2602 (n2600 n2593 vss vss) n12 w=1.6u l=0.13u
MP2603 (n2599 n2587 vdd vdd) p12 w=2.4u l=0.13u
MP2604 (n2599 n2593 vdd vdd) p12 w=2.4u l=0.13u
MN2607 (n2605 n2419 n2606 vss) n12 w=1.6u l=0.13u
MN2608 (n2606 n2446 vss vss) n12 w=1.6u l=0.13u
MP2609 (n2605 n2419 vdd vdd) p12 w=2.4u l=0.13u
MP2610 (n2605 n2446 vdd vdd) p12 w=2.4u l=0.13u
MN2613 (n2611 n2419 n2612 vss) n12 w=1.6u l=0.13u
MN2614 (n2612 n2605 vss vss) n12 w=1.6u l=0.13u
MP2615 (n2611 n2419 vdd vdd) p12 w=2.4u l=0.13u
MP2616 (n2611 n2605 vdd vdd) p12 w=2.4u l=0.13u
MN2619 (n2617 n2446 n2618 vss) n12 w=1.6u l=0.13u
MN2620 (n2618 n2605 vss vss) n12 w=1.6u l=0.13u
MP2621 (n2617 n2446 vdd vdd) p12 w=2.4u l=0.13u
MP2622 (n2617 n2605 vdd vdd) p12 w=2.4u l=0.13u
MN2625 (n2623 n2611 n2624 vss) n12 w=1.6u l=0.13u
MN2626 (n2624 n2617 vss vss) n12 w=1.6u l=0.13u
MP2627 (n2623 n2611 vdd vdd) p12 w=2.4u l=0.13u
MP2628 (n2623 n2617 vdd vdd) p12 w=2.4u l=0.13u
MN2631 (n2629 n2446 n2630 vss) n12 w=1.6u l=0.13u
MN2632 (n2630 n2473 vss vss) n12 w=1.6u l=0.13u
MP2633 (n2629 n2446 vdd vdd) p12 w=2.4u l=0.13u
MP2634 (n2629 n2473 vdd vdd) p12 w=2.4u l=0.13u
MN2637 (n2635 n2446 n2636 vss) n12 w=1.6u l=0.13u
MN2638 (n2636 n2629 vss vss) n12 w=1.6u l=0.13u
MP2639 (n2635 n2446 vdd vdd) p12 w=2.4u l=0.13u
MP2640 (n2635 n2629 vdd vdd) p12 w=2.4u l=0.13u
MN2643 (n2641 n2473 n2642 vss) n12 w=1.6u l=0.13u
MN2644 (n2642 n2629 vss vss) n12 w=1.6u l=0.13u
MP2645 (n2641 n2473 vdd vdd) p12 w=2.4u l=0.13u
MP2646 (n2641 n2629 vdd vdd) p12 w=2.4u l=0.13u
MN2649 (n2647 n2635 n2648 vss) n12 w=1.6u l=0.13u
MN2650 (n2648 n2641 vss vss) n12 w=1.6u l=0.13u
MP2651 (n2647 n2635 vdd vdd) p12 w=2.4u l=0.13u
MP2652 (n2647 n2641 vdd vdd) p12 w=2.4u l=0.13u
MN2655 (n2653 n2473 n2654 vss) n12 w=1.6u l=0.13u
MN2656 (n2654 n2500 vss vss) n12 w=1.6u l=0.13u
MP2657 (n2653 n2473 vdd vdd) p12 w=2.4u l=0.13u
MP2658 (n2653 n2500 vdd vdd) p12 w=2.4u l=0.13u
MN2661 (n2659 n2473 n2660 vss) n12 w=1.6u l=0.13u
MN2662 (n2660 n2653 vss vss) n12 w=1.6u l=0.13u
MP2663 (n2659 n2473 vdd vdd) p12 w=2.4u l=0.13u
MP2664 (n2659 n2653 vdd vdd) p12 w=2.4u l=0.13u
MN2667 (n2665 n2500 n2666 vss) n12 w=1.6u l=0.13u
MN2668 (n2666 n2653 vss vss) n12 w=1.6u l=0.13u
MP2669 (n2665 n2500 vdd vdd) p12 w=2.4u l=0.13u
MP2670 (n2665 n2653 vdd vdd) p12 w=2.4u l=0.13u
MN2673 (n2671 n2659 n2672 vss) n12 w=1.6u l=0.13u
MN2674 (n2672 n2665 vss vss) n12 w=1.6u l=0.13u
MP2675 (n2671 n2659 vdd vdd) p12 w=2.4u l=0.13u
MP2676 (n2671 n2665 vdd vdd) p12 w=2.4u l=0.13u
MN2681 (n2527 clk_low340 storage2680 vss) n12 w=1.2u l=0.13u
MP2682 (n2527 clk_lowb341 storage2680 vdd) p12 w=3.6u l=0.13u
MN2683 (qm2677 clk_high342 storage2680 vss) n12 w=1.2u l=0.13u
MP2684 (qm2677 clk_highb343 storage2680 vdd) p12 w=3.6u l=0.13u
MN2685 (qmb2678 storage2680 vss vss) n12 w=0.5u l=0.13u
MP2686 (qmb2678 storage2680 vdd vdd) p12 w=1.5u l=0.13u
MN2687 (qm2677 qmb2678 vss vss) n12 w=0.5u l=0.13u
MP2688 (qm2677 qmb2678 vdd vdd) p12 w=1.5u l=0.13u
MN2689 (storage2680 count_rst vss vss) n12 w=2u l=0.13u
MN2691 (qm2677 clk_high342 storage2690 vss) n12 w=1.2u l=0.13u
MP2692 (qm2677 clk_highb343 storage2690 vdd) p12 w=3.6u l=0.13u
MN2693 (div_g0 clk_low340 storage2690 vss) n12 w=1.2u l=0.13u
MP2694 (div_g0 clk_lowb341 storage2690 vdd) p12 w=3.6u l=0.13u
MN2695 (qb2679 storage2690 vss vss) n12 w=0.5u l=0.13u
MP2696 (qb2679 storage2690 vdd vdd) p12 w=1.5u l=0.13u
MN2697 (div_g0 qb2679 vss vss) n12 w=0.5u l=0.13u
MP2698 (div_g0 qb2679 vdd vdd) p12 w=1.5u l=0.13u
MN2699 (storage2690 count_rst vss vss) n12 w=2u l=0.13u
MN2704 (n2551 clk_low340 storage2703 vss) n12 w=1.2u l=0.13u
MP2705 (n2551 clk_lowb341 storage2703 vdd) p12 w=3.6u l=0.13u
MN2706 (qm2700 clk_high342 storage2703 vss) n12 w=1.2u l=0.13u
MP2707 (qm2700 clk_highb343 storage2703 vdd) p12 w=3.6u l=0.13u
MN2708 (qmb2701 storage2703 vss vss) n12 w=0.5u l=0.13u
MP2709 (qmb2701 storage2703 vdd vdd) p12 w=1.5u l=0.13u
MN2710 (qm2700 qmb2701 vss vss) n12 w=0.5u l=0.13u
MP2711 (qm2700 qmb2701 vdd vdd) p12 w=1.5u l=0.13u
MN2712 (storage2703 count_rst vss vss) n12 w=2u l=0.13u
MN2714 (qm2700 clk_high342 storage2713 vss) n12 w=1.2u l=0.13u
MP2715 (qm2700 clk_highb343 storage2713 vdd) p12 w=3.6u l=0.13u
MN2716 (div_g1 clk_low340 storage2713 vss) n12 w=1.2u l=0.13u
MP2717 (div_g1 clk_lowb341 storage2713 vdd) p12 w=3.6u l=0.13u
MN2718 (qb2702 storage2713 vss vss) n12 w=0.5u l=0.13u
MP2719 (qb2702 storage2713 vdd vdd) p12 w=1.5u l=0.13u
MN2720 (div_g1 qb2702 vss vss) n12 w=0.5u l=0.13u
MP2721 (div_g1 qb2702 vdd vdd) p12 w=1.5u l=0.13u
MN2722 (storage2713 count_rst vss vss) n12 w=2u l=0.13u
MN2727 (n2575 clk_low340 storage2726 vss) n12 w=1.2u l=0.13u
MP2728 (n2575 clk_lowb341 storage2726 vdd) p12 w=3.6u l=0.13u
MN2729 (qm2723 clk_high342 storage2726 vss) n12 w=1.2u l=0.13u
MP2730 (qm2723 clk_highb343 storage2726 vdd) p12 w=3.6u l=0.13u
MN2731 (qmb2724 storage2726 vss vss) n12 w=0.5u l=0.13u
MP2732 (qmb2724 storage2726 vdd vdd) p12 w=1.5u l=0.13u
MN2733 (qm2723 qmb2724 vss vss) n12 w=0.5u l=0.13u
MP2734 (qm2723 qmb2724 vdd vdd) p12 w=1.5u l=0.13u
MN2735 (storage2726 count_rst vss vss) n12 w=2u l=0.13u
MN2737 (qm2723 clk_high342 storage2736 vss) n12 w=1.2u l=0.13u
MP2738 (qm2723 clk_highb343 storage2736 vdd) p12 w=3.6u l=0.13u
MN2739 (div_g2 clk_low340 storage2736 vss) n12 w=1.2u l=0.13u
MP2740 (div_g2 clk_lowb341 storage2736 vdd) p12 w=3.6u l=0.13u
MN2741 (qb2725 storage2736 vss vss) n12 w=0.5u l=0.13u
MP2742 (qb2725 storage2736 vdd vdd) p12 w=1.5u l=0.13u
MN2743 (div_g2 qb2725 vss vss) n12 w=0.5u l=0.13u
MP2744 (div_g2 qb2725 vdd vdd) p12 w=1.5u l=0.13u
MN2745 (storage2736 count_rst vss vss) n12 w=2u l=0.13u
MN2750 (n2599 clk_low340 storage2749 vss) n12 w=1.2u l=0.13u
MP2751 (n2599 clk_lowb341 storage2749 vdd) p12 w=3.6u l=0.13u
MN2752 (qm2746 clk_high342 storage2749 vss) n12 w=1.2u l=0.13u
MP2753 (qm2746 clk_highb343 storage2749 vdd) p12 w=3.6u l=0.13u
MN2754 (qmb2747 storage2749 vss vss) n12 w=0.5u l=0.13u
MP2755 (qmb2747 storage2749 vdd vdd) p12 w=1.5u l=0.13u
MN2756 (qm2746 qmb2747 vss vss) n12 w=0.5u l=0.13u
MP2757 (qm2746 qmb2747 vdd vdd) p12 w=1.5u l=0.13u
MN2758 (storage2749 count_rst vss vss) n12 w=2u l=0.13u
MN2760 (qm2746 clk_high342 storage2759 vss) n12 w=1.2u l=0.13u
MP2761 (qm2746 clk_highb343 storage2759 vdd) p12 w=3.6u l=0.13u
MN2762 (div_g3 clk_low340 storage2759 vss) n12 w=1.2u l=0.13u
MP2763 (div_g3 clk_lowb341 storage2759 vdd) p12 w=3.6u l=0.13u
MN2764 (qb2748 storage2759 vss vss) n12 w=0.5u l=0.13u
MP2765 (qb2748 storage2759 vdd vdd) p12 w=1.5u l=0.13u
MN2766 (div_g3 qb2748 vss vss) n12 w=0.5u l=0.13u
MP2767 (div_g3 qb2748 vdd vdd) p12 w=1.5u l=0.13u
MN2768 (storage2759 count_rst vss vss) n12 w=2u l=0.13u
MN2773 (n2623 clk_low340 storage2772 vss) n12 w=1.2u l=0.13u
MP2774 (n2623 clk_lowb341 storage2772 vdd) p12 w=3.6u l=0.13u
MN2775 (qm2769 clk_high342 storage2772 vss) n12 w=1.2u l=0.13u
MP2776 (qm2769 clk_highb343 storage2772 vdd) p12 w=3.6u l=0.13u
MN2777 (qmb2770 storage2772 vss vss) n12 w=0.5u l=0.13u
MP2778 (qmb2770 storage2772 vdd vdd) p12 w=1.5u l=0.13u
MN2779 (qm2769 qmb2770 vss vss) n12 w=0.5u l=0.13u
MP2780 (qm2769 qmb2770 vdd vdd) p12 w=1.5u l=0.13u
MN2781 (storage2772 count_rst vss vss) n12 w=2u l=0.13u
MN2783 (qm2769 clk_high342 storage2782 vss) n12 w=1.2u l=0.13u
MP2784 (qm2769 clk_highb343 storage2782 vdd) p12 w=3.6u l=0.13u
MN2785 (div_g4 clk_low340 storage2782 vss) n12 w=1.2u l=0.13u
MP2786 (div_g4 clk_lowb341 storage2782 vdd) p12 w=3.6u l=0.13u
MN2787 (qb2771 storage2782 vss vss) n12 w=0.5u l=0.13u
MP2788 (qb2771 storage2782 vdd vdd) p12 w=1.5u l=0.13u
MN2789 (div_g4 qb2771 vss vss) n12 w=0.5u l=0.13u
MP2790 (div_g4 qb2771 vdd vdd) p12 w=1.5u l=0.13u
MN2791 (storage2782 count_rst vss vss) n12 w=2u l=0.13u
MN2796 (n2647 clk_low340 storage2795 vss) n12 w=1.2u l=0.13u
MP2797 (n2647 clk_lowb341 storage2795 vdd) p12 w=3.6u l=0.13u
MN2798 (qm2792 clk_high342 storage2795 vss) n12 w=1.2u l=0.13u
MP2799 (qm2792 clk_highb343 storage2795 vdd) p12 w=3.6u l=0.13u
MN2800 (qmb2793 storage2795 vss vss) n12 w=0.5u l=0.13u
MP2801 (qmb2793 storage2795 vdd vdd) p12 w=1.5u l=0.13u
MN2802 (qm2792 qmb2793 vss vss) n12 w=0.5u l=0.13u
MP2803 (qm2792 qmb2793 vdd vdd) p12 w=1.5u l=0.13u
MN2804 (storage2795 count_rst vss vss) n12 w=2u l=0.13u
MN2806 (qm2792 clk_high342 storage2805 vss) n12 w=1.2u l=0.13u
MP2807 (qm2792 clk_highb343 storage2805 vdd) p12 w=3.6u l=0.13u
MN2808 (div_g5 clk_low340 storage2805 vss) n12 w=1.2u l=0.13u
MP2809 (div_g5 clk_lowb341 storage2805 vdd) p12 w=3.6u l=0.13u
MN2810 (qb2794 storage2805 vss vss) n12 w=0.5u l=0.13u
MP2811 (qb2794 storage2805 vdd vdd) p12 w=1.5u l=0.13u
MN2812 (div_g5 qb2794 vss vss) n12 w=0.5u l=0.13u
MP2813 (div_g5 qb2794 vdd vdd) p12 w=1.5u l=0.13u
MN2814 (storage2805 count_rst vss vss) n12 w=2u l=0.13u
MN2819 (n2671 clk_low340 storage2818 vss) n12 w=1.2u l=0.13u
MP2820 (n2671 clk_lowb341 storage2818 vdd) p12 w=3.6u l=0.13u
MN2821 (qm2815 clk_high342 storage2818 vss) n12 w=1.2u l=0.13u
MP2822 (qm2815 clk_highb343 storage2818 vdd) p12 w=3.6u l=0.13u
MN2823 (qmb2816 storage2818 vss vss) n12 w=0.5u l=0.13u
MP2824 (qmb2816 storage2818 vdd vdd) p12 w=1.5u l=0.13u
MN2825 (qm2815 qmb2816 vss vss) n12 w=0.5u l=0.13u
MP2826 (qm2815 qmb2816 vdd vdd) p12 w=1.5u l=0.13u
MN2827 (storage2818 count_rst vss vss) n12 w=2u l=0.13u
MN2829 (qm2815 clk_high342 storage2828 vss) n12 w=1.2u l=0.13u
MP2830 (qm2815 clk_highb343 storage2828 vdd) p12 w=3.6u l=0.13u
MN2831 (div_g6 clk_low340 storage2828 vss) n12 w=1.2u l=0.13u
MP2832 (div_g6 clk_lowb341 storage2828 vdd) p12 w=3.6u l=0.13u
MN2833 (qb2817 storage2828 vss vss) n12 w=0.5u l=0.13u
MP2834 (qb2817 storage2828 vdd vdd) p12 w=1.5u l=0.13u
MN2835 (div_g6 qb2817 vss vss) n12 w=0.5u l=0.13u
MP2836 (div_g6 qb2817 vdd vdd) p12 w=1.5u l=0.13u
MN2837 (storage2828 count_rst vss vss) n12 w=2u l=0.13u
MN2842 (n2500 clk_low340 storage2841 vss) n12 w=1.2u l=0.13u
MP2843 (n2500 clk_lowb341 storage2841 vdd) p12 w=3.6u l=0.13u
MN2844 (qm2838 clk_high342 storage2841 vss) n12 w=1.2u l=0.13u
MP2845 (qm2838 clk_highb343 storage2841 vdd) p12 w=3.6u l=0.13u
MN2846 (qmb2839 storage2841 vss vss) n12 w=0.5u l=0.13u
MP2847 (qmb2839 storage2841 vdd vdd) p12 w=1.5u l=0.13u
MN2848 (qm2838 qmb2839 vss vss) n12 w=0.5u l=0.13u
MP2849 (qm2838 qmb2839 vdd vdd) p12 w=1.5u l=0.13u
MN2850 (storage2841 count_rst vss vss) n12 w=2u l=0.13u
MN2852 (qm2838 clk_high342 storage2851 vss) n12 w=1.2u l=0.13u
MP2853 (qm2838 clk_highb343 storage2851 vdd) p12 w=3.6u l=0.13u
MN2854 (div_g7 clk_low340 storage2851 vss) n12 w=1.2u l=0.13u
MP2855 (div_g7 clk_lowb341 storage2851 vdd) p12 w=3.6u l=0.13u
MN2856 (qb2840 storage2851 vss vss) n12 w=0.5u l=0.13u
MP2857 (qb2840 storage2851 vdd vdd) p12 w=1.5u l=0.13u
MN2858 (div_g7 qb2840 vss vss) n12 w=0.5u l=0.13u
MP2859 (div_g7 qb2840 vdd vdd) p12 w=1.5u l=0.13u
MN2860 (storage2851 count_rst vss vss) n12 w=2u l=0.13u
MN2869 (n2865 n22 n2866 vss) n12 w=3.2u l=0.13u
MP2870 (n2865 n22 vdd vdd) p12 w=2.4u l=0.13u
MN2871 (n2866 n102 n2867 vss) n12 w=3.2u l=0.13u
MP2872 (n2865 n102 vdd vdd) p12 w=2.4u l=0.13u
MN2873 (n2867 clk_highb2864 n2868 vss) n12 w=3.2u l=0.13u
MP2874 (n2865 clk_highb2864 vdd vdd) p12 w=2.4u l=0.13u
MN2875 (n2868 n337 vss vss) n12 w=3.2u l=0.13u
MP2876 (n2865 n337 vdd vdd) p12 w=2.4u l=0.13u
MN2881 (n2877 n19 n2878 vss) n12 w=3.2u l=0.13u
MP2882 (n2877 n19 vdd vdd) p12 w=2.4u l=0.13u
MN2883 (n2878 delay99 n2879 vss) n12 w=3.2u l=0.13u
MP2884 (n2877 delay99 vdd vdd) p12 w=2.4u l=0.13u
MN2885 (n2879 clk_lowb2862 n2880 vss) n12 w=3.2u l=0.13u
MP2886 (n2877 clk_lowb2862 vdd vdd) p12 w=2.4u l=0.13u
MN2887 (n2880 n337 vss vss) n12 w=3.2u l=0.13u
MP2888 (n2877 n337 vdd vdd) p12 w=2.4u l=0.13u
MN2889 (clk_low2861 n2865 vss vss) n12 w=8u l=0.13u
MP2890 (clk_low2861 n2865 vdd vdd) p12 w=24u l=0.13u
MN2891 (clk_lowb2862 clk_low2861 vss vss) n12 w=8u l=0.13u
MP2892 (clk_lowb2862 clk_low2861 vdd vdd) p12 w=24u l=0.13u
MN2893 (clk_high2863 n2877 vss vss) n12 w=8u l=0.13u
MP2894 (clk_high2863 n2877 vdd vdd) p12 w=24u l=0.13u
MN2895 (clk_highb2864 clk_high2863 vss vss) n12 w=8u l=0.13u
MP2896 (clk_highb2864 clk_high2863 vdd vdd) p12 w=24u l=0.13u
MN2901 (lead_g0 clk_low2861 storage2900 vss) n12 w=1.2u l=0.13u
MP2902 (lead_g0 clk_lowb2862 storage2900 vdd) p12 w=3.6u l=0.13u
MN2903 (qm2897 clk_high2863 storage2900 vss) n12 w=1.2u l=0.13u
MP2904 (qm2897 clk_highb2864 storage2900 vdd) p12 w=3.6u l=0.13u
MN2905 (qmb2898 storage2900 vss vss) n12 w=0.5u l=0.13u
MP2906 (qmb2898 storage2900 vdd vdd) p12 w=1.5u l=0.13u
MN2907 (qm2897 qmb2898 vss vss) n12 w=0.5u l=0.13u
MP2908 (qm2897 qmb2898 vdd vdd) p12 w=1.5u l=0.13u
MN2909 (storage2900 count_rst vss vss) n12 w=2u l=0.13u
MN2911 (qm2897 clk_high2863 storage2910 vss) n12 w=1.2u l=0.13u
MP2912 (qm2897 clk_highb2864 storage2910 vdd) p12 w=3.6u l=0.13u
MN2913 (lead_sync1_0 clk_low2861 storage2910 vss) n12 w=1.2u l=0.13u
MP2914 (lead_sync1_0 clk_lowb2862 storage2910 vdd) p12 w=3.6u l=0.13u
MN2915 (qb2899 storage2910 vss vss) n12 w=0.5u l=0.13u
MP2916 (qb2899 storage2910 vdd vdd) p12 w=1.5u l=0.13u
MN2917 (lead_sync1_0 qb2899 vss vss) n12 w=0.5u l=0.13u
MP2918 (lead_sync1_0 qb2899 vdd vdd) p12 w=1.5u l=0.13u
MN2919 (storage2910 count_rst vss vss) n12 w=2u l=0.13u
MN2924 (lead_sync1_0 clk_low2861 storage2923 vss) n12 w=1.2u l=0.13u
MP2925 (lead_sync1_0 clk_lowb2862 storage2923 vdd) p12 w=3.6u l=0.13u
MN2926 (qm2920 clk_high2863 storage2923 vss) n12 w=1.2u l=0.13u
MP2927 (qm2920 clk_highb2864 storage2923 vdd) p12 w=3.6u l=0.13u
MN2928 (qmb2921 storage2923 vss vss) n12 w=0.5u l=0.13u
MP2929 (qmb2921 storage2923 vdd vdd) p12 w=1.5u l=0.13u
MN2930 (qm2920 qmb2921 vss vss) n12 w=0.5u l=0.13u
MP2931 (qm2920 qmb2921 vdd vdd) p12 w=1.5u l=0.13u
MN2932 (storage2923 count_rst vss vss) n12 w=2u l=0.13u
MN2934 (qm2920 clk_high2863 storage2933 vss) n12 w=1.2u l=0.13u
MP2935 (qm2920 clk_highb2864 storage2933 vdd) p12 w=3.6u l=0.13u
MN2936 (lead_sync2_0 clk_low2861 storage2933 vss) n12 w=1.2u l=0.13u
MP2937 (lead_sync2_0 clk_lowb2862 storage2933 vdd) p12 w=3.6u l=0.13u
MN2938 (qb2922 storage2933 vss vss) n12 w=0.5u l=0.13u
MP2939 (qb2922 storage2933 vdd vdd) p12 w=1.5u l=0.13u
MN2940 (lead_sync2_0 qb2922 vss vss) n12 w=0.5u l=0.13u
MP2941 (lead_sync2_0 qb2922 vdd vdd) p12 w=1.5u l=0.13u
MN2942 (storage2933 count_rst vss vss) n12 w=2u l=0.13u
MN2947 (lead_g1 clk_low2861 storage2946 vss) n12 w=1.2u l=0.13u
MP2948 (lead_g1 clk_lowb2862 storage2946 vdd) p12 w=3.6u l=0.13u
MN2949 (qm2943 clk_high2863 storage2946 vss) n12 w=1.2u l=0.13u
MP2950 (qm2943 clk_highb2864 storage2946 vdd) p12 w=3.6u l=0.13u
MN2951 (qmb2944 storage2946 vss vss) n12 w=0.5u l=0.13u
MP2952 (qmb2944 storage2946 vdd vdd) p12 w=1.5u l=0.13u
MN2953 (qm2943 qmb2944 vss vss) n12 w=0.5u l=0.13u
MP2954 (qm2943 qmb2944 vdd vdd) p12 w=1.5u l=0.13u
MN2955 (storage2946 count_rst vss vss) n12 w=2u l=0.13u
MN2957 (qm2943 clk_high2863 storage2956 vss) n12 w=1.2u l=0.13u
MP2958 (qm2943 clk_highb2864 storage2956 vdd) p12 w=3.6u l=0.13u
MN2959 (lead_sync1_1 clk_low2861 storage2956 vss) n12 w=1.2u l=0.13u
MP2960 (lead_sync1_1 clk_lowb2862 storage2956 vdd) p12 w=3.6u l=0.13u
MN2961 (qb2945 storage2956 vss vss) n12 w=0.5u l=0.13u
MP2962 (qb2945 storage2956 vdd vdd) p12 w=1.5u l=0.13u
MN2963 (lead_sync1_1 qb2945 vss vss) n12 w=0.5u l=0.13u
MP2964 (lead_sync1_1 qb2945 vdd vdd) p12 w=1.5u l=0.13u
MN2965 (storage2956 count_rst vss vss) n12 w=2u l=0.13u
MN2970 (lead_sync1_1 clk_low2861 storage2969 vss) n12 w=1.2u l=0.13u
MP2971 (lead_sync1_1 clk_lowb2862 storage2969 vdd) p12 w=3.6u l=0.13u
MN2972 (qm2966 clk_high2863 storage2969 vss) n12 w=1.2u l=0.13u
MP2973 (qm2966 clk_highb2864 storage2969 vdd) p12 w=3.6u l=0.13u
MN2974 (qmb2967 storage2969 vss vss) n12 w=0.5u l=0.13u
MP2975 (qmb2967 storage2969 vdd vdd) p12 w=1.5u l=0.13u
MN2976 (qm2966 qmb2967 vss vss) n12 w=0.5u l=0.13u
MP2977 (qm2966 qmb2967 vdd vdd) p12 w=1.5u l=0.13u
MN2978 (storage2969 count_rst vss vss) n12 w=2u l=0.13u
MN2980 (qm2966 clk_high2863 storage2979 vss) n12 w=1.2u l=0.13u
MP2981 (qm2966 clk_highb2864 storage2979 vdd) p12 w=3.6u l=0.13u
MN2982 (lead_sync2_1 clk_low2861 storage2979 vss) n12 w=1.2u l=0.13u
MP2983 (lead_sync2_1 clk_lowb2862 storage2979 vdd) p12 w=3.6u l=0.13u
MN2984 (qb2968 storage2979 vss vss) n12 w=0.5u l=0.13u
MP2985 (qb2968 storage2979 vdd vdd) p12 w=1.5u l=0.13u
MN2986 (lead_sync2_1 qb2968 vss vss) n12 w=0.5u l=0.13u
MP2987 (lead_sync2_1 qb2968 vdd vdd) p12 w=1.5u l=0.13u
MN2988 (storage2979 count_rst vss vss) n12 w=2u l=0.13u
MN2993 (lead_g2 clk_low2861 storage2992 vss) n12 w=1.2u l=0.13u
MP2994 (lead_g2 clk_lowb2862 storage2992 vdd) p12 w=3.6u l=0.13u
MN2995 (qm2989 clk_high2863 storage2992 vss) n12 w=1.2u l=0.13u
MP2996 (qm2989 clk_highb2864 storage2992 vdd) p12 w=3.6u l=0.13u
MN2997 (qmb2990 storage2992 vss vss) n12 w=0.5u l=0.13u
MP2998 (qmb2990 storage2992 vdd vdd) p12 w=1.5u l=0.13u
MN2999 (qm2989 qmb2990 vss vss) n12 w=0.5u l=0.13u
MP3000 (qm2989 qmb2990 vdd vdd) p12 w=1.5u l=0.13u
MN3001 (storage2992 count_rst vss vss) n12 w=2u l=0.13u
MN3003 (qm2989 clk_high2863 storage3002 vss) n12 w=1.2u l=0.13u
MP3004 (qm2989 clk_highb2864 storage3002 vdd) p12 w=3.6u l=0.13u
MN3005 (lead_sync1_2 clk_low2861 storage3002 vss) n12 w=1.2u l=0.13u
MP3006 (lead_sync1_2 clk_lowb2862 storage3002 vdd) p12 w=3.6u l=0.13u
MN3007 (qb2991 storage3002 vss vss) n12 w=0.5u l=0.13u
MP3008 (qb2991 storage3002 vdd vdd) p12 w=1.5u l=0.13u
MN3009 (lead_sync1_2 qb2991 vss vss) n12 w=0.5u l=0.13u
MP3010 (lead_sync1_2 qb2991 vdd vdd) p12 w=1.5u l=0.13u
MN3011 (storage3002 count_rst vss vss) n12 w=2u l=0.13u
MN3016 (lead_sync1_2 clk_low2861 storage3015 vss) n12 w=1.2u l=0.13u
MP3017 (lead_sync1_2 clk_lowb2862 storage3015 vdd) p12 w=3.6u l=0.13u
MN3018 (qm3012 clk_high2863 storage3015 vss) n12 w=1.2u l=0.13u
MP3019 (qm3012 clk_highb2864 storage3015 vdd) p12 w=3.6u l=0.13u
MN3020 (qmb3013 storage3015 vss vss) n12 w=0.5u l=0.13u
MP3021 (qmb3013 storage3015 vdd vdd) p12 w=1.5u l=0.13u
MN3022 (qm3012 qmb3013 vss vss) n12 w=0.5u l=0.13u
MP3023 (qm3012 qmb3013 vdd vdd) p12 w=1.5u l=0.13u
MN3024 (storage3015 count_rst vss vss) n12 w=2u l=0.13u
MN3026 (qm3012 clk_high2863 storage3025 vss) n12 w=1.2u l=0.13u
MP3027 (qm3012 clk_highb2864 storage3025 vdd) p12 w=3.6u l=0.13u
MN3028 (lead_sync2_2 clk_low2861 storage3025 vss) n12 w=1.2u l=0.13u
MP3029 (lead_sync2_2 clk_lowb2862 storage3025 vdd) p12 w=3.6u l=0.13u
MN3030 (qb3014 storage3025 vss vss) n12 w=0.5u l=0.13u
MP3031 (qb3014 storage3025 vdd vdd) p12 w=1.5u l=0.13u
MN3032 (lead_sync2_2 qb3014 vss vss) n12 w=0.5u l=0.13u
MP3033 (lead_sync2_2 qb3014 vdd vdd) p12 w=1.5u l=0.13u
MN3034 (storage3025 count_rst vss vss) n12 w=2u l=0.13u
MN3039 (lead_g3 clk_low2861 storage3038 vss) n12 w=1.2u l=0.13u
MP3040 (lead_g3 clk_lowb2862 storage3038 vdd) p12 w=3.6u l=0.13u
MN3041 (qm3035 clk_high2863 storage3038 vss) n12 w=1.2u l=0.13u
MP3042 (qm3035 clk_highb2864 storage3038 vdd) p12 w=3.6u l=0.13u
MN3043 (qmb3036 storage3038 vss vss) n12 w=0.5u l=0.13u
MP3044 (qmb3036 storage3038 vdd vdd) p12 w=1.5u l=0.13u
MN3045 (qm3035 qmb3036 vss vss) n12 w=0.5u l=0.13u
MP3046 (qm3035 qmb3036 vdd vdd) p12 w=1.5u l=0.13u
MN3047 (storage3038 count_rst vss vss) n12 w=2u l=0.13u
MN3049 (qm3035 clk_high2863 storage3048 vss) n12 w=1.2u l=0.13u
MP3050 (qm3035 clk_highb2864 storage3048 vdd) p12 w=3.6u l=0.13u
MN3051 (lead_sync1_3 clk_low2861 storage3048 vss) n12 w=1.2u l=0.13u
MP3052 (lead_sync1_3 clk_lowb2862 storage3048 vdd) p12 w=3.6u l=0.13u
MN3053 (qb3037 storage3048 vss vss) n12 w=0.5u l=0.13u
MP3054 (qb3037 storage3048 vdd vdd) p12 w=1.5u l=0.13u
MN3055 (lead_sync1_3 qb3037 vss vss) n12 w=0.5u l=0.13u
MP3056 (lead_sync1_3 qb3037 vdd vdd) p12 w=1.5u l=0.13u
MN3057 (storage3048 count_rst vss vss) n12 w=2u l=0.13u
MN3062 (lead_sync1_3 clk_low2861 storage3061 vss) n12 w=1.2u l=0.13u
MP3063 (lead_sync1_3 clk_lowb2862 storage3061 vdd) p12 w=3.6u l=0.13u
MN3064 (qm3058 clk_high2863 storage3061 vss) n12 w=1.2u l=0.13u
MP3065 (qm3058 clk_highb2864 storage3061 vdd) p12 w=3.6u l=0.13u
MN3066 (qmb3059 storage3061 vss vss) n12 w=0.5u l=0.13u
MP3067 (qmb3059 storage3061 vdd vdd) p12 w=1.5u l=0.13u
MN3068 (qm3058 qmb3059 vss vss) n12 w=0.5u l=0.13u
MP3069 (qm3058 qmb3059 vdd vdd) p12 w=1.5u l=0.13u
MN3070 (storage3061 count_rst vss vss) n12 w=2u l=0.13u
MN3072 (qm3058 clk_high2863 storage3071 vss) n12 w=1.2u l=0.13u
MP3073 (qm3058 clk_highb2864 storage3071 vdd) p12 w=3.6u l=0.13u
MN3074 (lead_sync2_3 clk_low2861 storage3071 vss) n12 w=1.2u l=0.13u
MP3075 (lead_sync2_3 clk_lowb2862 storage3071 vdd) p12 w=3.6u l=0.13u
MN3076 (qb3060 storage3071 vss vss) n12 w=0.5u l=0.13u
MP3077 (qb3060 storage3071 vdd vdd) p12 w=1.5u l=0.13u
MN3078 (lead_sync2_3 qb3060 vss vss) n12 w=0.5u l=0.13u
MP3079 (lead_sync2_3 qb3060 vdd vdd) p12 w=1.5u l=0.13u
MN3080 (storage3071 count_rst vss vss) n12 w=2u l=0.13u
MN3085 (lead_g4 clk_low2861 storage3084 vss) n12 w=1.2u l=0.13u
MP3086 (lead_g4 clk_lowb2862 storage3084 vdd) p12 w=3.6u l=0.13u
MN3087 (qm3081 clk_high2863 storage3084 vss) n12 w=1.2u l=0.13u
MP3088 (qm3081 clk_highb2864 storage3084 vdd) p12 w=3.6u l=0.13u
MN3089 (qmb3082 storage3084 vss vss) n12 w=0.5u l=0.13u
MP3090 (qmb3082 storage3084 vdd vdd) p12 w=1.5u l=0.13u
MN3091 (qm3081 qmb3082 vss vss) n12 w=0.5u l=0.13u
MP3092 (qm3081 qmb3082 vdd vdd) p12 w=1.5u l=0.13u
MN3093 (storage3084 count_rst vss vss) n12 w=2u l=0.13u
MN3095 (qm3081 clk_high2863 storage3094 vss) n12 w=1.2u l=0.13u
MP3096 (qm3081 clk_highb2864 storage3094 vdd) p12 w=3.6u l=0.13u
MN3097 (lead_sync1_4 clk_low2861 storage3094 vss) n12 w=1.2u l=0.13u
MP3098 (lead_sync1_4 clk_lowb2862 storage3094 vdd) p12 w=3.6u l=0.13u
MN3099 (qb3083 storage3094 vss vss) n12 w=0.5u l=0.13u
MP3100 (qb3083 storage3094 vdd vdd) p12 w=1.5u l=0.13u
MN3101 (lead_sync1_4 qb3083 vss vss) n12 w=0.5u l=0.13u
MP3102 (lead_sync1_4 qb3083 vdd vdd) p12 w=1.5u l=0.13u
MN3103 (storage3094 count_rst vss vss) n12 w=2u l=0.13u
MN3108 (lead_sync1_4 clk_low2861 storage3107 vss) n12 w=1.2u l=0.13u
MP3109 (lead_sync1_4 clk_lowb2862 storage3107 vdd) p12 w=3.6u l=0.13u
MN3110 (qm3104 clk_high2863 storage3107 vss) n12 w=1.2u l=0.13u
MP3111 (qm3104 clk_highb2864 storage3107 vdd) p12 w=3.6u l=0.13u
MN3112 (qmb3105 storage3107 vss vss) n12 w=0.5u l=0.13u
MP3113 (qmb3105 storage3107 vdd vdd) p12 w=1.5u l=0.13u
MN3114 (qm3104 qmb3105 vss vss) n12 w=0.5u l=0.13u
MP3115 (qm3104 qmb3105 vdd vdd) p12 w=1.5u l=0.13u
MN3116 (storage3107 count_rst vss vss) n12 w=2u l=0.13u
MN3118 (qm3104 clk_high2863 storage3117 vss) n12 w=1.2u l=0.13u
MP3119 (qm3104 clk_highb2864 storage3117 vdd) p12 w=3.6u l=0.13u
MN3120 (lead_sync2_4 clk_low2861 storage3117 vss) n12 w=1.2u l=0.13u
MP3121 (lead_sync2_4 clk_lowb2862 storage3117 vdd) p12 w=3.6u l=0.13u
MN3122 (qb3106 storage3117 vss vss) n12 w=0.5u l=0.13u
MP3123 (qb3106 storage3117 vdd vdd) p12 w=1.5u l=0.13u
MN3124 (lead_sync2_4 qb3106 vss vss) n12 w=0.5u l=0.13u
MP3125 (lead_sync2_4 qb3106 vdd vdd) p12 w=1.5u l=0.13u
MN3126 (storage3117 count_rst vss vss) n12 w=2u l=0.13u
MN3131 (lead_g5 clk_low2861 storage3130 vss) n12 w=1.2u l=0.13u
MP3132 (lead_g5 clk_lowb2862 storage3130 vdd) p12 w=3.6u l=0.13u
MN3133 (qm3127 clk_high2863 storage3130 vss) n12 w=1.2u l=0.13u
MP3134 (qm3127 clk_highb2864 storage3130 vdd) p12 w=3.6u l=0.13u
MN3135 (qmb3128 storage3130 vss vss) n12 w=0.5u l=0.13u
MP3136 (qmb3128 storage3130 vdd vdd) p12 w=1.5u l=0.13u
MN3137 (qm3127 qmb3128 vss vss) n12 w=0.5u l=0.13u
MP3138 (qm3127 qmb3128 vdd vdd) p12 w=1.5u l=0.13u
MN3139 (storage3130 count_rst vss vss) n12 w=2u l=0.13u
MN3141 (qm3127 clk_high2863 storage3140 vss) n12 w=1.2u l=0.13u
MP3142 (qm3127 clk_highb2864 storage3140 vdd) p12 w=3.6u l=0.13u
MN3143 (lead_sync1_5 clk_low2861 storage3140 vss) n12 w=1.2u l=0.13u
MP3144 (lead_sync1_5 clk_lowb2862 storage3140 vdd) p12 w=3.6u l=0.13u
MN3145 (qb3129 storage3140 vss vss) n12 w=0.5u l=0.13u
MP3146 (qb3129 storage3140 vdd vdd) p12 w=1.5u l=0.13u
MN3147 (lead_sync1_5 qb3129 vss vss) n12 w=0.5u l=0.13u
MP3148 (lead_sync1_5 qb3129 vdd vdd) p12 w=1.5u l=0.13u
MN3149 (storage3140 count_rst vss vss) n12 w=2u l=0.13u
MN3154 (lead_sync1_5 clk_low2861 storage3153 vss) n12 w=1.2u l=0.13u
MP3155 (lead_sync1_5 clk_lowb2862 storage3153 vdd) p12 w=3.6u l=0.13u
MN3156 (qm3150 clk_high2863 storage3153 vss) n12 w=1.2u l=0.13u
MP3157 (qm3150 clk_highb2864 storage3153 vdd) p12 w=3.6u l=0.13u
MN3158 (qmb3151 storage3153 vss vss) n12 w=0.5u l=0.13u
MP3159 (qmb3151 storage3153 vdd vdd) p12 w=1.5u l=0.13u
MN3160 (qm3150 qmb3151 vss vss) n12 w=0.5u l=0.13u
MP3161 (qm3150 qmb3151 vdd vdd) p12 w=1.5u l=0.13u
MN3162 (storage3153 count_rst vss vss) n12 w=2u l=0.13u
MN3164 (qm3150 clk_high2863 storage3163 vss) n12 w=1.2u l=0.13u
MP3165 (qm3150 clk_highb2864 storage3163 vdd) p12 w=3.6u l=0.13u
MN3166 (lead_sync2_5 clk_low2861 storage3163 vss) n12 w=1.2u l=0.13u
MP3167 (lead_sync2_5 clk_lowb2862 storage3163 vdd) p12 w=3.6u l=0.13u
MN3168 (qb3152 storage3163 vss vss) n12 w=0.5u l=0.13u
MP3169 (qb3152 storage3163 vdd vdd) p12 w=1.5u l=0.13u
MN3170 (lead_sync2_5 qb3152 vss vss) n12 w=0.5u l=0.13u
MP3171 (lead_sync2_5 qb3152 vdd vdd) p12 w=1.5u l=0.13u
MN3172 (storage3163 count_rst vss vss) n12 w=2u l=0.13u
MN3177 (lead_g6 clk_low2861 storage3176 vss) n12 w=1.2u l=0.13u
MP3178 (lead_g6 clk_lowb2862 storage3176 vdd) p12 w=3.6u l=0.13u
MN3179 (qm3173 clk_high2863 storage3176 vss) n12 w=1.2u l=0.13u
MP3180 (qm3173 clk_highb2864 storage3176 vdd) p12 w=3.6u l=0.13u
MN3181 (qmb3174 storage3176 vss vss) n12 w=0.5u l=0.13u
MP3182 (qmb3174 storage3176 vdd vdd) p12 w=1.5u l=0.13u
MN3183 (qm3173 qmb3174 vss vss) n12 w=0.5u l=0.13u
MP3184 (qm3173 qmb3174 vdd vdd) p12 w=1.5u l=0.13u
MN3185 (storage3176 count_rst vss vss) n12 w=2u l=0.13u
MN3187 (qm3173 clk_high2863 storage3186 vss) n12 w=1.2u l=0.13u
MP3188 (qm3173 clk_highb2864 storage3186 vdd) p12 w=3.6u l=0.13u
MN3189 (lead_sync1_6 clk_low2861 storage3186 vss) n12 w=1.2u l=0.13u
MP3190 (lead_sync1_6 clk_lowb2862 storage3186 vdd) p12 w=3.6u l=0.13u
MN3191 (qb3175 storage3186 vss vss) n12 w=0.5u l=0.13u
MP3192 (qb3175 storage3186 vdd vdd) p12 w=1.5u l=0.13u
MN3193 (lead_sync1_6 qb3175 vss vss) n12 w=0.5u l=0.13u
MP3194 (lead_sync1_6 qb3175 vdd vdd) p12 w=1.5u l=0.13u
MN3195 (storage3186 count_rst vss vss) n12 w=2u l=0.13u
MN3200 (lead_sync1_6 clk_low2861 storage3199 vss) n12 w=1.2u l=0.13u
MP3201 (lead_sync1_6 clk_lowb2862 storage3199 vdd) p12 w=3.6u l=0.13u
MN3202 (qm3196 clk_high2863 storage3199 vss) n12 w=1.2u l=0.13u
MP3203 (qm3196 clk_highb2864 storage3199 vdd) p12 w=3.6u l=0.13u
MN3204 (qmb3197 storage3199 vss vss) n12 w=0.5u l=0.13u
MP3205 (qmb3197 storage3199 vdd vdd) p12 w=1.5u l=0.13u
MN3206 (qm3196 qmb3197 vss vss) n12 w=0.5u l=0.13u
MP3207 (qm3196 qmb3197 vdd vdd) p12 w=1.5u l=0.13u
MN3208 (storage3199 count_rst vss vss) n12 w=2u l=0.13u
MN3210 (qm3196 clk_high2863 storage3209 vss) n12 w=1.2u l=0.13u
MP3211 (qm3196 clk_highb2864 storage3209 vdd) p12 w=3.6u l=0.13u
MN3212 (lead_sync2_6 clk_low2861 storage3209 vss) n12 w=1.2u l=0.13u
MP3213 (lead_sync2_6 clk_lowb2862 storage3209 vdd) p12 w=3.6u l=0.13u
MN3214 (qb3198 storage3209 vss vss) n12 w=0.5u l=0.13u
MP3215 (qb3198 storage3209 vdd vdd) p12 w=1.5u l=0.13u
MN3216 (lead_sync2_6 qb3198 vss vss) n12 w=0.5u l=0.13u
MP3217 (lead_sync2_6 qb3198 vdd vdd) p12 w=1.5u l=0.13u
MN3218 (storage3209 count_rst vss vss) n12 w=2u l=0.13u
MN3223 (lead_g7 clk_low2861 storage3222 vss) n12 w=1.2u l=0.13u
MP3224 (lead_g7 clk_lowb2862 storage3222 vdd) p12 w=3.6u l=0.13u
MN3225 (qm3219 clk_high2863 storage3222 vss) n12 w=1.2u l=0.13u
MP3226 (qm3219 clk_highb2864 storage3222 vdd) p12 w=3.6u l=0.13u
MN3227 (qmb3220 storage3222 vss vss) n12 w=0.5u l=0.13u
MP3228 (qmb3220 storage3222 vdd vdd) p12 w=1.5u l=0.13u
MN3229 (qm3219 qmb3220 vss vss) n12 w=0.5u l=0.13u
MP3230 (qm3219 qmb3220 vdd vdd) p12 w=1.5u l=0.13u
MN3231 (storage3222 count_rst vss vss) n12 w=2u l=0.13u
MN3233 (qm3219 clk_high2863 storage3232 vss) n12 w=1.2u l=0.13u
MP3234 (qm3219 clk_highb2864 storage3232 vdd) p12 w=3.6u l=0.13u
MN3235 (lead_sync1_7 clk_low2861 storage3232 vss) n12 w=1.2u l=0.13u
MP3236 (lead_sync1_7 clk_lowb2862 storage3232 vdd) p12 w=3.6u l=0.13u
MN3237 (qb3221 storage3232 vss vss) n12 w=0.5u l=0.13u
MP3238 (qb3221 storage3232 vdd vdd) p12 w=1.5u l=0.13u
MN3239 (lead_sync1_7 qb3221 vss vss) n12 w=0.5u l=0.13u
MP3240 (lead_sync1_7 qb3221 vdd vdd) p12 w=1.5u l=0.13u
MN3241 (storage3232 count_rst vss vss) n12 w=2u l=0.13u
MN3246 (lead_sync1_7 clk_low2861 storage3245 vss) n12 w=1.2u l=0.13u
MP3247 (lead_sync1_7 clk_lowb2862 storage3245 vdd) p12 w=3.6u l=0.13u
MN3248 (qm3242 clk_high2863 storage3245 vss) n12 w=1.2u l=0.13u
MP3249 (qm3242 clk_highb2864 storage3245 vdd) p12 w=3.6u l=0.13u
MN3250 (qmb3243 storage3245 vss vss) n12 w=0.5u l=0.13u
MP3251 (qmb3243 storage3245 vdd vdd) p12 w=1.5u l=0.13u
MN3252 (qm3242 qmb3243 vss vss) n12 w=0.5u l=0.13u
MP3253 (qm3242 qmb3243 vdd vdd) p12 w=1.5u l=0.13u
MN3254 (storage3245 count_rst vss vss) n12 w=2u l=0.13u
MN3256 (qm3242 clk_high2863 storage3255 vss) n12 w=1.2u l=0.13u
MP3257 (qm3242 clk_highb2864 storage3255 vdd) p12 w=3.6u l=0.13u
MN3258 (lead_sync2_7 clk_low2861 storage3255 vss) n12 w=1.2u l=0.13u
MP3259 (lead_sync2_7 clk_lowb2862 storage3255 vdd) p12 w=3.6u l=0.13u
MN3260 (qb3244 storage3255 vss vss) n12 w=0.5u l=0.13u
MP3261 (qb3244 storage3255 vdd vdd) p12 w=1.5u l=0.13u
MN3262 (lead_sync2_7 qb3244 vss vss) n12 w=0.5u l=0.13u
MP3263 (lead_sync2_7 qb3244 vdd vdd) p12 w=1.5u l=0.13u
MN3264 (storage3255 count_rst vss vss) n12 w=2u l=0.13u
MN3269 (lag_g0 clk_low2861 storage3268 vss) n12 w=1.2u l=0.13u
MP3270 (lag_g0 clk_lowb2862 storage3268 vdd) p12 w=3.6u l=0.13u
MN3271 (qm3265 clk_high2863 storage3268 vss) n12 w=1.2u l=0.13u
MP3272 (qm3265 clk_highb2864 storage3268 vdd) p12 w=3.6u l=0.13u
MN3273 (qmb3266 storage3268 vss vss) n12 w=0.5u l=0.13u
MP3274 (qmb3266 storage3268 vdd vdd) p12 w=1.5u l=0.13u
MN3275 (qm3265 qmb3266 vss vss) n12 w=0.5u l=0.13u
MP3276 (qm3265 qmb3266 vdd vdd) p12 w=1.5u l=0.13u
MN3277 (storage3268 count_rst vss vss) n12 w=2u l=0.13u
MN3279 (qm3265 clk_high2863 storage3278 vss) n12 w=1.2u l=0.13u
MP3280 (qm3265 clk_highb2864 storage3278 vdd) p12 w=3.6u l=0.13u
MN3281 (lag_sync1_0 clk_low2861 storage3278 vss) n12 w=1.2u l=0.13u
MP3282 (lag_sync1_0 clk_lowb2862 storage3278 vdd) p12 w=3.6u l=0.13u
MN3283 (qb3267 storage3278 vss vss) n12 w=0.5u l=0.13u
MP3284 (qb3267 storage3278 vdd vdd) p12 w=1.5u l=0.13u
MN3285 (lag_sync1_0 qb3267 vss vss) n12 w=0.5u l=0.13u
MP3286 (lag_sync1_0 qb3267 vdd vdd) p12 w=1.5u l=0.13u
MN3287 (storage3278 count_rst vss vss) n12 w=2u l=0.13u
MN3292 (lag_sync1_0 clk_low2861 storage3291 vss) n12 w=1.2u l=0.13u
MP3293 (lag_sync1_0 clk_lowb2862 storage3291 vdd) p12 w=3.6u l=0.13u
MN3294 (qm3288 clk_high2863 storage3291 vss) n12 w=1.2u l=0.13u
MP3295 (qm3288 clk_highb2864 storage3291 vdd) p12 w=3.6u l=0.13u
MN3296 (qmb3289 storage3291 vss vss) n12 w=0.5u l=0.13u
MP3297 (qmb3289 storage3291 vdd vdd) p12 w=1.5u l=0.13u
MN3298 (qm3288 qmb3289 vss vss) n12 w=0.5u l=0.13u
MP3299 (qm3288 qmb3289 vdd vdd) p12 w=1.5u l=0.13u
MN3300 (storage3291 count_rst vss vss) n12 w=2u l=0.13u
MN3302 (qm3288 clk_high2863 storage3301 vss) n12 w=1.2u l=0.13u
MP3303 (qm3288 clk_highb2864 storage3301 vdd) p12 w=3.6u l=0.13u
MN3304 (lag_sync2_0 clk_low2861 storage3301 vss) n12 w=1.2u l=0.13u
MP3305 (lag_sync2_0 clk_lowb2862 storage3301 vdd) p12 w=3.6u l=0.13u
MN3306 (qb3290 storage3301 vss vss) n12 w=0.5u l=0.13u
MP3307 (qb3290 storage3301 vdd vdd) p12 w=1.5u l=0.13u
MN3308 (lag_sync2_0 qb3290 vss vss) n12 w=0.5u l=0.13u
MP3309 (lag_sync2_0 qb3290 vdd vdd) p12 w=1.5u l=0.13u
MN3310 (storage3301 count_rst vss vss) n12 w=2u l=0.13u
MN3315 (lag_g1 clk_low2861 storage3314 vss) n12 w=1.2u l=0.13u
MP3316 (lag_g1 clk_lowb2862 storage3314 vdd) p12 w=3.6u l=0.13u
MN3317 (qm3311 clk_high2863 storage3314 vss) n12 w=1.2u l=0.13u
MP3318 (qm3311 clk_highb2864 storage3314 vdd) p12 w=3.6u l=0.13u
MN3319 (qmb3312 storage3314 vss vss) n12 w=0.5u l=0.13u
MP3320 (qmb3312 storage3314 vdd vdd) p12 w=1.5u l=0.13u
MN3321 (qm3311 qmb3312 vss vss) n12 w=0.5u l=0.13u
MP3322 (qm3311 qmb3312 vdd vdd) p12 w=1.5u l=0.13u
MN3323 (storage3314 count_rst vss vss) n12 w=2u l=0.13u
MN3325 (qm3311 clk_high2863 storage3324 vss) n12 w=1.2u l=0.13u
MP3326 (qm3311 clk_highb2864 storage3324 vdd) p12 w=3.6u l=0.13u
MN3327 (lag_sync1_1 clk_low2861 storage3324 vss) n12 w=1.2u l=0.13u
MP3328 (lag_sync1_1 clk_lowb2862 storage3324 vdd) p12 w=3.6u l=0.13u
MN3329 (qb3313 storage3324 vss vss) n12 w=0.5u l=0.13u
MP3330 (qb3313 storage3324 vdd vdd) p12 w=1.5u l=0.13u
MN3331 (lag_sync1_1 qb3313 vss vss) n12 w=0.5u l=0.13u
MP3332 (lag_sync1_1 qb3313 vdd vdd) p12 w=1.5u l=0.13u
MN3333 (storage3324 count_rst vss vss) n12 w=2u l=0.13u
MN3338 (lag_sync1_1 clk_low2861 storage3337 vss) n12 w=1.2u l=0.13u
MP3339 (lag_sync1_1 clk_lowb2862 storage3337 vdd) p12 w=3.6u l=0.13u
MN3340 (qm3334 clk_high2863 storage3337 vss) n12 w=1.2u l=0.13u
MP3341 (qm3334 clk_highb2864 storage3337 vdd) p12 w=3.6u l=0.13u
MN3342 (qmb3335 storage3337 vss vss) n12 w=0.5u l=0.13u
MP3343 (qmb3335 storage3337 vdd vdd) p12 w=1.5u l=0.13u
MN3344 (qm3334 qmb3335 vss vss) n12 w=0.5u l=0.13u
MP3345 (qm3334 qmb3335 vdd vdd) p12 w=1.5u l=0.13u
MN3346 (storage3337 count_rst vss vss) n12 w=2u l=0.13u
MN3348 (qm3334 clk_high2863 storage3347 vss) n12 w=1.2u l=0.13u
MP3349 (qm3334 clk_highb2864 storage3347 vdd) p12 w=3.6u l=0.13u
MN3350 (lag_sync2_1 clk_low2861 storage3347 vss) n12 w=1.2u l=0.13u
MP3351 (lag_sync2_1 clk_lowb2862 storage3347 vdd) p12 w=3.6u l=0.13u
MN3352 (qb3336 storage3347 vss vss) n12 w=0.5u l=0.13u
MP3353 (qb3336 storage3347 vdd vdd) p12 w=1.5u l=0.13u
MN3354 (lag_sync2_1 qb3336 vss vss) n12 w=0.5u l=0.13u
MP3355 (lag_sync2_1 qb3336 vdd vdd) p12 w=1.5u l=0.13u
MN3356 (storage3347 count_rst vss vss) n12 w=2u l=0.13u
MN3361 (lag_g2 clk_low2861 storage3360 vss) n12 w=1.2u l=0.13u
MP3362 (lag_g2 clk_lowb2862 storage3360 vdd) p12 w=3.6u l=0.13u
MN3363 (qm3357 clk_high2863 storage3360 vss) n12 w=1.2u l=0.13u
MP3364 (qm3357 clk_highb2864 storage3360 vdd) p12 w=3.6u l=0.13u
MN3365 (qmb3358 storage3360 vss vss) n12 w=0.5u l=0.13u
MP3366 (qmb3358 storage3360 vdd vdd) p12 w=1.5u l=0.13u
MN3367 (qm3357 qmb3358 vss vss) n12 w=0.5u l=0.13u
MP3368 (qm3357 qmb3358 vdd vdd) p12 w=1.5u l=0.13u
MN3369 (storage3360 count_rst vss vss) n12 w=2u l=0.13u
MN3371 (qm3357 clk_high2863 storage3370 vss) n12 w=1.2u l=0.13u
MP3372 (qm3357 clk_highb2864 storage3370 vdd) p12 w=3.6u l=0.13u
MN3373 (lag_sync1_2 clk_low2861 storage3370 vss) n12 w=1.2u l=0.13u
MP3374 (lag_sync1_2 clk_lowb2862 storage3370 vdd) p12 w=3.6u l=0.13u
MN3375 (qb3359 storage3370 vss vss) n12 w=0.5u l=0.13u
MP3376 (qb3359 storage3370 vdd vdd) p12 w=1.5u l=0.13u
MN3377 (lag_sync1_2 qb3359 vss vss) n12 w=0.5u l=0.13u
MP3378 (lag_sync1_2 qb3359 vdd vdd) p12 w=1.5u l=0.13u
MN3379 (storage3370 count_rst vss vss) n12 w=2u l=0.13u
MN3384 (lag_sync1_2 clk_low2861 storage3383 vss) n12 w=1.2u l=0.13u
MP3385 (lag_sync1_2 clk_lowb2862 storage3383 vdd) p12 w=3.6u l=0.13u
MN3386 (qm3380 clk_high2863 storage3383 vss) n12 w=1.2u l=0.13u
MP3387 (qm3380 clk_highb2864 storage3383 vdd) p12 w=3.6u l=0.13u
MN3388 (qmb3381 storage3383 vss vss) n12 w=0.5u l=0.13u
MP3389 (qmb3381 storage3383 vdd vdd) p12 w=1.5u l=0.13u
MN3390 (qm3380 qmb3381 vss vss) n12 w=0.5u l=0.13u
MP3391 (qm3380 qmb3381 vdd vdd) p12 w=1.5u l=0.13u
MN3392 (storage3383 count_rst vss vss) n12 w=2u l=0.13u
MN3394 (qm3380 clk_high2863 storage3393 vss) n12 w=1.2u l=0.13u
MP3395 (qm3380 clk_highb2864 storage3393 vdd) p12 w=3.6u l=0.13u
MN3396 (lag_sync2_2 clk_low2861 storage3393 vss) n12 w=1.2u l=0.13u
MP3397 (lag_sync2_2 clk_lowb2862 storage3393 vdd) p12 w=3.6u l=0.13u
MN3398 (qb3382 storage3393 vss vss) n12 w=0.5u l=0.13u
MP3399 (qb3382 storage3393 vdd vdd) p12 w=1.5u l=0.13u
MN3400 (lag_sync2_2 qb3382 vss vss) n12 w=0.5u l=0.13u
MP3401 (lag_sync2_2 qb3382 vdd vdd) p12 w=1.5u l=0.13u
MN3402 (storage3393 count_rst vss vss) n12 w=2u l=0.13u
MN3407 (lag_g3 clk_low2861 storage3406 vss) n12 w=1.2u l=0.13u
MP3408 (lag_g3 clk_lowb2862 storage3406 vdd) p12 w=3.6u l=0.13u
MN3409 (qm3403 clk_high2863 storage3406 vss) n12 w=1.2u l=0.13u
MP3410 (qm3403 clk_highb2864 storage3406 vdd) p12 w=3.6u l=0.13u
MN3411 (qmb3404 storage3406 vss vss) n12 w=0.5u l=0.13u
MP3412 (qmb3404 storage3406 vdd vdd) p12 w=1.5u l=0.13u
MN3413 (qm3403 qmb3404 vss vss) n12 w=0.5u l=0.13u
MP3414 (qm3403 qmb3404 vdd vdd) p12 w=1.5u l=0.13u
MN3415 (storage3406 count_rst vss vss) n12 w=2u l=0.13u
MN3417 (qm3403 clk_high2863 storage3416 vss) n12 w=1.2u l=0.13u
MP3418 (qm3403 clk_highb2864 storage3416 vdd) p12 w=3.6u l=0.13u
MN3419 (lag_sync1_3 clk_low2861 storage3416 vss) n12 w=1.2u l=0.13u
MP3420 (lag_sync1_3 clk_lowb2862 storage3416 vdd) p12 w=3.6u l=0.13u
MN3421 (qb3405 storage3416 vss vss) n12 w=0.5u l=0.13u
MP3422 (qb3405 storage3416 vdd vdd) p12 w=1.5u l=0.13u
MN3423 (lag_sync1_3 qb3405 vss vss) n12 w=0.5u l=0.13u
MP3424 (lag_sync1_3 qb3405 vdd vdd) p12 w=1.5u l=0.13u
MN3425 (storage3416 count_rst vss vss) n12 w=2u l=0.13u
MN3430 (lag_sync1_3 clk_low2861 storage3429 vss) n12 w=1.2u l=0.13u
MP3431 (lag_sync1_3 clk_lowb2862 storage3429 vdd) p12 w=3.6u l=0.13u
MN3432 (qm3426 clk_high2863 storage3429 vss) n12 w=1.2u l=0.13u
MP3433 (qm3426 clk_highb2864 storage3429 vdd) p12 w=3.6u l=0.13u
MN3434 (qmb3427 storage3429 vss vss) n12 w=0.5u l=0.13u
MP3435 (qmb3427 storage3429 vdd vdd) p12 w=1.5u l=0.13u
MN3436 (qm3426 qmb3427 vss vss) n12 w=0.5u l=0.13u
MP3437 (qm3426 qmb3427 vdd vdd) p12 w=1.5u l=0.13u
MN3438 (storage3429 count_rst vss vss) n12 w=2u l=0.13u
MN3440 (qm3426 clk_high2863 storage3439 vss) n12 w=1.2u l=0.13u
MP3441 (qm3426 clk_highb2864 storage3439 vdd) p12 w=3.6u l=0.13u
MN3442 (lag_sync2_3 clk_low2861 storage3439 vss) n12 w=1.2u l=0.13u
MP3443 (lag_sync2_3 clk_lowb2862 storage3439 vdd) p12 w=3.6u l=0.13u
MN3444 (qb3428 storage3439 vss vss) n12 w=0.5u l=0.13u
MP3445 (qb3428 storage3439 vdd vdd) p12 w=1.5u l=0.13u
MN3446 (lag_sync2_3 qb3428 vss vss) n12 w=0.5u l=0.13u
MP3447 (lag_sync2_3 qb3428 vdd vdd) p12 w=1.5u l=0.13u
MN3448 (storage3439 count_rst vss vss) n12 w=2u l=0.13u
MN3453 (lag_g4 clk_low2861 storage3452 vss) n12 w=1.2u l=0.13u
MP3454 (lag_g4 clk_lowb2862 storage3452 vdd) p12 w=3.6u l=0.13u
MN3455 (qm3449 clk_high2863 storage3452 vss) n12 w=1.2u l=0.13u
MP3456 (qm3449 clk_highb2864 storage3452 vdd) p12 w=3.6u l=0.13u
MN3457 (qmb3450 storage3452 vss vss) n12 w=0.5u l=0.13u
MP3458 (qmb3450 storage3452 vdd vdd) p12 w=1.5u l=0.13u
MN3459 (qm3449 qmb3450 vss vss) n12 w=0.5u l=0.13u
MP3460 (qm3449 qmb3450 vdd vdd) p12 w=1.5u l=0.13u
MN3461 (storage3452 count_rst vss vss) n12 w=2u l=0.13u
MN3463 (qm3449 clk_high2863 storage3462 vss) n12 w=1.2u l=0.13u
MP3464 (qm3449 clk_highb2864 storage3462 vdd) p12 w=3.6u l=0.13u
MN3465 (lag_sync1_4 clk_low2861 storage3462 vss) n12 w=1.2u l=0.13u
MP3466 (lag_sync1_4 clk_lowb2862 storage3462 vdd) p12 w=3.6u l=0.13u
MN3467 (qb3451 storage3462 vss vss) n12 w=0.5u l=0.13u
MP3468 (qb3451 storage3462 vdd vdd) p12 w=1.5u l=0.13u
MN3469 (lag_sync1_4 qb3451 vss vss) n12 w=0.5u l=0.13u
MP3470 (lag_sync1_4 qb3451 vdd vdd) p12 w=1.5u l=0.13u
MN3471 (storage3462 count_rst vss vss) n12 w=2u l=0.13u
MN3476 (lag_sync1_4 clk_low2861 storage3475 vss) n12 w=1.2u l=0.13u
MP3477 (lag_sync1_4 clk_lowb2862 storage3475 vdd) p12 w=3.6u l=0.13u
MN3478 (qm3472 clk_high2863 storage3475 vss) n12 w=1.2u l=0.13u
MP3479 (qm3472 clk_highb2864 storage3475 vdd) p12 w=3.6u l=0.13u
MN3480 (qmb3473 storage3475 vss vss) n12 w=0.5u l=0.13u
MP3481 (qmb3473 storage3475 vdd vdd) p12 w=1.5u l=0.13u
MN3482 (qm3472 qmb3473 vss vss) n12 w=0.5u l=0.13u
MP3483 (qm3472 qmb3473 vdd vdd) p12 w=1.5u l=0.13u
MN3484 (storage3475 count_rst vss vss) n12 w=2u l=0.13u
MN3486 (qm3472 clk_high2863 storage3485 vss) n12 w=1.2u l=0.13u
MP3487 (qm3472 clk_highb2864 storage3485 vdd) p12 w=3.6u l=0.13u
MN3488 (lag_sync2_4 clk_low2861 storage3485 vss) n12 w=1.2u l=0.13u
MP3489 (lag_sync2_4 clk_lowb2862 storage3485 vdd) p12 w=3.6u l=0.13u
MN3490 (qb3474 storage3485 vss vss) n12 w=0.5u l=0.13u
MP3491 (qb3474 storage3485 vdd vdd) p12 w=1.5u l=0.13u
MN3492 (lag_sync2_4 qb3474 vss vss) n12 w=0.5u l=0.13u
MP3493 (lag_sync2_4 qb3474 vdd vdd) p12 w=1.5u l=0.13u
MN3494 (storage3485 count_rst vss vss) n12 w=2u l=0.13u
MN3499 (lag_g5 clk_low2861 storage3498 vss) n12 w=1.2u l=0.13u
MP3500 (lag_g5 clk_lowb2862 storage3498 vdd) p12 w=3.6u l=0.13u
MN3501 (qm3495 clk_high2863 storage3498 vss) n12 w=1.2u l=0.13u
MP3502 (qm3495 clk_highb2864 storage3498 vdd) p12 w=3.6u l=0.13u
MN3503 (qmb3496 storage3498 vss vss) n12 w=0.5u l=0.13u
MP3504 (qmb3496 storage3498 vdd vdd) p12 w=1.5u l=0.13u
MN3505 (qm3495 qmb3496 vss vss) n12 w=0.5u l=0.13u
MP3506 (qm3495 qmb3496 vdd vdd) p12 w=1.5u l=0.13u
MN3507 (storage3498 count_rst vss vss) n12 w=2u l=0.13u
MN3509 (qm3495 clk_high2863 storage3508 vss) n12 w=1.2u l=0.13u
MP3510 (qm3495 clk_highb2864 storage3508 vdd) p12 w=3.6u l=0.13u
MN3511 (lag_sync1_5 clk_low2861 storage3508 vss) n12 w=1.2u l=0.13u
MP3512 (lag_sync1_5 clk_lowb2862 storage3508 vdd) p12 w=3.6u l=0.13u
MN3513 (qb3497 storage3508 vss vss) n12 w=0.5u l=0.13u
MP3514 (qb3497 storage3508 vdd vdd) p12 w=1.5u l=0.13u
MN3515 (lag_sync1_5 qb3497 vss vss) n12 w=0.5u l=0.13u
MP3516 (lag_sync1_5 qb3497 vdd vdd) p12 w=1.5u l=0.13u
MN3517 (storage3508 count_rst vss vss) n12 w=2u l=0.13u
MN3522 (lag_sync1_5 clk_low2861 storage3521 vss) n12 w=1.2u l=0.13u
MP3523 (lag_sync1_5 clk_lowb2862 storage3521 vdd) p12 w=3.6u l=0.13u
MN3524 (qm3518 clk_high2863 storage3521 vss) n12 w=1.2u l=0.13u
MP3525 (qm3518 clk_highb2864 storage3521 vdd) p12 w=3.6u l=0.13u
MN3526 (qmb3519 storage3521 vss vss) n12 w=0.5u l=0.13u
MP3527 (qmb3519 storage3521 vdd vdd) p12 w=1.5u l=0.13u
MN3528 (qm3518 qmb3519 vss vss) n12 w=0.5u l=0.13u
MP3529 (qm3518 qmb3519 vdd vdd) p12 w=1.5u l=0.13u
MN3530 (storage3521 count_rst vss vss) n12 w=2u l=0.13u
MN3532 (qm3518 clk_high2863 storage3531 vss) n12 w=1.2u l=0.13u
MP3533 (qm3518 clk_highb2864 storage3531 vdd) p12 w=3.6u l=0.13u
MN3534 (lag_sync2_5 clk_low2861 storage3531 vss) n12 w=1.2u l=0.13u
MP3535 (lag_sync2_5 clk_lowb2862 storage3531 vdd) p12 w=3.6u l=0.13u
MN3536 (qb3520 storage3531 vss vss) n12 w=0.5u l=0.13u
MP3537 (qb3520 storage3531 vdd vdd) p12 w=1.5u l=0.13u
MN3538 (lag_sync2_5 qb3520 vss vss) n12 w=0.5u l=0.13u
MP3539 (lag_sync2_5 qb3520 vdd vdd) p12 w=1.5u l=0.13u
MN3540 (storage3531 count_rst vss vss) n12 w=2u l=0.13u
MN3545 (lag_g6 clk_low2861 storage3544 vss) n12 w=1.2u l=0.13u
MP3546 (lag_g6 clk_lowb2862 storage3544 vdd) p12 w=3.6u l=0.13u
MN3547 (qm3541 clk_high2863 storage3544 vss) n12 w=1.2u l=0.13u
MP3548 (qm3541 clk_highb2864 storage3544 vdd) p12 w=3.6u l=0.13u
MN3549 (qmb3542 storage3544 vss vss) n12 w=0.5u l=0.13u
MP3550 (qmb3542 storage3544 vdd vdd) p12 w=1.5u l=0.13u
MN3551 (qm3541 qmb3542 vss vss) n12 w=0.5u l=0.13u
MP3552 (qm3541 qmb3542 vdd vdd) p12 w=1.5u l=0.13u
MN3553 (storage3544 count_rst vss vss) n12 w=2u l=0.13u
MN3555 (qm3541 clk_high2863 storage3554 vss) n12 w=1.2u l=0.13u
MP3556 (qm3541 clk_highb2864 storage3554 vdd) p12 w=3.6u l=0.13u
MN3557 (lag_sync1_6 clk_low2861 storage3554 vss) n12 w=1.2u l=0.13u
MP3558 (lag_sync1_6 clk_lowb2862 storage3554 vdd) p12 w=3.6u l=0.13u
MN3559 (qb3543 storage3554 vss vss) n12 w=0.5u l=0.13u
MP3560 (qb3543 storage3554 vdd vdd) p12 w=1.5u l=0.13u
MN3561 (lag_sync1_6 qb3543 vss vss) n12 w=0.5u l=0.13u
MP3562 (lag_sync1_6 qb3543 vdd vdd) p12 w=1.5u l=0.13u
MN3563 (storage3554 count_rst vss vss) n12 w=2u l=0.13u
MN3568 (lag_sync1_6 clk_low2861 storage3567 vss) n12 w=1.2u l=0.13u
MP3569 (lag_sync1_6 clk_lowb2862 storage3567 vdd) p12 w=3.6u l=0.13u
MN3570 (qm3564 clk_high2863 storage3567 vss) n12 w=1.2u l=0.13u
MP3571 (qm3564 clk_highb2864 storage3567 vdd) p12 w=3.6u l=0.13u
MN3572 (qmb3565 storage3567 vss vss) n12 w=0.5u l=0.13u
MP3573 (qmb3565 storage3567 vdd vdd) p12 w=1.5u l=0.13u
MN3574 (qm3564 qmb3565 vss vss) n12 w=0.5u l=0.13u
MP3575 (qm3564 qmb3565 vdd vdd) p12 w=1.5u l=0.13u
MN3576 (storage3567 count_rst vss vss) n12 w=2u l=0.13u
MN3578 (qm3564 clk_high2863 storage3577 vss) n12 w=1.2u l=0.13u
MP3579 (qm3564 clk_highb2864 storage3577 vdd) p12 w=3.6u l=0.13u
MN3580 (lag_sync2_6 clk_low2861 storage3577 vss) n12 w=1.2u l=0.13u
MP3581 (lag_sync2_6 clk_lowb2862 storage3577 vdd) p12 w=3.6u l=0.13u
MN3582 (qb3566 storage3577 vss vss) n12 w=0.5u l=0.13u
MP3583 (qb3566 storage3577 vdd vdd) p12 w=1.5u l=0.13u
MN3584 (lag_sync2_6 qb3566 vss vss) n12 w=0.5u l=0.13u
MP3585 (lag_sync2_6 qb3566 vdd vdd) p12 w=1.5u l=0.13u
MN3586 (storage3577 count_rst vss vss) n12 w=2u l=0.13u
MN3591 (lag_g7 clk_low2861 storage3590 vss) n12 w=1.2u l=0.13u
MP3592 (lag_g7 clk_lowb2862 storage3590 vdd) p12 w=3.6u l=0.13u
MN3593 (qm3587 clk_high2863 storage3590 vss) n12 w=1.2u l=0.13u
MP3594 (qm3587 clk_highb2864 storage3590 vdd) p12 w=3.6u l=0.13u
MN3595 (qmb3588 storage3590 vss vss) n12 w=0.5u l=0.13u
MP3596 (qmb3588 storage3590 vdd vdd) p12 w=1.5u l=0.13u
MN3597 (qm3587 qmb3588 vss vss) n12 w=0.5u l=0.13u
MP3598 (qm3587 qmb3588 vdd vdd) p12 w=1.5u l=0.13u
MN3599 (storage3590 count_rst vss vss) n12 w=2u l=0.13u
MN3601 (qm3587 clk_high2863 storage3600 vss) n12 w=1.2u l=0.13u
MP3602 (qm3587 clk_highb2864 storage3600 vdd) p12 w=3.6u l=0.13u
MN3603 (lag_sync1_7 clk_low2861 storage3600 vss) n12 w=1.2u l=0.13u
MP3604 (lag_sync1_7 clk_lowb2862 storage3600 vdd) p12 w=3.6u l=0.13u
MN3605 (qb3589 storage3600 vss vss) n12 w=0.5u l=0.13u
MP3606 (qb3589 storage3600 vdd vdd) p12 w=1.5u l=0.13u
MN3607 (lag_sync1_7 qb3589 vss vss) n12 w=0.5u l=0.13u
MP3608 (lag_sync1_7 qb3589 vdd vdd) p12 w=1.5u l=0.13u
MN3609 (storage3600 count_rst vss vss) n12 w=2u l=0.13u
MN3614 (lag_sync1_7 clk_low2861 storage3613 vss) n12 w=1.2u l=0.13u
MP3615 (lag_sync1_7 clk_lowb2862 storage3613 vdd) p12 w=3.6u l=0.13u
MN3616 (qm3610 clk_high2863 storage3613 vss) n12 w=1.2u l=0.13u
MP3617 (qm3610 clk_highb2864 storage3613 vdd) p12 w=3.6u l=0.13u
MN3618 (qmb3611 storage3613 vss vss) n12 w=0.5u l=0.13u
MP3619 (qmb3611 storage3613 vdd vdd) p12 w=1.5u l=0.13u
MN3620 (qm3610 qmb3611 vss vss) n12 w=0.5u l=0.13u
MP3621 (qm3610 qmb3611 vdd vdd) p12 w=1.5u l=0.13u
MN3622 (storage3613 count_rst vss vss) n12 w=2u l=0.13u
MN3624 (qm3610 clk_high2863 storage3623 vss) n12 w=1.2u l=0.13u
MP3625 (qm3610 clk_highb2864 storage3623 vdd) p12 w=3.6u l=0.13u
MN3626 (lag_sync2_7 clk_low2861 storage3623 vss) n12 w=1.2u l=0.13u
MP3627 (lag_sync2_7 clk_lowb2862 storage3623 vdd) p12 w=3.6u l=0.13u
MN3628 (qb3612 storage3623 vss vss) n12 w=0.5u l=0.13u
MP3629 (qb3612 storage3623 vdd vdd) p12 w=1.5u l=0.13u
MN3630 (lag_sync2_7 qb3612 vss vss) n12 w=0.5u l=0.13u
MP3631 (lag_sync2_7 qb3612 vdd vdd) p12 w=1.5u l=0.13u
MN3632 (storage3623 count_rst vss vss) n12 w=2u l=0.13u
MN3637 (div_g0 clk_low2861 storage3636 vss) n12 w=1.2u l=0.13u
MP3638 (div_g0 clk_lowb2862 storage3636 vdd) p12 w=3.6u l=0.13u
MN3639 (qm3633 clk_high2863 storage3636 vss) n12 w=1.2u l=0.13u
MP3640 (qm3633 clk_highb2864 storage3636 vdd) p12 w=3.6u l=0.13u
MN3641 (qmb3634 storage3636 vss vss) n12 w=0.5u l=0.13u
MP3642 (qmb3634 storage3636 vdd vdd) p12 w=1.5u l=0.13u
MN3643 (qm3633 qmb3634 vss vss) n12 w=0.5u l=0.13u
MP3644 (qm3633 qmb3634 vdd vdd) p12 w=1.5u l=0.13u
MN3645 (storage3636 count_rst vss vss) n12 w=2u l=0.13u
MN3647 (qm3633 clk_high2863 storage3646 vss) n12 w=1.2u l=0.13u
MP3648 (qm3633 clk_highb2864 storage3646 vdd) p12 w=3.6u l=0.13u
MN3649 (div_sync1_0 clk_low2861 storage3646 vss) n12 w=1.2u l=0.13u
MP3650 (div_sync1_0 clk_lowb2862 storage3646 vdd) p12 w=3.6u l=0.13u
MN3651 (qb3635 storage3646 vss vss) n12 w=0.5u l=0.13u
MP3652 (qb3635 storage3646 vdd vdd) p12 w=1.5u l=0.13u
MN3653 (div_sync1_0 qb3635 vss vss) n12 w=0.5u l=0.13u
MP3654 (div_sync1_0 qb3635 vdd vdd) p12 w=1.5u l=0.13u
MN3655 (storage3646 count_rst vss vss) n12 w=2u l=0.13u
MN3660 (div_sync1_0 clk_low2861 storage3659 vss) n12 w=1.2u l=0.13u
MP3661 (div_sync1_0 clk_lowb2862 storage3659 vdd) p12 w=3.6u l=0.13u
MN3662 (qm3656 clk_high2863 storage3659 vss) n12 w=1.2u l=0.13u
MP3663 (qm3656 clk_highb2864 storage3659 vdd) p12 w=3.6u l=0.13u
MN3664 (qmb3657 storage3659 vss vss) n12 w=0.5u l=0.13u
MP3665 (qmb3657 storage3659 vdd vdd) p12 w=1.5u l=0.13u
MN3666 (qm3656 qmb3657 vss vss) n12 w=0.5u l=0.13u
MP3667 (qm3656 qmb3657 vdd vdd) p12 w=1.5u l=0.13u
MN3668 (storage3659 count_rst vss vss) n12 w=2u l=0.13u
MN3670 (qm3656 clk_high2863 storage3669 vss) n12 w=1.2u l=0.13u
MP3671 (qm3656 clk_highb2864 storage3669 vdd) p12 w=3.6u l=0.13u
MN3672 (div_sync2_0 clk_low2861 storage3669 vss) n12 w=1.2u l=0.13u
MP3673 (div_sync2_0 clk_lowb2862 storage3669 vdd) p12 w=3.6u l=0.13u
MN3674 (qb3658 storage3669 vss vss) n12 w=0.5u l=0.13u
MP3675 (qb3658 storage3669 vdd vdd) p12 w=1.5u l=0.13u
MN3676 (div_sync2_0 qb3658 vss vss) n12 w=0.5u l=0.13u
MP3677 (div_sync2_0 qb3658 vdd vdd) p12 w=1.5u l=0.13u
MN3678 (storage3669 count_rst vss vss) n12 w=2u l=0.13u
MN3683 (div_g1 clk_low2861 storage3682 vss) n12 w=1.2u l=0.13u
MP3684 (div_g1 clk_lowb2862 storage3682 vdd) p12 w=3.6u l=0.13u
MN3685 (qm3679 clk_high2863 storage3682 vss) n12 w=1.2u l=0.13u
MP3686 (qm3679 clk_highb2864 storage3682 vdd) p12 w=3.6u l=0.13u
MN3687 (qmb3680 storage3682 vss vss) n12 w=0.5u l=0.13u
MP3688 (qmb3680 storage3682 vdd vdd) p12 w=1.5u l=0.13u
MN3689 (qm3679 qmb3680 vss vss) n12 w=0.5u l=0.13u
MP3690 (qm3679 qmb3680 vdd vdd) p12 w=1.5u l=0.13u
MN3691 (storage3682 count_rst vss vss) n12 w=2u l=0.13u
MN3693 (qm3679 clk_high2863 storage3692 vss) n12 w=1.2u l=0.13u
MP3694 (qm3679 clk_highb2864 storage3692 vdd) p12 w=3.6u l=0.13u
MN3695 (div_sync1_1 clk_low2861 storage3692 vss) n12 w=1.2u l=0.13u
MP3696 (div_sync1_1 clk_lowb2862 storage3692 vdd) p12 w=3.6u l=0.13u
MN3697 (qb3681 storage3692 vss vss) n12 w=0.5u l=0.13u
MP3698 (qb3681 storage3692 vdd vdd) p12 w=1.5u l=0.13u
MN3699 (div_sync1_1 qb3681 vss vss) n12 w=0.5u l=0.13u
MP3700 (div_sync1_1 qb3681 vdd vdd) p12 w=1.5u l=0.13u
MN3701 (storage3692 count_rst vss vss) n12 w=2u l=0.13u
MN3706 (div_sync1_1 clk_low2861 storage3705 vss) n12 w=1.2u l=0.13u
MP3707 (div_sync1_1 clk_lowb2862 storage3705 vdd) p12 w=3.6u l=0.13u
MN3708 (qm3702 clk_high2863 storage3705 vss) n12 w=1.2u l=0.13u
MP3709 (qm3702 clk_highb2864 storage3705 vdd) p12 w=3.6u l=0.13u
MN3710 (qmb3703 storage3705 vss vss) n12 w=0.5u l=0.13u
MP3711 (qmb3703 storage3705 vdd vdd) p12 w=1.5u l=0.13u
MN3712 (qm3702 qmb3703 vss vss) n12 w=0.5u l=0.13u
MP3713 (qm3702 qmb3703 vdd vdd) p12 w=1.5u l=0.13u
MN3714 (storage3705 count_rst vss vss) n12 w=2u l=0.13u
MN3716 (qm3702 clk_high2863 storage3715 vss) n12 w=1.2u l=0.13u
MP3717 (qm3702 clk_highb2864 storage3715 vdd) p12 w=3.6u l=0.13u
MN3718 (div_sync2_1 clk_low2861 storage3715 vss) n12 w=1.2u l=0.13u
MP3719 (div_sync2_1 clk_lowb2862 storage3715 vdd) p12 w=3.6u l=0.13u
MN3720 (qb3704 storage3715 vss vss) n12 w=0.5u l=0.13u
MP3721 (qb3704 storage3715 vdd vdd) p12 w=1.5u l=0.13u
MN3722 (div_sync2_1 qb3704 vss vss) n12 w=0.5u l=0.13u
MP3723 (div_sync2_1 qb3704 vdd vdd) p12 w=1.5u l=0.13u
MN3724 (storage3715 count_rst vss vss) n12 w=2u l=0.13u
MN3729 (div_g2 clk_low2861 storage3728 vss) n12 w=1.2u l=0.13u
MP3730 (div_g2 clk_lowb2862 storage3728 vdd) p12 w=3.6u l=0.13u
MN3731 (qm3725 clk_high2863 storage3728 vss) n12 w=1.2u l=0.13u
MP3732 (qm3725 clk_highb2864 storage3728 vdd) p12 w=3.6u l=0.13u
MN3733 (qmb3726 storage3728 vss vss) n12 w=0.5u l=0.13u
MP3734 (qmb3726 storage3728 vdd vdd) p12 w=1.5u l=0.13u
MN3735 (qm3725 qmb3726 vss vss) n12 w=0.5u l=0.13u
MP3736 (qm3725 qmb3726 vdd vdd) p12 w=1.5u l=0.13u
MN3737 (storage3728 count_rst vss vss) n12 w=2u l=0.13u
MN3739 (qm3725 clk_high2863 storage3738 vss) n12 w=1.2u l=0.13u
MP3740 (qm3725 clk_highb2864 storage3738 vdd) p12 w=3.6u l=0.13u
MN3741 (div_sync1_2 clk_low2861 storage3738 vss) n12 w=1.2u l=0.13u
MP3742 (div_sync1_2 clk_lowb2862 storage3738 vdd) p12 w=3.6u l=0.13u
MN3743 (qb3727 storage3738 vss vss) n12 w=0.5u l=0.13u
MP3744 (qb3727 storage3738 vdd vdd) p12 w=1.5u l=0.13u
MN3745 (div_sync1_2 qb3727 vss vss) n12 w=0.5u l=0.13u
MP3746 (div_sync1_2 qb3727 vdd vdd) p12 w=1.5u l=0.13u
MN3747 (storage3738 count_rst vss vss) n12 w=2u l=0.13u
MN3752 (div_sync1_2 clk_low2861 storage3751 vss) n12 w=1.2u l=0.13u
MP3753 (div_sync1_2 clk_lowb2862 storage3751 vdd) p12 w=3.6u l=0.13u
MN3754 (qm3748 clk_high2863 storage3751 vss) n12 w=1.2u l=0.13u
MP3755 (qm3748 clk_highb2864 storage3751 vdd) p12 w=3.6u l=0.13u
MN3756 (qmb3749 storage3751 vss vss) n12 w=0.5u l=0.13u
MP3757 (qmb3749 storage3751 vdd vdd) p12 w=1.5u l=0.13u
MN3758 (qm3748 qmb3749 vss vss) n12 w=0.5u l=0.13u
MP3759 (qm3748 qmb3749 vdd vdd) p12 w=1.5u l=0.13u
MN3760 (storage3751 count_rst vss vss) n12 w=2u l=0.13u
MN3762 (qm3748 clk_high2863 storage3761 vss) n12 w=1.2u l=0.13u
MP3763 (qm3748 clk_highb2864 storage3761 vdd) p12 w=3.6u l=0.13u
MN3764 (div_sync2_2 clk_low2861 storage3761 vss) n12 w=1.2u l=0.13u
MP3765 (div_sync2_2 clk_lowb2862 storage3761 vdd) p12 w=3.6u l=0.13u
MN3766 (qb3750 storage3761 vss vss) n12 w=0.5u l=0.13u
MP3767 (qb3750 storage3761 vdd vdd) p12 w=1.5u l=0.13u
MN3768 (div_sync2_2 qb3750 vss vss) n12 w=0.5u l=0.13u
MP3769 (div_sync2_2 qb3750 vdd vdd) p12 w=1.5u l=0.13u
MN3770 (storage3761 count_rst vss vss) n12 w=2u l=0.13u
MN3775 (div_g3 clk_low2861 storage3774 vss) n12 w=1.2u l=0.13u
MP3776 (div_g3 clk_lowb2862 storage3774 vdd) p12 w=3.6u l=0.13u
MN3777 (qm3771 clk_high2863 storage3774 vss) n12 w=1.2u l=0.13u
MP3778 (qm3771 clk_highb2864 storage3774 vdd) p12 w=3.6u l=0.13u
MN3779 (qmb3772 storage3774 vss vss) n12 w=0.5u l=0.13u
MP3780 (qmb3772 storage3774 vdd vdd) p12 w=1.5u l=0.13u
MN3781 (qm3771 qmb3772 vss vss) n12 w=0.5u l=0.13u
MP3782 (qm3771 qmb3772 vdd vdd) p12 w=1.5u l=0.13u
MN3783 (storage3774 count_rst vss vss) n12 w=2u l=0.13u
MN3785 (qm3771 clk_high2863 storage3784 vss) n12 w=1.2u l=0.13u
MP3786 (qm3771 clk_highb2864 storage3784 vdd) p12 w=3.6u l=0.13u
MN3787 (div_sync1_3 clk_low2861 storage3784 vss) n12 w=1.2u l=0.13u
MP3788 (div_sync1_3 clk_lowb2862 storage3784 vdd) p12 w=3.6u l=0.13u
MN3789 (qb3773 storage3784 vss vss) n12 w=0.5u l=0.13u
MP3790 (qb3773 storage3784 vdd vdd) p12 w=1.5u l=0.13u
MN3791 (div_sync1_3 qb3773 vss vss) n12 w=0.5u l=0.13u
MP3792 (div_sync1_3 qb3773 vdd vdd) p12 w=1.5u l=0.13u
MN3793 (storage3784 count_rst vss vss) n12 w=2u l=0.13u
MN3798 (div_sync1_3 clk_low2861 storage3797 vss) n12 w=1.2u l=0.13u
MP3799 (div_sync1_3 clk_lowb2862 storage3797 vdd) p12 w=3.6u l=0.13u
MN3800 (qm3794 clk_high2863 storage3797 vss) n12 w=1.2u l=0.13u
MP3801 (qm3794 clk_highb2864 storage3797 vdd) p12 w=3.6u l=0.13u
MN3802 (qmb3795 storage3797 vss vss) n12 w=0.5u l=0.13u
MP3803 (qmb3795 storage3797 vdd vdd) p12 w=1.5u l=0.13u
MN3804 (qm3794 qmb3795 vss vss) n12 w=0.5u l=0.13u
MP3805 (qm3794 qmb3795 vdd vdd) p12 w=1.5u l=0.13u
MN3806 (storage3797 count_rst vss vss) n12 w=2u l=0.13u
MN3808 (qm3794 clk_high2863 storage3807 vss) n12 w=1.2u l=0.13u
MP3809 (qm3794 clk_highb2864 storage3807 vdd) p12 w=3.6u l=0.13u
MN3810 (div_sync2_3 clk_low2861 storage3807 vss) n12 w=1.2u l=0.13u
MP3811 (div_sync2_3 clk_lowb2862 storage3807 vdd) p12 w=3.6u l=0.13u
MN3812 (qb3796 storage3807 vss vss) n12 w=0.5u l=0.13u
MP3813 (qb3796 storage3807 vdd vdd) p12 w=1.5u l=0.13u
MN3814 (div_sync2_3 qb3796 vss vss) n12 w=0.5u l=0.13u
MP3815 (div_sync2_3 qb3796 vdd vdd) p12 w=1.5u l=0.13u
MN3816 (storage3807 count_rst vss vss) n12 w=2u l=0.13u
MN3821 (div_g4 clk_low2861 storage3820 vss) n12 w=1.2u l=0.13u
MP3822 (div_g4 clk_lowb2862 storage3820 vdd) p12 w=3.6u l=0.13u
MN3823 (qm3817 clk_high2863 storage3820 vss) n12 w=1.2u l=0.13u
MP3824 (qm3817 clk_highb2864 storage3820 vdd) p12 w=3.6u l=0.13u
MN3825 (qmb3818 storage3820 vss vss) n12 w=0.5u l=0.13u
MP3826 (qmb3818 storage3820 vdd vdd) p12 w=1.5u l=0.13u
MN3827 (qm3817 qmb3818 vss vss) n12 w=0.5u l=0.13u
MP3828 (qm3817 qmb3818 vdd vdd) p12 w=1.5u l=0.13u
MN3829 (storage3820 count_rst vss vss) n12 w=2u l=0.13u
MN3831 (qm3817 clk_high2863 storage3830 vss) n12 w=1.2u l=0.13u
MP3832 (qm3817 clk_highb2864 storage3830 vdd) p12 w=3.6u l=0.13u
MN3833 (div_sync1_4 clk_low2861 storage3830 vss) n12 w=1.2u l=0.13u
MP3834 (div_sync1_4 clk_lowb2862 storage3830 vdd) p12 w=3.6u l=0.13u
MN3835 (qb3819 storage3830 vss vss) n12 w=0.5u l=0.13u
MP3836 (qb3819 storage3830 vdd vdd) p12 w=1.5u l=0.13u
MN3837 (div_sync1_4 qb3819 vss vss) n12 w=0.5u l=0.13u
MP3838 (div_sync1_4 qb3819 vdd vdd) p12 w=1.5u l=0.13u
MN3839 (storage3830 count_rst vss vss) n12 w=2u l=0.13u
MN3844 (div_sync1_4 clk_low2861 storage3843 vss) n12 w=1.2u l=0.13u
MP3845 (div_sync1_4 clk_lowb2862 storage3843 vdd) p12 w=3.6u l=0.13u
MN3846 (qm3840 clk_high2863 storage3843 vss) n12 w=1.2u l=0.13u
MP3847 (qm3840 clk_highb2864 storage3843 vdd) p12 w=3.6u l=0.13u
MN3848 (qmb3841 storage3843 vss vss) n12 w=0.5u l=0.13u
MP3849 (qmb3841 storage3843 vdd vdd) p12 w=1.5u l=0.13u
MN3850 (qm3840 qmb3841 vss vss) n12 w=0.5u l=0.13u
MP3851 (qm3840 qmb3841 vdd vdd) p12 w=1.5u l=0.13u
MN3852 (storage3843 count_rst vss vss) n12 w=2u l=0.13u
MN3854 (qm3840 clk_high2863 storage3853 vss) n12 w=1.2u l=0.13u
MP3855 (qm3840 clk_highb2864 storage3853 vdd) p12 w=3.6u l=0.13u
MN3856 (div_sync2_4 clk_low2861 storage3853 vss) n12 w=1.2u l=0.13u
MP3857 (div_sync2_4 clk_lowb2862 storage3853 vdd) p12 w=3.6u l=0.13u
MN3858 (qb3842 storage3853 vss vss) n12 w=0.5u l=0.13u
MP3859 (qb3842 storage3853 vdd vdd) p12 w=1.5u l=0.13u
MN3860 (div_sync2_4 qb3842 vss vss) n12 w=0.5u l=0.13u
MP3861 (div_sync2_4 qb3842 vdd vdd) p12 w=1.5u l=0.13u
MN3862 (storage3853 count_rst vss vss) n12 w=2u l=0.13u
MN3867 (div_g5 clk_low2861 storage3866 vss) n12 w=1.2u l=0.13u
MP3868 (div_g5 clk_lowb2862 storage3866 vdd) p12 w=3.6u l=0.13u
MN3869 (qm3863 clk_high2863 storage3866 vss) n12 w=1.2u l=0.13u
MP3870 (qm3863 clk_highb2864 storage3866 vdd) p12 w=3.6u l=0.13u
MN3871 (qmb3864 storage3866 vss vss) n12 w=0.5u l=0.13u
MP3872 (qmb3864 storage3866 vdd vdd) p12 w=1.5u l=0.13u
MN3873 (qm3863 qmb3864 vss vss) n12 w=0.5u l=0.13u
MP3874 (qm3863 qmb3864 vdd vdd) p12 w=1.5u l=0.13u
MN3875 (storage3866 count_rst vss vss) n12 w=2u l=0.13u
MN3877 (qm3863 clk_high2863 storage3876 vss) n12 w=1.2u l=0.13u
MP3878 (qm3863 clk_highb2864 storage3876 vdd) p12 w=3.6u l=0.13u
MN3879 (div_sync1_5 clk_low2861 storage3876 vss) n12 w=1.2u l=0.13u
MP3880 (div_sync1_5 clk_lowb2862 storage3876 vdd) p12 w=3.6u l=0.13u
MN3881 (qb3865 storage3876 vss vss) n12 w=0.5u l=0.13u
MP3882 (qb3865 storage3876 vdd vdd) p12 w=1.5u l=0.13u
MN3883 (div_sync1_5 qb3865 vss vss) n12 w=0.5u l=0.13u
MP3884 (div_sync1_5 qb3865 vdd vdd) p12 w=1.5u l=0.13u
MN3885 (storage3876 count_rst vss vss) n12 w=2u l=0.13u
MN3890 (div_sync1_5 clk_low2861 storage3889 vss) n12 w=1.2u l=0.13u
MP3891 (div_sync1_5 clk_lowb2862 storage3889 vdd) p12 w=3.6u l=0.13u
MN3892 (qm3886 clk_high2863 storage3889 vss) n12 w=1.2u l=0.13u
MP3893 (qm3886 clk_highb2864 storage3889 vdd) p12 w=3.6u l=0.13u
MN3894 (qmb3887 storage3889 vss vss) n12 w=0.5u l=0.13u
MP3895 (qmb3887 storage3889 vdd vdd) p12 w=1.5u l=0.13u
MN3896 (qm3886 qmb3887 vss vss) n12 w=0.5u l=0.13u
MP3897 (qm3886 qmb3887 vdd vdd) p12 w=1.5u l=0.13u
MN3898 (storage3889 count_rst vss vss) n12 w=2u l=0.13u
MN3900 (qm3886 clk_high2863 storage3899 vss) n12 w=1.2u l=0.13u
MP3901 (qm3886 clk_highb2864 storage3899 vdd) p12 w=3.6u l=0.13u
MN3902 (div_sync2_5 clk_low2861 storage3899 vss) n12 w=1.2u l=0.13u
MP3903 (div_sync2_5 clk_lowb2862 storage3899 vdd) p12 w=3.6u l=0.13u
MN3904 (qb3888 storage3899 vss vss) n12 w=0.5u l=0.13u
MP3905 (qb3888 storage3899 vdd vdd) p12 w=1.5u l=0.13u
MN3906 (div_sync2_5 qb3888 vss vss) n12 w=0.5u l=0.13u
MP3907 (div_sync2_5 qb3888 vdd vdd) p12 w=1.5u l=0.13u
MN3908 (storage3899 count_rst vss vss) n12 w=2u l=0.13u
MN3913 (div_g6 clk_low2861 storage3912 vss) n12 w=1.2u l=0.13u
MP3914 (div_g6 clk_lowb2862 storage3912 vdd) p12 w=3.6u l=0.13u
MN3915 (qm3909 clk_high2863 storage3912 vss) n12 w=1.2u l=0.13u
MP3916 (qm3909 clk_highb2864 storage3912 vdd) p12 w=3.6u l=0.13u
MN3917 (qmb3910 storage3912 vss vss) n12 w=0.5u l=0.13u
MP3918 (qmb3910 storage3912 vdd vdd) p12 w=1.5u l=0.13u
MN3919 (qm3909 qmb3910 vss vss) n12 w=0.5u l=0.13u
MP3920 (qm3909 qmb3910 vdd vdd) p12 w=1.5u l=0.13u
MN3921 (storage3912 count_rst vss vss) n12 w=2u l=0.13u
MN3923 (qm3909 clk_high2863 storage3922 vss) n12 w=1.2u l=0.13u
MP3924 (qm3909 clk_highb2864 storage3922 vdd) p12 w=3.6u l=0.13u
MN3925 (div_sync1_6 clk_low2861 storage3922 vss) n12 w=1.2u l=0.13u
MP3926 (div_sync1_6 clk_lowb2862 storage3922 vdd) p12 w=3.6u l=0.13u
MN3927 (qb3911 storage3922 vss vss) n12 w=0.5u l=0.13u
MP3928 (qb3911 storage3922 vdd vdd) p12 w=1.5u l=0.13u
MN3929 (div_sync1_6 qb3911 vss vss) n12 w=0.5u l=0.13u
MP3930 (div_sync1_6 qb3911 vdd vdd) p12 w=1.5u l=0.13u
MN3931 (storage3922 count_rst vss vss) n12 w=2u l=0.13u
MN3936 (div_sync1_6 clk_low2861 storage3935 vss) n12 w=1.2u l=0.13u
MP3937 (div_sync1_6 clk_lowb2862 storage3935 vdd) p12 w=3.6u l=0.13u
MN3938 (qm3932 clk_high2863 storage3935 vss) n12 w=1.2u l=0.13u
MP3939 (qm3932 clk_highb2864 storage3935 vdd) p12 w=3.6u l=0.13u
MN3940 (qmb3933 storage3935 vss vss) n12 w=0.5u l=0.13u
MP3941 (qmb3933 storage3935 vdd vdd) p12 w=1.5u l=0.13u
MN3942 (qm3932 qmb3933 vss vss) n12 w=0.5u l=0.13u
MP3943 (qm3932 qmb3933 vdd vdd) p12 w=1.5u l=0.13u
MN3944 (storage3935 count_rst vss vss) n12 w=2u l=0.13u
MN3946 (qm3932 clk_high2863 storage3945 vss) n12 w=1.2u l=0.13u
MP3947 (qm3932 clk_highb2864 storage3945 vdd) p12 w=3.6u l=0.13u
MN3948 (div_sync2_6 clk_low2861 storage3945 vss) n12 w=1.2u l=0.13u
MP3949 (div_sync2_6 clk_lowb2862 storage3945 vdd) p12 w=3.6u l=0.13u
MN3950 (qb3934 storage3945 vss vss) n12 w=0.5u l=0.13u
MP3951 (qb3934 storage3945 vdd vdd) p12 w=1.5u l=0.13u
MN3952 (div_sync2_6 qb3934 vss vss) n12 w=0.5u l=0.13u
MP3953 (div_sync2_6 qb3934 vdd vdd) p12 w=1.5u l=0.13u
MN3954 (storage3945 count_rst vss vss) n12 w=2u l=0.13u
MN3959 (div_g7 clk_low2861 storage3958 vss) n12 w=1.2u l=0.13u
MP3960 (div_g7 clk_lowb2862 storage3958 vdd) p12 w=3.6u l=0.13u
MN3961 (qm3955 clk_high2863 storage3958 vss) n12 w=1.2u l=0.13u
MP3962 (qm3955 clk_highb2864 storage3958 vdd) p12 w=3.6u l=0.13u
MN3963 (qmb3956 storage3958 vss vss) n12 w=0.5u l=0.13u
MP3964 (qmb3956 storage3958 vdd vdd) p12 w=1.5u l=0.13u
MN3965 (qm3955 qmb3956 vss vss) n12 w=0.5u l=0.13u
MP3966 (qm3955 qmb3956 vdd vdd) p12 w=1.5u l=0.13u
MN3967 (storage3958 count_rst vss vss) n12 w=2u l=0.13u
MN3969 (qm3955 clk_high2863 storage3968 vss) n12 w=1.2u l=0.13u
MP3970 (qm3955 clk_highb2864 storage3968 vdd) p12 w=3.6u l=0.13u
MN3971 (div_sync1_7 clk_low2861 storage3968 vss) n12 w=1.2u l=0.13u
MP3972 (div_sync1_7 clk_lowb2862 storage3968 vdd) p12 w=3.6u l=0.13u
MN3973 (qb3957 storage3968 vss vss) n12 w=0.5u l=0.13u
MP3974 (qb3957 storage3968 vdd vdd) p12 w=1.5u l=0.13u
MN3975 (div_sync1_7 qb3957 vss vss) n12 w=0.5u l=0.13u
MP3976 (div_sync1_7 qb3957 vdd vdd) p12 w=1.5u l=0.13u
MN3977 (storage3968 count_rst vss vss) n12 w=2u l=0.13u
MN3982 (div_sync1_7 clk_low2861 storage3981 vss) n12 w=1.2u l=0.13u
MP3983 (div_sync1_7 clk_lowb2862 storage3981 vdd) p12 w=3.6u l=0.13u
MN3984 (qm3978 clk_high2863 storage3981 vss) n12 w=1.2u l=0.13u
MP3985 (qm3978 clk_highb2864 storage3981 vdd) p12 w=3.6u l=0.13u
MN3986 (qmb3979 storage3981 vss vss) n12 w=0.5u l=0.13u
MP3987 (qmb3979 storage3981 vdd vdd) p12 w=1.5u l=0.13u
MN3988 (qm3978 qmb3979 vss vss) n12 w=0.5u l=0.13u
MP3989 (qm3978 qmb3979 vdd vdd) p12 w=1.5u l=0.13u
MN3990 (storage3981 count_rst vss vss) n12 w=2u l=0.13u
MN3992 (qm3978 clk_high2863 storage3991 vss) n12 w=1.2u l=0.13u
MP3993 (qm3978 clk_highb2864 storage3991 vdd) p12 w=3.6u l=0.13u
MN3994 (div_sync2_7 clk_low2861 storage3991 vss) n12 w=1.2u l=0.13u
MP3995 (div_sync2_7 clk_lowb2862 storage3991 vdd) p12 w=3.6u l=0.13u
MN3996 (qb3980 storage3991 vss vss) n12 w=0.5u l=0.13u
MP3997 (qb3980 storage3991 vdd vdd) p12 w=1.5u l=0.13u
MN3998 (div_sync2_7 qb3980 vss vss) n12 w=0.5u l=0.13u
MP3999 (div_sync2_7 qb3980 vdd vdd) p12 w=1.5u l=0.13u
MN4000 (storage3991 count_rst vss vss) n12 w=2u l=0.13u
MN4003 (n4001 lead_sync2_6 n4002 vss) n12 w=1.6u l=0.13u
MN4004 (n4002 lead_sync2_7 vss vss) n12 w=1.6u l=0.13u
MP4005 (n4001 lead_sync2_6 vdd vdd) p12 w=2.4u l=0.13u
MP4006 (n4001 lead_sync2_7 vdd vdd) p12 w=2.4u l=0.13u
MN4009 (n4007 lead_sync2_6 n4008 vss) n12 w=1.6u l=0.13u
MN4010 (n4008 n4001 vss vss) n12 w=1.6u l=0.13u
MP4011 (n4007 lead_sync2_6 vdd vdd) p12 w=2.4u l=0.13u
MP4012 (n4007 n4001 vdd vdd) p12 w=2.4u l=0.13u
MN4015 (n4013 lead_sync2_7 n4014 vss) n12 w=1.6u l=0.13u
MN4016 (n4014 n4001 vss vss) n12 w=1.6u l=0.13u
MP4017 (n4013 lead_sync2_7 vdd vdd) p12 w=2.4u l=0.13u
MP4018 (n4013 n4001 vdd vdd) p12 w=2.4u l=0.13u
MN4021 (n4019 n4007 n4020 vss) n12 w=1.6u l=0.13u
MN4022 (n4020 n4013 vss vss) n12 w=1.6u l=0.13u
MP4023 (n4019 n4007 vdd vdd) p12 w=2.4u l=0.13u
MP4024 (n4019 n4013 vdd vdd) p12 w=2.4u l=0.13u
MN4027 (n4025 lead_sync2_5 n4026 vss) n12 w=1.6u l=0.13u
MN4028 (n4026 n4019 vss vss) n12 w=1.6u l=0.13u
MP4029 (n4025 lead_sync2_5 vdd vdd) p12 w=2.4u l=0.13u
MP4030 (n4025 n4019 vdd vdd) p12 w=2.4u l=0.13u
MN4033 (n4031 lead_sync2_5 n4032 vss) n12 w=1.6u l=0.13u
MN4034 (n4032 n4025 vss vss) n12 w=1.6u l=0.13u
MP4035 (n4031 lead_sync2_5 vdd vdd) p12 w=2.4u l=0.13u
MP4036 (n4031 n4025 vdd vdd) p12 w=2.4u l=0.13u
MN4039 (n4037 n4019 n4038 vss) n12 w=1.6u l=0.13u
MN4040 (n4038 n4025 vss vss) n12 w=1.6u l=0.13u
MP4041 (n4037 n4019 vdd vdd) p12 w=2.4u l=0.13u
MP4042 (n4037 n4025 vdd vdd) p12 w=2.4u l=0.13u
MN4045 (n4043 n4031 n4044 vss) n12 w=1.6u l=0.13u
MN4046 (n4044 n4037 vss vss) n12 w=1.6u l=0.13u
MP4047 (n4043 n4031 vdd vdd) p12 w=2.4u l=0.13u
MP4048 (n4043 n4037 vdd vdd) p12 w=2.4u l=0.13u
MN4051 (n4049 lead_sync2_4 n4050 vss) n12 w=1.6u l=0.13u
MN4052 (n4050 n4043 vss vss) n12 w=1.6u l=0.13u
MP4053 (n4049 lead_sync2_4 vdd vdd) p12 w=2.4u l=0.13u
MP4054 (n4049 n4043 vdd vdd) p12 w=2.4u l=0.13u
MN4057 (n4055 lead_sync2_4 n4056 vss) n12 w=1.6u l=0.13u
MN4058 (n4056 n4049 vss vss) n12 w=1.6u l=0.13u
MP4059 (n4055 lead_sync2_4 vdd vdd) p12 w=2.4u l=0.13u
MP4060 (n4055 n4049 vdd vdd) p12 w=2.4u l=0.13u
MN4063 (n4061 n4043 n4062 vss) n12 w=1.6u l=0.13u
MN4064 (n4062 n4049 vss vss) n12 w=1.6u l=0.13u
MP4065 (n4061 n4043 vdd vdd) p12 w=2.4u l=0.13u
MP4066 (n4061 n4049 vdd vdd) p12 w=2.4u l=0.13u
MN4069 (n4067 n4055 n4068 vss) n12 w=1.6u l=0.13u
MN4070 (n4068 n4061 vss vss) n12 w=1.6u l=0.13u
MP4071 (n4067 n4055 vdd vdd) p12 w=2.4u l=0.13u
MP4072 (n4067 n4061 vdd vdd) p12 w=2.4u l=0.13u
MN4075 (n4073 lead_sync2_3 n4074 vss) n12 w=1.6u l=0.13u
MN4076 (n4074 n4067 vss vss) n12 w=1.6u l=0.13u
MP4077 (n4073 lead_sync2_3 vdd vdd) p12 w=2.4u l=0.13u
MP4078 (n4073 n4067 vdd vdd) p12 w=2.4u l=0.13u
MN4081 (n4079 lead_sync2_3 n4080 vss) n12 w=1.6u l=0.13u
MN4082 (n4080 n4073 vss vss) n12 w=1.6u l=0.13u
MP4083 (n4079 lead_sync2_3 vdd vdd) p12 w=2.4u l=0.13u
MP4084 (n4079 n4073 vdd vdd) p12 w=2.4u l=0.13u
MN4087 (n4085 n4067 n4086 vss) n12 w=1.6u l=0.13u
MN4088 (n4086 n4073 vss vss) n12 w=1.6u l=0.13u
MP4089 (n4085 n4067 vdd vdd) p12 w=2.4u l=0.13u
MP4090 (n4085 n4073 vdd vdd) p12 w=2.4u l=0.13u
MN4093 (n4091 n4079 n4092 vss) n12 w=1.6u l=0.13u
MN4094 (n4092 n4085 vss vss) n12 w=1.6u l=0.13u
MP4095 (n4091 n4079 vdd vdd) p12 w=2.4u l=0.13u
MP4096 (n4091 n4085 vdd vdd) p12 w=2.4u l=0.13u
MN4099 (n4097 lead_sync2_2 n4098 vss) n12 w=1.6u l=0.13u
MN4100 (n4098 n4091 vss vss) n12 w=1.6u l=0.13u
MP4101 (n4097 lead_sync2_2 vdd vdd) p12 w=2.4u l=0.13u
MP4102 (n4097 n4091 vdd vdd) p12 w=2.4u l=0.13u
MN4105 (n4103 lead_sync2_2 n4104 vss) n12 w=1.6u l=0.13u
MN4106 (n4104 n4097 vss vss) n12 w=1.6u l=0.13u
MP4107 (n4103 lead_sync2_2 vdd vdd) p12 w=2.4u l=0.13u
MP4108 (n4103 n4097 vdd vdd) p12 w=2.4u l=0.13u
MN4111 (n4109 n4091 n4110 vss) n12 w=1.6u l=0.13u
MN4112 (n4110 n4097 vss vss) n12 w=1.6u l=0.13u
MP4113 (n4109 n4091 vdd vdd) p12 w=2.4u l=0.13u
MP4114 (n4109 n4097 vdd vdd) p12 w=2.4u l=0.13u
MN4117 (n4115 n4103 n4116 vss) n12 w=1.6u l=0.13u
MN4118 (n4116 n4109 vss vss) n12 w=1.6u l=0.13u
MP4119 (n4115 n4103 vdd vdd) p12 w=2.4u l=0.13u
MP4120 (n4115 n4109 vdd vdd) p12 w=2.4u l=0.13u
MN4123 (n4121 lead_sync2_1 n4122 vss) n12 w=1.6u l=0.13u
MN4124 (n4122 n4115 vss vss) n12 w=1.6u l=0.13u
MP4125 (n4121 lead_sync2_1 vdd vdd) p12 w=2.4u l=0.13u
MP4126 (n4121 n4115 vdd vdd) p12 w=2.4u l=0.13u
MN4129 (n4127 lead_sync2_1 n4128 vss) n12 w=1.6u l=0.13u
MN4130 (n4128 n4121 vss vss) n12 w=1.6u l=0.13u
MP4131 (n4127 lead_sync2_1 vdd vdd) p12 w=2.4u l=0.13u
MP4132 (n4127 n4121 vdd vdd) p12 w=2.4u l=0.13u
MN4135 (n4133 n4115 n4134 vss) n12 w=1.6u l=0.13u
MN4136 (n4134 n4121 vss vss) n12 w=1.6u l=0.13u
MP4137 (n4133 n4115 vdd vdd) p12 w=2.4u l=0.13u
MP4138 (n4133 n4121 vdd vdd) p12 w=2.4u l=0.13u
MN4141 (n4139 n4127 n4140 vss) n12 w=1.6u l=0.13u
MN4142 (n4140 n4133 vss vss) n12 w=1.6u l=0.13u
MP4143 (n4139 n4127 vdd vdd) p12 w=2.4u l=0.13u
MP4144 (n4139 n4133 vdd vdd) p12 w=2.4u l=0.13u
MN4147 (n4145 lead_sync2_0 n4146 vss) n12 w=1.6u l=0.13u
MN4148 (n4146 n4139 vss vss) n12 w=1.6u l=0.13u
MP4149 (n4145 lead_sync2_0 vdd vdd) p12 w=2.4u l=0.13u
MP4150 (n4145 n4139 vdd vdd) p12 w=2.4u l=0.13u
MN4153 (n4151 lead_sync2_0 n4152 vss) n12 w=1.6u l=0.13u
MN4154 (n4152 n4145 vss vss) n12 w=1.6u l=0.13u
MP4155 (n4151 lead_sync2_0 vdd vdd) p12 w=2.4u l=0.13u
MP4156 (n4151 n4145 vdd vdd) p12 w=2.4u l=0.13u
MN4159 (n4157 n4139 n4158 vss) n12 w=1.6u l=0.13u
MN4160 (n4158 n4145 vss vss) n12 w=1.6u l=0.13u
MP4161 (n4157 n4139 vdd vdd) p12 w=2.4u l=0.13u
MP4162 (n4157 n4145 vdd vdd) p12 w=2.4u l=0.13u
MN4165 (n4163 n4151 n4164 vss) n12 w=1.6u l=0.13u
MN4166 (n4164 n4157 vss vss) n12 w=1.6u l=0.13u
MP4167 (n4163 n4151 vdd vdd) p12 w=2.4u l=0.13u
MP4168 (n4163 n4157 vdd vdd) p12 w=2.4u l=0.13u
MN4170 (n4169 n4163 vss vss) n12 w=0.8u l=0.13u
MP4171 (n4169 n4163 vdd vdd) p12 w=2.4u l=0.13u
MN4173 (n4172 n4169 vss vss) n12 w=0.8u l=0.13u
MP4174 (n4172 n4169 vdd vdd) p12 w=2.4u l=0.13u
MN4176 (n4175 n4172 vss vss) n12 w=0.8u l=0.13u
MP4177 (n4175 n4172 vdd vdd) p12 w=2.4u l=0.13u
MN4178 (cl0 n4175 vss vss) n12 w=0.8u l=0.13u
MP4179 (cl0 n4175 vdd vdd) p12 w=2.4u l=0.13u
MN4181 (n4180 n4139 vss vss) n12 w=0.8u l=0.13u
MP4182 (n4180 n4139 vdd vdd) p12 w=2.4u l=0.13u
MN4184 (n4183 n4180 vss vss) n12 w=0.8u l=0.13u
MP4185 (n4183 n4180 vdd vdd) p12 w=2.4u l=0.13u
MN4187 (n4186 n4183 vss vss) n12 w=0.8u l=0.13u
MP4188 (n4186 n4183 vdd vdd) p12 w=2.4u l=0.13u
MN4189 (cl1 n4186 vss vss) n12 w=0.8u l=0.13u
MP4190 (cl1 n4186 vdd vdd) p12 w=2.4u l=0.13u
MN4192 (n4191 n4115 vss vss) n12 w=0.8u l=0.13u
MP4193 (n4191 n4115 vdd vdd) p12 w=2.4u l=0.13u
MN4195 (n4194 n4191 vss vss) n12 w=0.8u l=0.13u
MP4196 (n4194 n4191 vdd vdd) p12 w=2.4u l=0.13u
MN4198 (n4197 n4194 vss vss) n12 w=0.8u l=0.13u
MP4199 (n4197 n4194 vdd vdd) p12 w=2.4u l=0.13u
MN4200 (cl2 n4197 vss vss) n12 w=0.8u l=0.13u
MP4201 (cl2 n4197 vdd vdd) p12 w=2.4u l=0.13u
MN4203 (n4202 n4091 vss vss) n12 w=0.8u l=0.13u
MP4204 (n4202 n4091 vdd vdd) p12 w=2.4u l=0.13u
MN4206 (n4205 n4202 vss vss) n12 w=0.8u l=0.13u
MP4207 (n4205 n4202 vdd vdd) p12 w=2.4u l=0.13u
MN4209 (n4208 n4205 vss vss) n12 w=0.8u l=0.13u
MP4210 (n4208 n4205 vdd vdd) p12 w=2.4u l=0.13u
MN4211 (cl3 n4208 vss vss) n12 w=0.8u l=0.13u
MP4212 (cl3 n4208 vdd vdd) p12 w=2.4u l=0.13u
MN4214 (n4213 n4067 vss vss) n12 w=0.8u l=0.13u
MP4215 (n4213 n4067 vdd vdd) p12 w=2.4u l=0.13u
MN4217 (n4216 n4213 vss vss) n12 w=0.8u l=0.13u
MP4218 (n4216 n4213 vdd vdd) p12 w=2.4u l=0.13u
MN4220 (n4219 n4216 vss vss) n12 w=0.8u l=0.13u
MP4221 (n4219 n4216 vdd vdd) p12 w=2.4u l=0.13u
MN4222 (cl4 n4219 vss vss) n12 w=0.8u l=0.13u
MP4223 (cl4 n4219 vdd vdd) p12 w=2.4u l=0.13u
MN4225 (n4224 n4043 vss vss) n12 w=0.8u l=0.13u
MP4226 (n4224 n4043 vdd vdd) p12 w=2.4u l=0.13u
MN4228 (n4227 n4224 vss vss) n12 w=0.8u l=0.13u
MP4229 (n4227 n4224 vdd vdd) p12 w=2.4u l=0.13u
MN4231 (n4230 n4227 vss vss) n12 w=0.8u l=0.13u
MP4232 (n4230 n4227 vdd vdd) p12 w=2.4u l=0.13u
MN4233 (cl5 n4230 vss vss) n12 w=0.8u l=0.13u
MP4234 (cl5 n4230 vdd vdd) p12 w=2.4u l=0.13u
MN4236 (n4235 n4019 vss vss) n12 w=0.8u l=0.13u
MP4237 (n4235 n4019 vdd vdd) p12 w=2.4u l=0.13u
MN4239 (n4238 n4235 vss vss) n12 w=0.8u l=0.13u
MP4240 (n4238 n4235 vdd vdd) p12 w=2.4u l=0.13u
MN4242 (n4241 n4238 vss vss) n12 w=0.8u l=0.13u
MP4243 (n4241 n4238 vdd vdd) p12 w=2.4u l=0.13u
MN4244 (cl6 n4241 vss vss) n12 w=0.8u l=0.13u
MP4245 (cl6 n4241 vdd vdd) p12 w=2.4u l=0.13u
MN4247 (n4246 lead_sync2_7 vss vss) n12 w=0.8u l=0.13u
MP4248 (n4246 lead_sync2_7 vdd vdd) p12 w=2.4u l=0.13u
MN4250 (n4249 n4246 vss vss) n12 w=0.8u l=0.13u
MP4251 (n4249 n4246 vdd vdd) p12 w=2.4u l=0.13u
MN4253 (n4252 n4249 vss vss) n12 w=0.8u l=0.13u
MP4254 (n4252 n4249 vdd vdd) p12 w=2.4u l=0.13u
MN4255 (cl7 n4252 vss vss) n12 w=0.8u l=0.13u
MP4256 (cl7 n4252 vdd vdd) p12 w=2.4u l=0.13u
MN4259 (n4257 lag_sync2_6 n4258 vss) n12 w=1.6u l=0.13u
MN4260 (n4258 lag_sync2_7 vss vss) n12 w=1.6u l=0.13u
MP4261 (n4257 lag_sync2_6 vdd vdd) p12 w=2.4u l=0.13u
MP4262 (n4257 lag_sync2_7 vdd vdd) p12 w=2.4u l=0.13u
MN4265 (n4263 lag_sync2_6 n4264 vss) n12 w=1.6u l=0.13u
MN4266 (n4264 n4257 vss vss) n12 w=1.6u l=0.13u
MP4267 (n4263 lag_sync2_6 vdd vdd) p12 w=2.4u l=0.13u
MP4268 (n4263 n4257 vdd vdd) p12 w=2.4u l=0.13u
MN4271 (n4269 lag_sync2_7 n4270 vss) n12 w=1.6u l=0.13u
MN4272 (n4270 n4257 vss vss) n12 w=1.6u l=0.13u
MP4273 (n4269 lag_sync2_7 vdd vdd) p12 w=2.4u l=0.13u
MP4274 (n4269 n4257 vdd vdd) p12 w=2.4u l=0.13u
MN4277 (n4275 n4263 n4276 vss) n12 w=1.6u l=0.13u
MN4278 (n4276 n4269 vss vss) n12 w=1.6u l=0.13u
MP4279 (n4275 n4263 vdd vdd) p12 w=2.4u l=0.13u
MP4280 (n4275 n4269 vdd vdd) p12 w=2.4u l=0.13u
MN4283 (n4281 lag_sync2_5 n4282 vss) n12 w=1.6u l=0.13u
MN4284 (n4282 n4275 vss vss) n12 w=1.6u l=0.13u
MP4285 (n4281 lag_sync2_5 vdd vdd) p12 w=2.4u l=0.13u
MP4286 (n4281 n4275 vdd vdd) p12 w=2.4u l=0.13u
MN4289 (n4287 lag_sync2_5 n4288 vss) n12 w=1.6u l=0.13u
MN4290 (n4288 n4281 vss vss) n12 w=1.6u l=0.13u
MP4291 (n4287 lag_sync2_5 vdd vdd) p12 w=2.4u l=0.13u
MP4292 (n4287 n4281 vdd vdd) p12 w=2.4u l=0.13u
MN4295 (n4293 n4275 n4294 vss) n12 w=1.6u l=0.13u
MN4296 (n4294 n4281 vss vss) n12 w=1.6u l=0.13u
MP4297 (n4293 n4275 vdd vdd) p12 w=2.4u l=0.13u
MP4298 (n4293 n4281 vdd vdd) p12 w=2.4u l=0.13u
MN4301 (n4299 n4287 n4300 vss) n12 w=1.6u l=0.13u
MN4302 (n4300 n4293 vss vss) n12 w=1.6u l=0.13u
MP4303 (n4299 n4287 vdd vdd) p12 w=2.4u l=0.13u
MP4304 (n4299 n4293 vdd vdd) p12 w=2.4u l=0.13u
MN4307 (n4305 lag_sync2_4 n4306 vss) n12 w=1.6u l=0.13u
MN4308 (n4306 n4299 vss vss) n12 w=1.6u l=0.13u
MP4309 (n4305 lag_sync2_4 vdd vdd) p12 w=2.4u l=0.13u
MP4310 (n4305 n4299 vdd vdd) p12 w=2.4u l=0.13u
MN4313 (n4311 lag_sync2_4 n4312 vss) n12 w=1.6u l=0.13u
MN4314 (n4312 n4305 vss vss) n12 w=1.6u l=0.13u
MP4315 (n4311 lag_sync2_4 vdd vdd) p12 w=2.4u l=0.13u
MP4316 (n4311 n4305 vdd vdd) p12 w=2.4u l=0.13u
MN4319 (n4317 n4299 n4318 vss) n12 w=1.6u l=0.13u
MN4320 (n4318 n4305 vss vss) n12 w=1.6u l=0.13u
MP4321 (n4317 n4299 vdd vdd) p12 w=2.4u l=0.13u
MP4322 (n4317 n4305 vdd vdd) p12 w=2.4u l=0.13u
MN4325 (n4323 n4311 n4324 vss) n12 w=1.6u l=0.13u
MN4326 (n4324 n4317 vss vss) n12 w=1.6u l=0.13u
MP4327 (n4323 n4311 vdd vdd) p12 w=2.4u l=0.13u
MP4328 (n4323 n4317 vdd vdd) p12 w=2.4u l=0.13u
MN4331 (n4329 lag_sync2_3 n4330 vss) n12 w=1.6u l=0.13u
MN4332 (n4330 n4323 vss vss) n12 w=1.6u l=0.13u
MP4333 (n4329 lag_sync2_3 vdd vdd) p12 w=2.4u l=0.13u
MP4334 (n4329 n4323 vdd vdd) p12 w=2.4u l=0.13u
MN4337 (n4335 lag_sync2_3 n4336 vss) n12 w=1.6u l=0.13u
MN4338 (n4336 n4329 vss vss) n12 w=1.6u l=0.13u
MP4339 (n4335 lag_sync2_3 vdd vdd) p12 w=2.4u l=0.13u
MP4340 (n4335 n4329 vdd vdd) p12 w=2.4u l=0.13u
MN4343 (n4341 n4323 n4342 vss) n12 w=1.6u l=0.13u
MN4344 (n4342 n4329 vss vss) n12 w=1.6u l=0.13u
MP4345 (n4341 n4323 vdd vdd) p12 w=2.4u l=0.13u
MP4346 (n4341 n4329 vdd vdd) p12 w=2.4u l=0.13u
MN4349 (n4347 n4335 n4348 vss) n12 w=1.6u l=0.13u
MN4350 (n4348 n4341 vss vss) n12 w=1.6u l=0.13u
MP4351 (n4347 n4335 vdd vdd) p12 w=2.4u l=0.13u
MP4352 (n4347 n4341 vdd vdd) p12 w=2.4u l=0.13u
MN4355 (n4353 lag_sync2_2 n4354 vss) n12 w=1.6u l=0.13u
MN4356 (n4354 n4347 vss vss) n12 w=1.6u l=0.13u
MP4357 (n4353 lag_sync2_2 vdd vdd) p12 w=2.4u l=0.13u
MP4358 (n4353 n4347 vdd vdd) p12 w=2.4u l=0.13u
MN4361 (n4359 lag_sync2_2 n4360 vss) n12 w=1.6u l=0.13u
MN4362 (n4360 n4353 vss vss) n12 w=1.6u l=0.13u
MP4363 (n4359 lag_sync2_2 vdd vdd) p12 w=2.4u l=0.13u
MP4364 (n4359 n4353 vdd vdd) p12 w=2.4u l=0.13u
MN4367 (n4365 n4347 n4366 vss) n12 w=1.6u l=0.13u
MN4368 (n4366 n4353 vss vss) n12 w=1.6u l=0.13u
MP4369 (n4365 n4347 vdd vdd) p12 w=2.4u l=0.13u
MP4370 (n4365 n4353 vdd vdd) p12 w=2.4u l=0.13u
MN4373 (n4371 n4359 n4372 vss) n12 w=1.6u l=0.13u
MN4374 (n4372 n4365 vss vss) n12 w=1.6u l=0.13u
MP4375 (n4371 n4359 vdd vdd) p12 w=2.4u l=0.13u
MP4376 (n4371 n4365 vdd vdd) p12 w=2.4u l=0.13u
MN4379 (n4377 lag_sync2_1 n4378 vss) n12 w=1.6u l=0.13u
MN4380 (n4378 n4371 vss vss) n12 w=1.6u l=0.13u
MP4381 (n4377 lag_sync2_1 vdd vdd) p12 w=2.4u l=0.13u
MP4382 (n4377 n4371 vdd vdd) p12 w=2.4u l=0.13u
MN4385 (n4383 lag_sync2_1 n4384 vss) n12 w=1.6u l=0.13u
MN4386 (n4384 n4377 vss vss) n12 w=1.6u l=0.13u
MP4387 (n4383 lag_sync2_1 vdd vdd) p12 w=2.4u l=0.13u
MP4388 (n4383 n4377 vdd vdd) p12 w=2.4u l=0.13u
MN4391 (n4389 n4371 n4390 vss) n12 w=1.6u l=0.13u
MN4392 (n4390 n4377 vss vss) n12 w=1.6u l=0.13u
MP4393 (n4389 n4371 vdd vdd) p12 w=2.4u l=0.13u
MP4394 (n4389 n4377 vdd vdd) p12 w=2.4u l=0.13u
MN4397 (n4395 n4383 n4396 vss) n12 w=1.6u l=0.13u
MN4398 (n4396 n4389 vss vss) n12 w=1.6u l=0.13u
MP4399 (n4395 n4383 vdd vdd) p12 w=2.4u l=0.13u
MP4400 (n4395 n4389 vdd vdd) p12 w=2.4u l=0.13u
MN4403 (n4401 lag_sync2_0 n4402 vss) n12 w=1.6u l=0.13u
MN4404 (n4402 n4395 vss vss) n12 w=1.6u l=0.13u
MP4405 (n4401 lag_sync2_0 vdd vdd) p12 w=2.4u l=0.13u
MP4406 (n4401 n4395 vdd vdd) p12 w=2.4u l=0.13u
MN4409 (n4407 lag_sync2_0 n4408 vss) n12 w=1.6u l=0.13u
MN4410 (n4408 n4401 vss vss) n12 w=1.6u l=0.13u
MP4411 (n4407 lag_sync2_0 vdd vdd) p12 w=2.4u l=0.13u
MP4412 (n4407 n4401 vdd vdd) p12 w=2.4u l=0.13u
MN4415 (n4413 n4395 n4414 vss) n12 w=1.6u l=0.13u
MN4416 (n4414 n4401 vss vss) n12 w=1.6u l=0.13u
MP4417 (n4413 n4395 vdd vdd) p12 w=2.4u l=0.13u
MP4418 (n4413 n4401 vdd vdd) p12 w=2.4u l=0.13u
MN4421 (n4419 n4407 n4420 vss) n12 w=1.6u l=0.13u
MN4422 (n4420 n4413 vss vss) n12 w=1.6u l=0.13u
MP4423 (n4419 n4407 vdd vdd) p12 w=2.4u l=0.13u
MP4424 (n4419 n4413 vdd vdd) p12 w=2.4u l=0.13u
MN4426 (n4425 n4419 vss vss) n12 w=0.8u l=0.13u
MP4427 (n4425 n4419 vdd vdd) p12 w=2.4u l=0.13u
MN4429 (n4428 n4425 vss vss) n12 w=0.8u l=0.13u
MP4430 (n4428 n4425 vdd vdd) p12 w=2.4u l=0.13u
MN4432 (n4431 n4428 vss vss) n12 w=0.8u l=0.13u
MP4433 (n4431 n4428 vdd vdd) p12 w=2.4u l=0.13u
MN4434 (cg0 n4431 vss vss) n12 w=0.8u l=0.13u
MP4435 (cg0 n4431 vdd vdd) p12 w=2.4u l=0.13u
MN4437 (n4436 n4395 vss vss) n12 w=0.8u l=0.13u
MP4438 (n4436 n4395 vdd vdd) p12 w=2.4u l=0.13u
MN4440 (n4439 n4436 vss vss) n12 w=0.8u l=0.13u
MP4441 (n4439 n4436 vdd vdd) p12 w=2.4u l=0.13u
MN4443 (n4442 n4439 vss vss) n12 w=0.8u l=0.13u
MP4444 (n4442 n4439 vdd vdd) p12 w=2.4u l=0.13u
MN4445 (cg1 n4442 vss vss) n12 w=0.8u l=0.13u
MP4446 (cg1 n4442 vdd vdd) p12 w=2.4u l=0.13u
MN4448 (n4447 n4371 vss vss) n12 w=0.8u l=0.13u
MP4449 (n4447 n4371 vdd vdd) p12 w=2.4u l=0.13u
MN4451 (n4450 n4447 vss vss) n12 w=0.8u l=0.13u
MP4452 (n4450 n4447 vdd vdd) p12 w=2.4u l=0.13u
MN4454 (n4453 n4450 vss vss) n12 w=0.8u l=0.13u
MP4455 (n4453 n4450 vdd vdd) p12 w=2.4u l=0.13u
MN4456 (cg2 n4453 vss vss) n12 w=0.8u l=0.13u
MP4457 (cg2 n4453 vdd vdd) p12 w=2.4u l=0.13u
MN4459 (n4458 n4347 vss vss) n12 w=0.8u l=0.13u
MP4460 (n4458 n4347 vdd vdd) p12 w=2.4u l=0.13u
MN4462 (n4461 n4458 vss vss) n12 w=0.8u l=0.13u
MP4463 (n4461 n4458 vdd vdd) p12 w=2.4u l=0.13u
MN4465 (n4464 n4461 vss vss) n12 w=0.8u l=0.13u
MP4466 (n4464 n4461 vdd vdd) p12 w=2.4u l=0.13u
MN4467 (cg3 n4464 vss vss) n12 w=0.8u l=0.13u
MP4468 (cg3 n4464 vdd vdd) p12 w=2.4u l=0.13u
MN4470 (n4469 n4323 vss vss) n12 w=0.8u l=0.13u
MP4471 (n4469 n4323 vdd vdd) p12 w=2.4u l=0.13u
MN4473 (n4472 n4469 vss vss) n12 w=0.8u l=0.13u
MP4474 (n4472 n4469 vdd vdd) p12 w=2.4u l=0.13u
MN4476 (n4475 n4472 vss vss) n12 w=0.8u l=0.13u
MP4477 (n4475 n4472 vdd vdd) p12 w=2.4u l=0.13u
MN4478 (cg4 n4475 vss vss) n12 w=0.8u l=0.13u
MP4479 (cg4 n4475 vdd vdd) p12 w=2.4u l=0.13u
MN4481 (n4480 n4299 vss vss) n12 w=0.8u l=0.13u
MP4482 (n4480 n4299 vdd vdd) p12 w=2.4u l=0.13u
MN4484 (n4483 n4480 vss vss) n12 w=0.8u l=0.13u
MP4485 (n4483 n4480 vdd vdd) p12 w=2.4u l=0.13u
MN4487 (n4486 n4483 vss vss) n12 w=0.8u l=0.13u
MP4488 (n4486 n4483 vdd vdd) p12 w=2.4u l=0.13u
MN4489 (cg5 n4486 vss vss) n12 w=0.8u l=0.13u
MP4490 (cg5 n4486 vdd vdd) p12 w=2.4u l=0.13u
MN4492 (n4491 n4275 vss vss) n12 w=0.8u l=0.13u
MP4493 (n4491 n4275 vdd vdd) p12 w=2.4u l=0.13u
MN4495 (n4494 n4491 vss vss) n12 w=0.8u l=0.13u
MP4496 (n4494 n4491 vdd vdd) p12 w=2.4u l=0.13u
MN4498 (n4497 n4494 vss vss) n12 w=0.8u l=0.13u
MP4499 (n4497 n4494 vdd vdd) p12 w=2.4u l=0.13u
MN4500 (cg6 n4497 vss vss) n12 w=0.8u l=0.13u
MP4501 (cg6 n4497 vdd vdd) p12 w=2.4u l=0.13u
MN4503 (n4502 lag_sync2_7 vss vss) n12 w=0.8u l=0.13u
MP4504 (n4502 lag_sync2_7 vdd vdd) p12 w=2.4u l=0.13u
MN4506 (n4505 n4502 vss vss) n12 w=0.8u l=0.13u
MP4507 (n4505 n4502 vdd vdd) p12 w=2.4u l=0.13u
MN4509 (n4508 n4505 vss vss) n12 w=0.8u l=0.13u
MP4510 (n4508 n4505 vdd vdd) p12 w=2.4u l=0.13u
MN4511 (cg7 n4508 vss vss) n12 w=0.8u l=0.13u
MP4512 (cg7 n4508 vdd vdd) p12 w=2.4u l=0.13u
MN4515 (n4513 div_sync2_6 n4514 vss) n12 w=1.6u l=0.13u
MN4516 (n4514 div_sync2_7 vss vss) n12 w=1.6u l=0.13u
MP4517 (n4513 div_sync2_6 vdd vdd) p12 w=2.4u l=0.13u
MP4518 (n4513 div_sync2_7 vdd vdd) p12 w=2.4u l=0.13u
MN4521 (n4519 div_sync2_6 n4520 vss) n12 w=1.6u l=0.13u
MN4522 (n4520 n4513 vss vss) n12 w=1.6u l=0.13u
MP4523 (n4519 div_sync2_6 vdd vdd) p12 w=2.4u l=0.13u
MP4524 (n4519 n4513 vdd vdd) p12 w=2.4u l=0.13u
MN4527 (n4525 div_sync2_7 n4526 vss) n12 w=1.6u l=0.13u
MN4528 (n4526 n4513 vss vss) n12 w=1.6u l=0.13u
MP4529 (n4525 div_sync2_7 vdd vdd) p12 w=2.4u l=0.13u
MP4530 (n4525 n4513 vdd vdd) p12 w=2.4u l=0.13u
MN4533 (n4531 n4519 n4532 vss) n12 w=1.6u l=0.13u
MN4534 (n4532 n4525 vss vss) n12 w=1.6u l=0.13u
MP4535 (n4531 n4519 vdd vdd) p12 w=2.4u l=0.13u
MP4536 (n4531 n4525 vdd vdd) p12 w=2.4u l=0.13u
MN4539 (n4537 div_sync2_5 n4538 vss) n12 w=1.6u l=0.13u
MN4540 (n4538 n4531 vss vss) n12 w=1.6u l=0.13u
MP4541 (n4537 div_sync2_5 vdd vdd) p12 w=2.4u l=0.13u
MP4542 (n4537 n4531 vdd vdd) p12 w=2.4u l=0.13u
MN4545 (n4543 div_sync2_5 n4544 vss) n12 w=1.6u l=0.13u
MN4546 (n4544 n4537 vss vss) n12 w=1.6u l=0.13u
MP4547 (n4543 div_sync2_5 vdd vdd) p12 w=2.4u l=0.13u
MP4548 (n4543 n4537 vdd vdd) p12 w=2.4u l=0.13u
MN4551 (n4549 n4531 n4550 vss) n12 w=1.6u l=0.13u
MN4552 (n4550 n4537 vss vss) n12 w=1.6u l=0.13u
MP4553 (n4549 n4531 vdd vdd) p12 w=2.4u l=0.13u
MP4554 (n4549 n4537 vdd vdd) p12 w=2.4u l=0.13u
MN4557 (n4555 n4543 n4556 vss) n12 w=1.6u l=0.13u
MN4558 (n4556 n4549 vss vss) n12 w=1.6u l=0.13u
MP4559 (n4555 n4543 vdd vdd) p12 w=2.4u l=0.13u
MP4560 (n4555 n4549 vdd vdd) p12 w=2.4u l=0.13u
MN4563 (n4561 div_sync2_4 n4562 vss) n12 w=1.6u l=0.13u
MN4564 (n4562 n4555 vss vss) n12 w=1.6u l=0.13u
MP4565 (n4561 div_sync2_4 vdd vdd) p12 w=2.4u l=0.13u
MP4566 (n4561 n4555 vdd vdd) p12 w=2.4u l=0.13u
MN4569 (n4567 div_sync2_4 n4568 vss) n12 w=1.6u l=0.13u
MN4570 (n4568 n4561 vss vss) n12 w=1.6u l=0.13u
MP4571 (n4567 div_sync2_4 vdd vdd) p12 w=2.4u l=0.13u
MP4572 (n4567 n4561 vdd vdd) p12 w=2.4u l=0.13u
MN4575 (n4573 n4555 n4574 vss) n12 w=1.6u l=0.13u
MN4576 (n4574 n4561 vss vss) n12 w=1.6u l=0.13u
MP4577 (n4573 n4555 vdd vdd) p12 w=2.4u l=0.13u
MP4578 (n4573 n4561 vdd vdd) p12 w=2.4u l=0.13u
MN4581 (n4579 n4567 n4580 vss) n12 w=1.6u l=0.13u
MN4582 (n4580 n4573 vss vss) n12 w=1.6u l=0.13u
MP4583 (n4579 n4567 vdd vdd) p12 w=2.4u l=0.13u
MP4584 (n4579 n4573 vdd vdd) p12 w=2.4u l=0.13u
MN4587 (n4585 div_sync2_3 n4586 vss) n12 w=1.6u l=0.13u
MN4588 (n4586 n4579 vss vss) n12 w=1.6u l=0.13u
MP4589 (n4585 div_sync2_3 vdd vdd) p12 w=2.4u l=0.13u
MP4590 (n4585 n4579 vdd vdd) p12 w=2.4u l=0.13u
MN4593 (n4591 div_sync2_3 n4592 vss) n12 w=1.6u l=0.13u
MN4594 (n4592 n4585 vss vss) n12 w=1.6u l=0.13u
MP4595 (n4591 div_sync2_3 vdd vdd) p12 w=2.4u l=0.13u
MP4596 (n4591 n4585 vdd vdd) p12 w=2.4u l=0.13u
MN4599 (n4597 n4579 n4598 vss) n12 w=1.6u l=0.13u
MN4600 (n4598 n4585 vss vss) n12 w=1.6u l=0.13u
MP4601 (n4597 n4579 vdd vdd) p12 w=2.4u l=0.13u
MP4602 (n4597 n4585 vdd vdd) p12 w=2.4u l=0.13u
MN4605 (n4603 n4591 n4604 vss) n12 w=1.6u l=0.13u
MN4606 (n4604 n4597 vss vss) n12 w=1.6u l=0.13u
MP4607 (n4603 n4591 vdd vdd) p12 w=2.4u l=0.13u
MP4608 (n4603 n4597 vdd vdd) p12 w=2.4u l=0.13u
MN4611 (n4609 div_sync2_2 n4610 vss) n12 w=1.6u l=0.13u
MN4612 (n4610 n4603 vss vss) n12 w=1.6u l=0.13u
MP4613 (n4609 div_sync2_2 vdd vdd) p12 w=2.4u l=0.13u
MP4614 (n4609 n4603 vdd vdd) p12 w=2.4u l=0.13u
MN4617 (n4615 div_sync2_2 n4616 vss) n12 w=1.6u l=0.13u
MN4618 (n4616 n4609 vss vss) n12 w=1.6u l=0.13u
MP4619 (n4615 div_sync2_2 vdd vdd) p12 w=2.4u l=0.13u
MP4620 (n4615 n4609 vdd vdd) p12 w=2.4u l=0.13u
MN4623 (n4621 n4603 n4622 vss) n12 w=1.6u l=0.13u
MN4624 (n4622 n4609 vss vss) n12 w=1.6u l=0.13u
MP4625 (n4621 n4603 vdd vdd) p12 w=2.4u l=0.13u
MP4626 (n4621 n4609 vdd vdd) p12 w=2.4u l=0.13u
MN4629 (n4627 n4615 n4628 vss) n12 w=1.6u l=0.13u
MN4630 (n4628 n4621 vss vss) n12 w=1.6u l=0.13u
MP4631 (n4627 n4615 vdd vdd) p12 w=2.4u l=0.13u
MP4632 (n4627 n4621 vdd vdd) p12 w=2.4u l=0.13u
MN4635 (n4633 div_sync2_1 n4634 vss) n12 w=1.6u l=0.13u
MN4636 (n4634 n4627 vss vss) n12 w=1.6u l=0.13u
MP4637 (n4633 div_sync2_1 vdd vdd) p12 w=2.4u l=0.13u
MP4638 (n4633 n4627 vdd vdd) p12 w=2.4u l=0.13u
MN4641 (n4639 div_sync2_1 n4640 vss) n12 w=1.6u l=0.13u
MN4642 (n4640 n4633 vss vss) n12 w=1.6u l=0.13u
MP4643 (n4639 div_sync2_1 vdd vdd) p12 w=2.4u l=0.13u
MP4644 (n4639 n4633 vdd vdd) p12 w=2.4u l=0.13u
MN4647 (n4645 n4627 n4646 vss) n12 w=1.6u l=0.13u
MN4648 (n4646 n4633 vss vss) n12 w=1.6u l=0.13u
MP4649 (n4645 n4627 vdd vdd) p12 w=2.4u l=0.13u
MP4650 (n4645 n4633 vdd vdd) p12 w=2.4u l=0.13u
MN4653 (n4651 n4639 n4652 vss) n12 w=1.6u l=0.13u
MN4654 (n4652 n4645 vss vss) n12 w=1.6u l=0.13u
MP4655 (n4651 n4639 vdd vdd) p12 w=2.4u l=0.13u
MP4656 (n4651 n4645 vdd vdd) p12 w=2.4u l=0.13u
MN4659 (n4657 div_sync2_0 n4658 vss) n12 w=1.6u l=0.13u
MN4660 (n4658 n4651 vss vss) n12 w=1.6u l=0.13u
MP4661 (n4657 div_sync2_0 vdd vdd) p12 w=2.4u l=0.13u
MP4662 (n4657 n4651 vdd vdd) p12 w=2.4u l=0.13u
MN4665 (n4663 div_sync2_0 n4664 vss) n12 w=1.6u l=0.13u
MN4666 (n4664 n4657 vss vss) n12 w=1.6u l=0.13u
MP4667 (n4663 div_sync2_0 vdd vdd) p12 w=2.4u l=0.13u
MP4668 (n4663 n4657 vdd vdd) p12 w=2.4u l=0.13u
MN4671 (n4669 n4651 n4670 vss) n12 w=1.6u l=0.13u
MN4672 (n4670 n4657 vss vss) n12 w=1.6u l=0.13u
MP4673 (n4669 n4651 vdd vdd) p12 w=2.4u l=0.13u
MP4674 (n4669 n4657 vdd vdd) p12 w=2.4u l=0.13u
MN4677 (n4675 n4663 n4676 vss) n12 w=1.6u l=0.13u
MN4678 (n4676 n4669 vss vss) n12 w=1.6u l=0.13u
MP4679 (n4675 n4663 vdd vdd) p12 w=2.4u l=0.13u
MP4680 (n4675 n4669 vdd vdd) p12 w=2.4u l=0.13u
MN4682 (n4681 n4675 vss vss) n12 w=0.8u l=0.13u
MP4683 (n4681 n4675 vdd vdd) p12 w=2.4u l=0.13u
MN4685 (n4684 n4681 vss vss) n12 w=0.8u l=0.13u
MP4686 (n4684 n4681 vdd vdd) p12 w=2.4u l=0.13u
MN4688 (n4687 n4684 vss vss) n12 w=0.8u l=0.13u
MP4689 (n4687 n4684 vdd vdd) p12 w=2.4u l=0.13u
MN4690 (cd0 n4687 vss vss) n12 w=0.8u l=0.13u
MP4691 (cd0 n4687 vdd vdd) p12 w=2.4u l=0.13u
MN4693 (n4692 n4651 vss vss) n12 w=0.8u l=0.13u
MP4694 (n4692 n4651 vdd vdd) p12 w=2.4u l=0.13u
MN4696 (n4695 n4692 vss vss) n12 w=0.8u l=0.13u
MP4697 (n4695 n4692 vdd vdd) p12 w=2.4u l=0.13u
MN4699 (n4698 n4695 vss vss) n12 w=0.8u l=0.13u
MP4700 (n4698 n4695 vdd vdd) p12 w=2.4u l=0.13u
MN4701 (cd1 n4698 vss vss) n12 w=0.8u l=0.13u
MP4702 (cd1 n4698 vdd vdd) p12 w=2.4u l=0.13u
MN4704 (n4703 n4627 vss vss) n12 w=0.8u l=0.13u
MP4705 (n4703 n4627 vdd vdd) p12 w=2.4u l=0.13u
MN4707 (n4706 n4703 vss vss) n12 w=0.8u l=0.13u
MP4708 (n4706 n4703 vdd vdd) p12 w=2.4u l=0.13u
MN4710 (n4709 n4706 vss vss) n12 w=0.8u l=0.13u
MP4711 (n4709 n4706 vdd vdd) p12 w=2.4u l=0.13u
MN4712 (cd2 n4709 vss vss) n12 w=0.8u l=0.13u
MP4713 (cd2 n4709 vdd vdd) p12 w=2.4u l=0.13u
MN4715 (n4714 n4603 vss vss) n12 w=0.8u l=0.13u
MP4716 (n4714 n4603 vdd vdd) p12 w=2.4u l=0.13u
MN4718 (n4717 n4714 vss vss) n12 w=0.8u l=0.13u
MP4719 (n4717 n4714 vdd vdd) p12 w=2.4u l=0.13u
MN4721 (n4720 n4717 vss vss) n12 w=0.8u l=0.13u
MP4722 (n4720 n4717 vdd vdd) p12 w=2.4u l=0.13u
MN4723 (cd3 n4720 vss vss) n12 w=0.8u l=0.13u
MP4724 (cd3 n4720 vdd vdd) p12 w=2.4u l=0.13u
MN4726 (n4725 n4579 vss vss) n12 w=0.8u l=0.13u
MP4727 (n4725 n4579 vdd vdd) p12 w=2.4u l=0.13u
MN4729 (n4728 n4725 vss vss) n12 w=0.8u l=0.13u
MP4730 (n4728 n4725 vdd vdd) p12 w=2.4u l=0.13u
MN4732 (n4731 n4728 vss vss) n12 w=0.8u l=0.13u
MP4733 (n4731 n4728 vdd vdd) p12 w=2.4u l=0.13u
MN4734 (cd4 n4731 vss vss) n12 w=0.8u l=0.13u
MP4735 (cd4 n4731 vdd vdd) p12 w=2.4u l=0.13u
MN4737 (n4736 n4555 vss vss) n12 w=0.8u l=0.13u
MP4738 (n4736 n4555 vdd vdd) p12 w=2.4u l=0.13u
MN4740 (n4739 n4736 vss vss) n12 w=0.8u l=0.13u
MP4741 (n4739 n4736 vdd vdd) p12 w=2.4u l=0.13u
MN4743 (n4742 n4739 vss vss) n12 w=0.8u l=0.13u
MP4744 (n4742 n4739 vdd vdd) p12 w=2.4u l=0.13u
MN4745 (cd5 n4742 vss vss) n12 w=0.8u l=0.13u
MP4746 (cd5 n4742 vdd vdd) p12 w=2.4u l=0.13u
MN4748 (n4747 n4531 vss vss) n12 w=0.8u l=0.13u
MP4749 (n4747 n4531 vdd vdd) p12 w=2.4u l=0.13u
MN4751 (n4750 n4747 vss vss) n12 w=0.8u l=0.13u
MP4752 (n4750 n4747 vdd vdd) p12 w=2.4u l=0.13u
MN4754 (n4753 n4750 vss vss) n12 w=0.8u l=0.13u
MP4755 (n4753 n4750 vdd vdd) p12 w=2.4u l=0.13u
MN4756 (cd6 n4753 vss vss) n12 w=0.8u l=0.13u
MP4757 (cd6 n4753 vdd vdd) p12 w=2.4u l=0.13u
MN4759 (n4758 div_sync2_7 vss vss) n12 w=0.8u l=0.13u
MP4760 (n4758 div_sync2_7 vdd vdd) p12 w=2.4u l=0.13u
MN4762 (n4761 n4758 vss vss) n12 w=0.8u l=0.13u
MP4763 (n4761 n4758 vdd vdd) p12 w=2.4u l=0.13u
MN4765 (n4764 n4761 vss vss) n12 w=0.8u l=0.13u
MP4766 (n4764 n4761 vdd vdd) p12 w=2.4u l=0.13u
MN4767 (cd7 n4764 vss vss) n12 w=0.8u l=0.13u
MP4768 (cd7 n4764 vdd vdd) p12 w=2.4u l=0.13u
MN4773 (seen clk_low2861 storage4772 vss) n12 w=1.2u l=0.13u
MP4774 (seen clk_lowb2862 storage4772 vdd) p12 w=3.6u l=0.13u
MN4775 (qm4769 clk_high2863 storage4772 vss) n12 w=1.2u l=0.13u
MP4776 (qm4769 clk_highb2864 storage4772 vdd) p12 w=3.6u l=0.13u
MN4777 (qmb4770 storage4772 vss vss) n12 w=0.5u l=0.13u
MP4778 (qmb4770 storage4772 vdd vdd) p12 w=1.5u l=0.13u
MN4779 (qm4769 qmb4770 vss vss) n12 w=0.5u l=0.13u
MP4780 (qm4769 qmb4770 vdd vdd) p12 w=1.5u l=0.13u
MN4781 (storage4772 count_rst vss vss) n12 w=2u l=0.13u
MN4783 (qm4769 clk_high2863 storage4782 vss) n12 w=1.2u l=0.13u
MP4784 (qm4769 clk_highb2864 storage4782 vdd) p12 w=3.6u l=0.13u
MN4785 (seen_sync1 clk_low2861 storage4782 vss) n12 w=1.2u l=0.13u
MP4786 (seen_sync1 clk_lowb2862 storage4782 vdd) p12 w=3.6u l=0.13u
MN4787 (qb4771 storage4782 vss vss) n12 w=0.5u l=0.13u
MP4788 (qb4771 storage4782 vdd vdd) p12 w=1.5u l=0.13u
MN4789 (seen_sync1 qb4771 vss vss) n12 w=0.5u l=0.13u
MP4790 (seen_sync1 qb4771 vdd vdd) p12 w=1.5u l=0.13u
MN4791 (storage4782 count_rst vss vss) n12 w=2u l=0.13u
MN4796 (seen_sync1 clk_low2861 storage4795 vss) n12 w=1.2u l=0.13u
MP4797 (seen_sync1 clk_lowb2862 storage4795 vdd) p12 w=3.6u l=0.13u
MN4798 (qm4792 clk_high2863 storage4795 vss) n12 w=1.2u l=0.13u
MP4799 (qm4792 clk_highb2864 storage4795 vdd) p12 w=3.6u l=0.13u
MN4800 (qmb4793 storage4795 vss vss) n12 w=0.5u l=0.13u
MP4801 (qmb4793 storage4795 vdd vdd) p12 w=1.5u l=0.13u
MN4802 (qm4792 qmb4793 vss vss) n12 w=0.5u l=0.13u
MP4803 (qm4792 qmb4793 vdd vdd) p12 w=1.5u l=0.13u
MN4804 (storage4795 count_rst vss vss) n12 w=2u l=0.13u
MN4806 (qm4792 clk_high2863 storage4805 vss) n12 w=1.2u l=0.13u
MP4807 (qm4792 clk_highb2864 storage4805 vdd) p12 w=3.6u l=0.13u
MN4808 (seen_sync2 clk_low2861 storage4805 vss) n12 w=1.2u l=0.13u
MP4809 (seen_sync2 clk_lowb2862 storage4805 vdd) p12 w=3.6u l=0.13u
MN4810 (qb4794 storage4805 vss vss) n12 w=0.5u l=0.13u
MP4811 (qb4794 storage4805 vdd vdd) p12 w=1.5u l=0.13u
MN4812 (seen_sync2 qb4794 vss vss) n12 w=0.5u l=0.13u
MP4813 (seen_sync2 qb4794 vdd vdd) p12 w=1.5u l=0.13u
MN4814 (storage4805 count_rst vss vss) n12 w=2u l=0.13u
MN4819 (seen_sync2 clk_low2861 storage4818 vss) n12 w=1.2u l=0.13u
MP4820 (seen_sync2 clk_lowb2862 storage4818 vdd) p12 w=3.6u l=0.13u
MN4821 (qm4815 clk_high2863 storage4818 vss) n12 w=1.2u l=0.13u
MP4822 (qm4815 clk_highb2864 storage4818 vdd) p12 w=3.6u l=0.13u
MN4823 (qmb4816 storage4818 vss vss) n12 w=0.5u l=0.13u
MP4824 (qmb4816 storage4818 vdd vdd) p12 w=1.5u l=0.13u
MN4825 (qm4815 qmb4816 vss vss) n12 w=0.5u l=0.13u
MP4826 (qm4815 qmb4816 vdd vdd) p12 w=1.5u l=0.13u
MN4827 (storage4818 count_rst vss vss) n12 w=2u l=0.13u
MN4829 (qm4815 clk_high2863 storage4828 vss) n12 w=1.2u l=0.13u
MP4830 (qm4815 clk_highb2864 storage4828 vdd) p12 w=3.6u l=0.13u
MN4831 (epoch_valid1 clk_low2861 storage4828 vss) n12 w=1.2u l=0.13u
MP4832 (epoch_valid1 clk_lowb2862 storage4828 vdd) p12 w=3.6u l=0.13u
MN4833 (qb4817 storage4828 vss vss) n12 w=0.5u l=0.13u
MP4834 (qb4817 storage4828 vdd vdd) p12 w=1.5u l=0.13u
MN4835 (epoch_valid1 qb4817 vss vss) n12 w=0.5u l=0.13u
MP4836 (epoch_valid1 qb4817 vdd vdd) p12 w=1.5u l=0.13u
MN4837 (storage4828 count_rst vss vss) n12 w=2u l=0.13u
MN4842 (epoch_valid1 clk_low2861 storage4841 vss) n12 w=1.2u l=0.13u
MP4843 (epoch_valid1 clk_lowb2862 storage4841 vdd) p12 w=3.6u l=0.13u
MN4844 (qm4838 clk_high2863 storage4841 vss) n12 w=1.2u l=0.13u
MP4845 (qm4838 clk_highb2864 storage4841 vdd) p12 w=3.6u l=0.13u
MN4846 (qmb4839 storage4841 vss vss) n12 w=0.5u l=0.13u
MP4847 (qmb4839 storage4841 vdd vdd) p12 w=1.5u l=0.13u
MN4848 (qm4838 qmb4839 vss vss) n12 w=0.5u l=0.13u
MP4849 (qm4838 qmb4839 vdd vdd) p12 w=1.5u l=0.13u
MN4850 (storage4841 count_rst vss vss) n12 w=2u l=0.13u
MN4852 (qm4838 clk_high2863 storage4851 vss) n12 w=1.2u l=0.13u
MP4853 (qm4838 clk_highb2864 storage4851 vdd) p12 w=3.6u l=0.13u
MN4854 (epoch_valid clk_low2861 storage4851 vss) n12 w=1.2u l=0.13u
MP4855 (epoch_valid clk_lowb2862 storage4851 vdd) p12 w=3.6u l=0.13u
MN4856 (qb4840 storage4851 vss vss) n12 w=0.5u l=0.13u
MP4857 (qb4840 storage4851 vdd vdd) p12 w=1.5u l=0.13u
MN4858 (epoch_valid qb4840 vss vss) n12 w=0.5u l=0.13u
MP4859 (epoch_valid qb4840 vdd vdd) p12 w=1.5u l=0.13u
MN4860 (storage4851 count_rst vss vss) n12 w=2u l=0.13u
MN4862 (n4861 cd0 vss vss) n12 w=0.8u l=0.13u
MP4863 (n4861 cd0 vdd vdd) p12 w=2.4u l=0.13u
MN4866 (n4864 cg0 n4865 vss) n12 w=1.6u l=0.13u
MN4867 (n4865 n4861 vss vss) n12 w=1.6u l=0.13u
MP4868 (n4864 cg0 vdd vdd) p12 w=2.4u l=0.13u
MP4869 (n4864 n4861 vdd vdd) p12 w=2.4u l=0.13u
MN4872 (n4870 cg0 n4871 vss) n12 w=1.6u l=0.13u
MN4873 (n4871 n4864 vss vss) n12 w=1.6u l=0.13u
MP4874 (n4870 cg0 vdd vdd) p12 w=2.4u l=0.13u
MP4875 (n4870 n4864 vdd vdd) p12 w=2.4u l=0.13u
MN4878 (n4876 n4861 n4877 vss) n12 w=1.6u l=0.13u
MN4879 (n4877 n4864 vss vss) n12 w=1.6u l=0.13u
MP4880 (n4876 n4861 vdd vdd) p12 w=2.4u l=0.13u
MP4881 (n4876 n4864 vdd vdd) p12 w=2.4u l=0.13u
MN4884 (n4882 n4870 n4883 vss) n12 w=1.6u l=0.13u
MN4885 (n4883 n4876 vss vss) n12 w=1.6u l=0.13u
MP4886 (n4882 n4870 vdd vdd) p12 w=2.4u l=0.13u
MP4887 (n4882 n4876 vdd vdd) p12 w=2.4u l=0.13u
MN4889 (n4888 n4882 vss vss) n12 w=0.8u l=0.13u
MP4890 (n4888 n4882 vdd vdd) p12 w=2.4u l=0.13u
MN4892 (n4891 n4864 vss vss) n12 w=0.8u l=0.13u
MP4893 (n4891 n4864 vdd vdd) p12 w=2.4u l=0.13u
MN4896 (n4894 n4882 vss vss) n12 w=0.8u l=0.13u
MN4897 (n4894 n4891 vss vss) n12 w=0.8u l=0.13u
MP4898 (n4894 n4882 n4895 vdd) p12 w=4.8u l=0.13u
MP4899 (n4895 n4891 vdd vdd) p12 w=4.8u l=0.13u
MN4901 (n4900 n4894 vss vss) n12 w=0.8u l=0.13u
MP4902 (n4900 n4894 vdd vdd) p12 w=2.4u l=0.13u
MN4904 (n4903 cd1 vss vss) n12 w=0.8u l=0.13u
MP4905 (n4903 cd1 vdd vdd) p12 w=2.4u l=0.13u
MN4908 (n4906 cg1 n4907 vss) n12 w=1.6u l=0.13u
MN4909 (n4907 n4903 vss vss) n12 w=1.6u l=0.13u
MP4910 (n4906 cg1 vdd vdd) p12 w=2.4u l=0.13u
MP4911 (n4906 n4903 vdd vdd) p12 w=2.4u l=0.13u
MN4914 (n4912 cg1 n4913 vss) n12 w=1.6u l=0.13u
MN4915 (n4913 n4906 vss vss) n12 w=1.6u l=0.13u
MP4916 (n4912 cg1 vdd vdd) p12 w=2.4u l=0.13u
MP4917 (n4912 n4906 vdd vdd) p12 w=2.4u l=0.13u
MN4920 (n4918 n4903 n4919 vss) n12 w=1.6u l=0.13u
MN4921 (n4919 n4906 vss vss) n12 w=1.6u l=0.13u
MP4922 (n4918 n4903 vdd vdd) p12 w=2.4u l=0.13u
MP4923 (n4918 n4906 vdd vdd) p12 w=2.4u l=0.13u
MN4926 (n4924 n4912 n4925 vss) n12 w=1.6u l=0.13u
MN4927 (n4925 n4918 vss vss) n12 w=1.6u l=0.13u
MP4928 (n4924 n4912 vdd vdd) p12 w=2.4u l=0.13u
MP4929 (n4924 n4918 vdd vdd) p12 w=2.4u l=0.13u
MN4932 (n4930 n4900 n4931 vss) n12 w=1.6u l=0.13u
MN4933 (n4931 n4924 vss vss) n12 w=1.6u l=0.13u
MP4934 (n4930 n4900 vdd vdd) p12 w=2.4u l=0.13u
MP4935 (n4930 n4924 vdd vdd) p12 w=2.4u l=0.13u
MN4938 (n4936 n4900 n4937 vss) n12 w=1.6u l=0.13u
MN4939 (n4937 n4930 vss vss) n12 w=1.6u l=0.13u
MP4940 (n4936 n4900 vdd vdd) p12 w=2.4u l=0.13u
MP4941 (n4936 n4930 vdd vdd) p12 w=2.4u l=0.13u
MN4944 (n4942 n4924 n4943 vss) n12 w=1.6u l=0.13u
MN4945 (n4943 n4930 vss vss) n12 w=1.6u l=0.13u
MP4946 (n4942 n4924 vdd vdd) p12 w=2.4u l=0.13u
MP4947 (n4942 n4930 vdd vdd) p12 w=2.4u l=0.13u
MN4950 (n4948 n4936 n4949 vss) n12 w=1.6u l=0.13u
MN4951 (n4949 n4942 vss vss) n12 w=1.6u l=0.13u
MP4952 (n4948 n4936 vdd vdd) p12 w=2.4u l=0.13u
MP4953 (n4948 n4942 vdd vdd) p12 w=2.4u l=0.13u
MN4955 (n4954 n4906 vss vss) n12 w=0.8u l=0.13u
MP4956 (n4954 n4906 vdd vdd) p12 w=2.4u l=0.13u
MN4958 (n4957 n4930 vss vss) n12 w=0.8u l=0.13u
MP4959 (n4957 n4930 vdd vdd) p12 w=2.4u l=0.13u
MN4962 (n4960 n4954 vss vss) n12 w=0.8u l=0.13u
MN4963 (n4960 n4957 vss vss) n12 w=0.8u l=0.13u
MP4964 (n4960 n4954 n4961 vdd) p12 w=4.8u l=0.13u
MP4965 (n4961 n4957 vdd vdd) p12 w=4.8u l=0.13u
MN4967 (n4966 n4960 vss vss) n12 w=0.8u l=0.13u
MP4968 (n4966 n4960 vdd vdd) p12 w=2.4u l=0.13u
MN4970 (n4969 cd2 vss vss) n12 w=0.8u l=0.13u
MP4971 (n4969 cd2 vdd vdd) p12 w=2.4u l=0.13u
MN4974 (n4972 cg2 n4973 vss) n12 w=1.6u l=0.13u
MN4975 (n4973 n4969 vss vss) n12 w=1.6u l=0.13u
MP4976 (n4972 cg2 vdd vdd) p12 w=2.4u l=0.13u
MP4977 (n4972 n4969 vdd vdd) p12 w=2.4u l=0.13u
MN4980 (n4978 cg2 n4979 vss) n12 w=1.6u l=0.13u
MN4981 (n4979 n4972 vss vss) n12 w=1.6u l=0.13u
MP4982 (n4978 cg2 vdd vdd) p12 w=2.4u l=0.13u
MP4983 (n4978 n4972 vdd vdd) p12 w=2.4u l=0.13u
MN4986 (n4984 n4969 n4985 vss) n12 w=1.6u l=0.13u
MN4987 (n4985 n4972 vss vss) n12 w=1.6u l=0.13u
MP4988 (n4984 n4969 vdd vdd) p12 w=2.4u l=0.13u
MP4989 (n4984 n4972 vdd vdd) p12 w=2.4u l=0.13u
MN4992 (n4990 n4978 n4991 vss) n12 w=1.6u l=0.13u
MN4993 (n4991 n4984 vss vss) n12 w=1.6u l=0.13u
MP4994 (n4990 n4978 vdd vdd) p12 w=2.4u l=0.13u
MP4995 (n4990 n4984 vdd vdd) p12 w=2.4u l=0.13u
MN4998 (n4996 n4966 n4997 vss) n12 w=1.6u l=0.13u
MN4999 (n4997 n4990 vss vss) n12 w=1.6u l=0.13u
MP5000 (n4996 n4966 vdd vdd) p12 w=2.4u l=0.13u
MP5001 (n4996 n4990 vdd vdd) p12 w=2.4u l=0.13u
MN5004 (n5002 n4966 n5003 vss) n12 w=1.6u l=0.13u
MN5005 (n5003 n4996 vss vss) n12 w=1.6u l=0.13u
MP5006 (n5002 n4966 vdd vdd) p12 w=2.4u l=0.13u
MP5007 (n5002 n4996 vdd vdd) p12 w=2.4u l=0.13u
MN5010 (n5008 n4990 n5009 vss) n12 w=1.6u l=0.13u
MN5011 (n5009 n4996 vss vss) n12 w=1.6u l=0.13u
MP5012 (n5008 n4990 vdd vdd) p12 w=2.4u l=0.13u
MP5013 (n5008 n4996 vdd vdd) p12 w=2.4u l=0.13u
MN5016 (n5014 n5002 n5015 vss) n12 w=1.6u l=0.13u
MN5017 (n5015 n5008 vss vss) n12 w=1.6u l=0.13u
MP5018 (n5014 n5002 vdd vdd) p12 w=2.4u l=0.13u
MP5019 (n5014 n5008 vdd vdd) p12 w=2.4u l=0.13u
MN5021 (n5020 n4972 vss vss) n12 w=0.8u l=0.13u
MP5022 (n5020 n4972 vdd vdd) p12 w=2.4u l=0.13u
MN5024 (n5023 n4996 vss vss) n12 w=0.8u l=0.13u
MP5025 (n5023 n4996 vdd vdd) p12 w=2.4u l=0.13u
MN5028 (n5026 n5020 vss vss) n12 w=0.8u l=0.13u
MN5029 (n5026 n5023 vss vss) n12 w=0.8u l=0.13u
MP5030 (n5026 n5020 n5027 vdd) p12 w=4.8u l=0.13u
MP5031 (n5027 n5023 vdd vdd) p12 w=4.8u l=0.13u
MN5033 (n5032 n5026 vss vss) n12 w=0.8u l=0.13u
MP5034 (n5032 n5026 vdd vdd) p12 w=2.4u l=0.13u
MN5036 (n5035 cd3 vss vss) n12 w=0.8u l=0.13u
MP5037 (n5035 cd3 vdd vdd) p12 w=2.4u l=0.13u
MN5040 (n5038 cg3 n5039 vss) n12 w=1.6u l=0.13u
MN5041 (n5039 n5035 vss vss) n12 w=1.6u l=0.13u
MP5042 (n5038 cg3 vdd vdd) p12 w=2.4u l=0.13u
MP5043 (n5038 n5035 vdd vdd) p12 w=2.4u l=0.13u
MN5046 (n5044 cg3 n5045 vss) n12 w=1.6u l=0.13u
MN5047 (n5045 n5038 vss vss) n12 w=1.6u l=0.13u
MP5048 (n5044 cg3 vdd vdd) p12 w=2.4u l=0.13u
MP5049 (n5044 n5038 vdd vdd) p12 w=2.4u l=0.13u
MN5052 (n5050 n5035 n5051 vss) n12 w=1.6u l=0.13u
MN5053 (n5051 n5038 vss vss) n12 w=1.6u l=0.13u
MP5054 (n5050 n5035 vdd vdd) p12 w=2.4u l=0.13u
MP5055 (n5050 n5038 vdd vdd) p12 w=2.4u l=0.13u
MN5058 (n5056 n5044 n5057 vss) n12 w=1.6u l=0.13u
MN5059 (n5057 n5050 vss vss) n12 w=1.6u l=0.13u
MP5060 (n5056 n5044 vdd vdd) p12 w=2.4u l=0.13u
MP5061 (n5056 n5050 vdd vdd) p12 w=2.4u l=0.13u
MN5064 (n5062 n5032 n5063 vss) n12 w=1.6u l=0.13u
MN5065 (n5063 n5056 vss vss) n12 w=1.6u l=0.13u
MP5066 (n5062 n5032 vdd vdd) p12 w=2.4u l=0.13u
MP5067 (n5062 n5056 vdd vdd) p12 w=2.4u l=0.13u
MN5070 (n5068 n5032 n5069 vss) n12 w=1.6u l=0.13u
MN5071 (n5069 n5062 vss vss) n12 w=1.6u l=0.13u
MP5072 (n5068 n5032 vdd vdd) p12 w=2.4u l=0.13u
MP5073 (n5068 n5062 vdd vdd) p12 w=2.4u l=0.13u
MN5076 (n5074 n5056 n5075 vss) n12 w=1.6u l=0.13u
MN5077 (n5075 n5062 vss vss) n12 w=1.6u l=0.13u
MP5078 (n5074 n5056 vdd vdd) p12 w=2.4u l=0.13u
MP5079 (n5074 n5062 vdd vdd) p12 w=2.4u l=0.13u
MN5082 (n5080 n5068 n5081 vss) n12 w=1.6u l=0.13u
MN5083 (n5081 n5074 vss vss) n12 w=1.6u l=0.13u
MP5084 (n5080 n5068 vdd vdd) p12 w=2.4u l=0.13u
MP5085 (n5080 n5074 vdd vdd) p12 w=2.4u l=0.13u
MN5087 (n5086 n5038 vss vss) n12 w=0.8u l=0.13u
MP5088 (n5086 n5038 vdd vdd) p12 w=2.4u l=0.13u
MN5090 (n5089 n5062 vss vss) n12 w=0.8u l=0.13u
MP5091 (n5089 n5062 vdd vdd) p12 w=2.4u l=0.13u
MN5094 (n5092 n5086 vss vss) n12 w=0.8u l=0.13u
MN5095 (n5092 n5089 vss vss) n12 w=0.8u l=0.13u
MP5096 (n5092 n5086 n5093 vdd) p12 w=4.8u l=0.13u
MP5097 (n5093 n5089 vdd vdd) p12 w=4.8u l=0.13u
MN5099 (n5098 n5092 vss vss) n12 w=0.8u l=0.13u
MP5100 (n5098 n5092 vdd vdd) p12 w=2.4u l=0.13u
MN5102 (n5101 cd4 vss vss) n12 w=0.8u l=0.13u
MP5103 (n5101 cd4 vdd vdd) p12 w=2.4u l=0.13u
MN5106 (n5104 cg4 n5105 vss) n12 w=1.6u l=0.13u
MN5107 (n5105 n5101 vss vss) n12 w=1.6u l=0.13u
MP5108 (n5104 cg4 vdd vdd) p12 w=2.4u l=0.13u
MP5109 (n5104 n5101 vdd vdd) p12 w=2.4u l=0.13u
MN5112 (n5110 cg4 n5111 vss) n12 w=1.6u l=0.13u
MN5113 (n5111 n5104 vss vss) n12 w=1.6u l=0.13u
MP5114 (n5110 cg4 vdd vdd) p12 w=2.4u l=0.13u
MP5115 (n5110 n5104 vdd vdd) p12 w=2.4u l=0.13u
MN5118 (n5116 n5101 n5117 vss) n12 w=1.6u l=0.13u
MN5119 (n5117 n5104 vss vss) n12 w=1.6u l=0.13u
MP5120 (n5116 n5101 vdd vdd) p12 w=2.4u l=0.13u
MP5121 (n5116 n5104 vdd vdd) p12 w=2.4u l=0.13u
MN5124 (n5122 n5110 n5123 vss) n12 w=1.6u l=0.13u
MN5125 (n5123 n5116 vss vss) n12 w=1.6u l=0.13u
MP5126 (n5122 n5110 vdd vdd) p12 w=2.4u l=0.13u
MP5127 (n5122 n5116 vdd vdd) p12 w=2.4u l=0.13u
MN5130 (n5128 n5098 n5129 vss) n12 w=1.6u l=0.13u
MN5131 (n5129 n5122 vss vss) n12 w=1.6u l=0.13u
MP5132 (n5128 n5098 vdd vdd) p12 w=2.4u l=0.13u
MP5133 (n5128 n5122 vdd vdd) p12 w=2.4u l=0.13u
MN5136 (n5134 n5098 n5135 vss) n12 w=1.6u l=0.13u
MN5137 (n5135 n5128 vss vss) n12 w=1.6u l=0.13u
MP5138 (n5134 n5098 vdd vdd) p12 w=2.4u l=0.13u
MP5139 (n5134 n5128 vdd vdd) p12 w=2.4u l=0.13u
MN5142 (n5140 n5122 n5141 vss) n12 w=1.6u l=0.13u
MN5143 (n5141 n5128 vss vss) n12 w=1.6u l=0.13u
MP5144 (n5140 n5122 vdd vdd) p12 w=2.4u l=0.13u
MP5145 (n5140 n5128 vdd vdd) p12 w=2.4u l=0.13u
MN5148 (n5146 n5134 n5147 vss) n12 w=1.6u l=0.13u
MN5149 (n5147 n5140 vss vss) n12 w=1.6u l=0.13u
MP5150 (n5146 n5134 vdd vdd) p12 w=2.4u l=0.13u
MP5151 (n5146 n5140 vdd vdd) p12 w=2.4u l=0.13u
MN5153 (n5152 n5104 vss vss) n12 w=0.8u l=0.13u
MP5154 (n5152 n5104 vdd vdd) p12 w=2.4u l=0.13u
MN5156 (n5155 n5128 vss vss) n12 w=0.8u l=0.13u
MP5157 (n5155 n5128 vdd vdd) p12 w=2.4u l=0.13u
MN5160 (n5158 n5152 vss vss) n12 w=0.8u l=0.13u
MN5161 (n5158 n5155 vss vss) n12 w=0.8u l=0.13u
MP5162 (n5158 n5152 n5159 vdd) p12 w=4.8u l=0.13u
MP5163 (n5159 n5155 vdd vdd) p12 w=4.8u l=0.13u
MN5165 (n5164 n5158 vss vss) n12 w=0.8u l=0.13u
MP5166 (n5164 n5158 vdd vdd) p12 w=2.4u l=0.13u
MN5168 (n5167 cd5 vss vss) n12 w=0.8u l=0.13u
MP5169 (n5167 cd5 vdd vdd) p12 w=2.4u l=0.13u
MN5172 (n5170 cg5 n5171 vss) n12 w=1.6u l=0.13u
MN5173 (n5171 n5167 vss vss) n12 w=1.6u l=0.13u
MP5174 (n5170 cg5 vdd vdd) p12 w=2.4u l=0.13u
MP5175 (n5170 n5167 vdd vdd) p12 w=2.4u l=0.13u
MN5178 (n5176 cg5 n5177 vss) n12 w=1.6u l=0.13u
MN5179 (n5177 n5170 vss vss) n12 w=1.6u l=0.13u
MP5180 (n5176 cg5 vdd vdd) p12 w=2.4u l=0.13u
MP5181 (n5176 n5170 vdd vdd) p12 w=2.4u l=0.13u
MN5184 (n5182 n5167 n5183 vss) n12 w=1.6u l=0.13u
MN5185 (n5183 n5170 vss vss) n12 w=1.6u l=0.13u
MP5186 (n5182 n5167 vdd vdd) p12 w=2.4u l=0.13u
MP5187 (n5182 n5170 vdd vdd) p12 w=2.4u l=0.13u
MN5190 (n5188 n5176 n5189 vss) n12 w=1.6u l=0.13u
MN5191 (n5189 n5182 vss vss) n12 w=1.6u l=0.13u
MP5192 (n5188 n5176 vdd vdd) p12 w=2.4u l=0.13u
MP5193 (n5188 n5182 vdd vdd) p12 w=2.4u l=0.13u
MN5196 (n5194 n5164 n5195 vss) n12 w=1.6u l=0.13u
MN5197 (n5195 n5188 vss vss) n12 w=1.6u l=0.13u
MP5198 (n5194 n5164 vdd vdd) p12 w=2.4u l=0.13u
MP5199 (n5194 n5188 vdd vdd) p12 w=2.4u l=0.13u
MN5202 (n5200 n5164 n5201 vss) n12 w=1.6u l=0.13u
MN5203 (n5201 n5194 vss vss) n12 w=1.6u l=0.13u
MP5204 (n5200 n5164 vdd vdd) p12 w=2.4u l=0.13u
MP5205 (n5200 n5194 vdd vdd) p12 w=2.4u l=0.13u
MN5208 (n5206 n5188 n5207 vss) n12 w=1.6u l=0.13u
MN5209 (n5207 n5194 vss vss) n12 w=1.6u l=0.13u
MP5210 (n5206 n5188 vdd vdd) p12 w=2.4u l=0.13u
MP5211 (n5206 n5194 vdd vdd) p12 w=2.4u l=0.13u
MN5214 (n5212 n5200 n5213 vss) n12 w=1.6u l=0.13u
MN5215 (n5213 n5206 vss vss) n12 w=1.6u l=0.13u
MP5216 (n5212 n5200 vdd vdd) p12 w=2.4u l=0.13u
MP5217 (n5212 n5206 vdd vdd) p12 w=2.4u l=0.13u
MN5219 (n5218 n5170 vss vss) n12 w=0.8u l=0.13u
MP5220 (n5218 n5170 vdd vdd) p12 w=2.4u l=0.13u
MN5222 (n5221 n5194 vss vss) n12 w=0.8u l=0.13u
MP5223 (n5221 n5194 vdd vdd) p12 w=2.4u l=0.13u
MN5226 (n5224 n5218 vss vss) n12 w=0.8u l=0.13u
MN5227 (n5224 n5221 vss vss) n12 w=0.8u l=0.13u
MP5228 (n5224 n5218 n5225 vdd) p12 w=4.8u l=0.13u
MP5229 (n5225 n5221 vdd vdd) p12 w=4.8u l=0.13u
MN5231 (n5230 n5224 vss vss) n12 w=0.8u l=0.13u
MP5232 (n5230 n5224 vdd vdd) p12 w=2.4u l=0.13u
MN5234 (n5233 cd6 vss vss) n12 w=0.8u l=0.13u
MP5235 (n5233 cd6 vdd vdd) p12 w=2.4u l=0.13u
MN5238 (n5236 cg6 n5237 vss) n12 w=1.6u l=0.13u
MN5239 (n5237 n5233 vss vss) n12 w=1.6u l=0.13u
MP5240 (n5236 cg6 vdd vdd) p12 w=2.4u l=0.13u
MP5241 (n5236 n5233 vdd vdd) p12 w=2.4u l=0.13u
MN5244 (n5242 cg6 n5243 vss) n12 w=1.6u l=0.13u
MN5245 (n5243 n5236 vss vss) n12 w=1.6u l=0.13u
MP5246 (n5242 cg6 vdd vdd) p12 w=2.4u l=0.13u
MP5247 (n5242 n5236 vdd vdd) p12 w=2.4u l=0.13u
MN5250 (n5248 n5233 n5249 vss) n12 w=1.6u l=0.13u
MN5251 (n5249 n5236 vss vss) n12 w=1.6u l=0.13u
MP5252 (n5248 n5233 vdd vdd) p12 w=2.4u l=0.13u
MP5253 (n5248 n5236 vdd vdd) p12 w=2.4u l=0.13u
MN5256 (n5254 n5242 n5255 vss) n12 w=1.6u l=0.13u
MN5257 (n5255 n5248 vss vss) n12 w=1.6u l=0.13u
MP5258 (n5254 n5242 vdd vdd) p12 w=2.4u l=0.13u
MP5259 (n5254 n5248 vdd vdd) p12 w=2.4u l=0.13u
MN5262 (n5260 n5230 n5261 vss) n12 w=1.6u l=0.13u
MN5263 (n5261 n5254 vss vss) n12 w=1.6u l=0.13u
MP5264 (n5260 n5230 vdd vdd) p12 w=2.4u l=0.13u
MP5265 (n5260 n5254 vdd vdd) p12 w=2.4u l=0.13u
MN5268 (n5266 n5230 n5267 vss) n12 w=1.6u l=0.13u
MN5269 (n5267 n5260 vss vss) n12 w=1.6u l=0.13u
MP5270 (n5266 n5230 vdd vdd) p12 w=2.4u l=0.13u
MP5271 (n5266 n5260 vdd vdd) p12 w=2.4u l=0.13u
MN5274 (n5272 n5254 n5273 vss) n12 w=1.6u l=0.13u
MN5275 (n5273 n5260 vss vss) n12 w=1.6u l=0.13u
MP5276 (n5272 n5254 vdd vdd) p12 w=2.4u l=0.13u
MP5277 (n5272 n5260 vdd vdd) p12 w=2.4u l=0.13u
MN5280 (n5278 n5266 n5279 vss) n12 w=1.6u l=0.13u
MN5281 (n5279 n5272 vss vss) n12 w=1.6u l=0.13u
MP5282 (n5278 n5266 vdd vdd) p12 w=2.4u l=0.13u
MP5283 (n5278 n5272 vdd vdd) p12 w=2.4u l=0.13u
MN5285 (n5284 n5236 vss vss) n12 w=0.8u l=0.13u
MP5286 (n5284 n5236 vdd vdd) p12 w=2.4u l=0.13u
MN5288 (n5287 n5260 vss vss) n12 w=0.8u l=0.13u
MP5289 (n5287 n5260 vdd vdd) p12 w=2.4u l=0.13u
MN5292 (n5290 n5284 vss vss) n12 w=0.8u l=0.13u
MN5293 (n5290 n5287 vss vss) n12 w=0.8u l=0.13u
MP5294 (n5290 n5284 n5291 vdd) p12 w=4.8u l=0.13u
MP5295 (n5291 n5287 vdd vdd) p12 w=4.8u l=0.13u
MN5297 (n5296 n5290 vss vss) n12 w=0.8u l=0.13u
MP5298 (n5296 n5290 vdd vdd) p12 w=2.4u l=0.13u
MN5300 (n5299 cd7 vss vss) n12 w=0.8u l=0.13u
MP5301 (n5299 cd7 vdd vdd) p12 w=2.4u l=0.13u
MN5304 (n5302 cg7 n5303 vss) n12 w=1.6u l=0.13u
MN5305 (n5303 n5299 vss vss) n12 w=1.6u l=0.13u
MP5306 (n5302 cg7 vdd vdd) p12 w=2.4u l=0.13u
MP5307 (n5302 n5299 vdd vdd) p12 w=2.4u l=0.13u
MN5310 (n5308 cg7 n5309 vss) n12 w=1.6u l=0.13u
MN5311 (n5309 n5302 vss vss) n12 w=1.6u l=0.13u
MP5312 (n5308 cg7 vdd vdd) p12 w=2.4u l=0.13u
MP5313 (n5308 n5302 vdd vdd) p12 w=2.4u l=0.13u
MN5316 (n5314 n5299 n5315 vss) n12 w=1.6u l=0.13u
MN5317 (n5315 n5302 vss vss) n12 w=1.6u l=0.13u
MP5318 (n5314 n5299 vdd vdd) p12 w=2.4u l=0.13u
MP5319 (n5314 n5302 vdd vdd) p12 w=2.4u l=0.13u
MN5322 (n5320 n5308 n5321 vss) n12 w=1.6u l=0.13u
MN5323 (n5321 n5314 vss vss) n12 w=1.6u l=0.13u
MP5324 (n5320 n5308 vdd vdd) p12 w=2.4u l=0.13u
MP5325 (n5320 n5314 vdd vdd) p12 w=2.4u l=0.13u
MN5328 (n5326 n5296 n5327 vss) n12 w=1.6u l=0.13u
MN5329 (n5327 n5320 vss vss) n12 w=1.6u l=0.13u
MP5330 (n5326 n5296 vdd vdd) p12 w=2.4u l=0.13u
MP5331 (n5326 n5320 vdd vdd) p12 w=2.4u l=0.13u
MN5334 (n5332 n5296 n5333 vss) n12 w=1.6u l=0.13u
MN5335 (n5333 n5326 vss vss) n12 w=1.6u l=0.13u
MP5336 (n5332 n5296 vdd vdd) p12 w=2.4u l=0.13u
MP5337 (n5332 n5326 vdd vdd) p12 w=2.4u l=0.13u
MN5340 (n5338 n5320 n5339 vss) n12 w=1.6u l=0.13u
MN5341 (n5339 n5326 vss vss) n12 w=1.6u l=0.13u
MP5342 (n5338 n5320 vdd vdd) p12 w=2.4u l=0.13u
MP5343 (n5338 n5326 vdd vdd) p12 w=2.4u l=0.13u
MN5346 (n5344 n5332 n5345 vss) n12 w=1.6u l=0.13u
MN5347 (n5345 n5338 vss vss) n12 w=1.6u l=0.13u
MP5348 (n5344 n5332 vdd vdd) p12 w=2.4u l=0.13u
MP5349 (n5344 n5338 vdd vdd) p12 w=2.4u l=0.13u
MN5351 (n5350 n5302 vss vss) n12 w=0.8u l=0.13u
MP5352 (n5350 n5302 vdd vdd) p12 w=2.4u l=0.13u
MN5354 (n5353 n5326 vss vss) n12 w=0.8u l=0.13u
MP5355 (n5353 n5326 vdd vdd) p12 w=2.4u l=0.13u
MN5358 (n5356 n5350 vss vss) n12 w=0.8u l=0.13u
MN5359 (n5356 n5353 vss vss) n12 w=0.8u l=0.13u
MP5360 (n5356 n5350 n5357 vdd) p12 w=4.8u l=0.13u
MP5361 (n5357 n5353 vdd vdd) p12 w=4.8u l=0.13u
MN5363 (n5362 n5356 vss vss) n12 w=0.8u l=0.13u
MP5364 (n5362 n5356 vdd vdd) p12 w=2.4u l=0.13u
MN5367 (n5365 n4948 vss vss) n12 w=0.8u l=0.13u
MN5368 (n5365 n5014 vss vss) n12 w=0.8u l=0.13u
MP5369 (n5365 n4948 n5366 vdd) p12 w=4.8u l=0.13u
MP5370 (n5366 n5014 vdd vdd) p12 w=4.8u l=0.13u
MN5372 (n5371 n5365 vss vss) n12 w=0.8u l=0.13u
MP5373 (n5371 n5365 vdd vdd) p12 w=2.4u l=0.13u
MN5376 (n5374 n5080 vss vss) n12 w=0.8u l=0.13u
MN5377 (n5374 n5146 vss vss) n12 w=0.8u l=0.13u
MP5378 (n5374 n5080 n5375 vdd) p12 w=4.8u l=0.13u
MP5379 (n5375 n5146 vdd vdd) p12 w=4.8u l=0.13u
MN5381 (n5380 n5374 vss vss) n12 w=0.8u l=0.13u
MP5382 (n5380 n5374 vdd vdd) p12 w=2.4u l=0.13u
MN5385 (n5383 n5212 vss vss) n12 w=0.8u l=0.13u
MN5386 (n5383 n5278 vss vss) n12 w=0.8u l=0.13u
MP5387 (n5383 n5212 n5384 vdd) p12 w=4.8u l=0.13u
MP5388 (n5384 n5278 vdd vdd) p12 w=4.8u l=0.13u
MN5390 (n5389 n5383 vss vss) n12 w=0.8u l=0.13u
MP5391 (n5389 n5383 vdd vdd) p12 w=2.4u l=0.13u
MN5394 (n5392 n5371 vss vss) n12 w=0.8u l=0.13u
MN5395 (n5392 n5380 vss vss) n12 w=0.8u l=0.13u
MP5396 (n5392 n5371 n5393 vdd) p12 w=4.8u l=0.13u
MP5397 (n5393 n5380 vdd vdd) p12 w=4.8u l=0.13u
MN5399 (n5398 n5392 vss vss) n12 w=0.8u l=0.13u
MP5400 (n5398 n5392 vdd vdd) p12 w=2.4u l=0.13u
MN5403 (n5401 n5344 vss vss) n12 w=0.8u l=0.13u
MN5404 (n5401 n5389 vss vss) n12 w=0.8u l=0.13u
MP5405 (n5401 n5344 n5402 vdd) p12 w=4.8u l=0.13u
MP5406 (n5402 n5389 vdd vdd) p12 w=4.8u l=0.13u
MN5408 (n5407 n5401 vss vss) n12 w=0.8u l=0.13u
MP5409 (n5407 n5401 vdd vdd) p12 w=2.4u l=0.13u
MN5412 (n5410 n5398 vss vss) n12 w=0.8u l=0.13u
MN5413 (n5410 n5407 vss vss) n12 w=0.8u l=0.13u
MP5414 (n5410 n5398 n5411 vdd) p12 w=4.8u l=0.13u
MP5415 (n5411 n5407 vdd vdd) p12 w=4.8u l=0.13u
MN5417 (n5416 n5410 vss vss) n12 w=0.8u l=0.13u
MP5418 (n5416 n5410 vdd vdd) p12 w=2.4u l=0.13u
MN5421 (n5419 n5362 n5420 vss) n12 w=1.6u l=0.13u
MN5422 (n5420 n5416 vss vss) n12 w=1.6u l=0.13u
MP5423 (n5419 n5362 vdd vdd) p12 w=2.4u l=0.13u
MP5424 (n5419 n5416 vdd vdd) p12 w=2.4u l=0.13u
MN5426 (n5425 n5419 vss vss) n12 w=0.8u l=0.13u
MP5427 (n5425 n5419 vdd vdd) p12 w=2.4u l=0.13u
MN5429 (n5428 cl0 vss vss) n12 w=0.8u l=0.13u
MP5430 (n5428 cl0 vdd vdd) p12 w=2.4u l=0.13u
MN5433 (n5431 cd0 n5432 vss) n12 w=1.6u l=0.13u
MN5434 (n5432 n5428 vss vss) n12 w=1.6u l=0.13u
MP5435 (n5431 cd0 vdd vdd) p12 w=2.4u l=0.13u
MP5436 (n5431 n5428 vdd vdd) p12 w=2.4u l=0.13u
MN5439 (n5437 cd0 n5438 vss) n12 w=1.6u l=0.13u
MN5440 (n5438 n5431 vss vss) n12 w=1.6u l=0.13u
MP5441 (n5437 cd0 vdd vdd) p12 w=2.4u l=0.13u
MP5442 (n5437 n5431 vdd vdd) p12 w=2.4u l=0.13u
MN5445 (n5443 n5428 n5444 vss) n12 w=1.6u l=0.13u
MN5446 (n5444 n5431 vss vss) n12 w=1.6u l=0.13u
MP5447 (n5443 n5428 vdd vdd) p12 w=2.4u l=0.13u
MP5448 (n5443 n5431 vdd vdd) p12 w=2.4u l=0.13u
MN5451 (n5449 n5437 n5450 vss) n12 w=1.6u l=0.13u
MN5452 (n5450 n5443 vss vss) n12 w=1.6u l=0.13u
MP5453 (n5449 n5437 vdd vdd) p12 w=2.4u l=0.13u
MP5454 (n5449 n5443 vdd vdd) p12 w=2.4u l=0.13u
MN5456 (n5455 n5449 vss vss) n12 w=0.8u l=0.13u
MP5457 (n5455 n5449 vdd vdd) p12 w=2.4u l=0.13u
MN5459 (n5458 n5431 vss vss) n12 w=0.8u l=0.13u
MP5460 (n5458 n5431 vdd vdd) p12 w=2.4u l=0.13u
MN5463 (n5461 n5449 vss vss) n12 w=0.8u l=0.13u
MN5464 (n5461 n5458 vss vss) n12 w=0.8u l=0.13u
MP5465 (n5461 n5449 n5462 vdd) p12 w=4.8u l=0.13u
MP5466 (n5462 n5458 vdd vdd) p12 w=4.8u l=0.13u
MN5468 (n5467 n5461 vss vss) n12 w=0.8u l=0.13u
MP5469 (n5467 n5461 vdd vdd) p12 w=2.4u l=0.13u
MN5471 (n5470 cl1 vss vss) n12 w=0.8u l=0.13u
MP5472 (n5470 cl1 vdd vdd) p12 w=2.4u l=0.13u
MN5475 (n5473 cd1 n5474 vss) n12 w=1.6u l=0.13u
MN5476 (n5474 n5470 vss vss) n12 w=1.6u l=0.13u
MP5477 (n5473 cd1 vdd vdd) p12 w=2.4u l=0.13u
MP5478 (n5473 n5470 vdd vdd) p12 w=2.4u l=0.13u
MN5481 (n5479 cd1 n5480 vss) n12 w=1.6u l=0.13u
MN5482 (n5480 n5473 vss vss) n12 w=1.6u l=0.13u
MP5483 (n5479 cd1 vdd vdd) p12 w=2.4u l=0.13u
MP5484 (n5479 n5473 vdd vdd) p12 w=2.4u l=0.13u
MN5487 (n5485 n5470 n5486 vss) n12 w=1.6u l=0.13u
MN5488 (n5486 n5473 vss vss) n12 w=1.6u l=0.13u
MP5489 (n5485 n5470 vdd vdd) p12 w=2.4u l=0.13u
MP5490 (n5485 n5473 vdd vdd) p12 w=2.4u l=0.13u
MN5493 (n5491 n5479 n5492 vss) n12 w=1.6u l=0.13u
MN5494 (n5492 n5485 vss vss) n12 w=1.6u l=0.13u
MP5495 (n5491 n5479 vdd vdd) p12 w=2.4u l=0.13u
MP5496 (n5491 n5485 vdd vdd) p12 w=2.4u l=0.13u
MN5499 (n5497 n5467 n5498 vss) n12 w=1.6u l=0.13u
MN5500 (n5498 n5491 vss vss) n12 w=1.6u l=0.13u
MP5501 (n5497 n5467 vdd vdd) p12 w=2.4u l=0.13u
MP5502 (n5497 n5491 vdd vdd) p12 w=2.4u l=0.13u
MN5505 (n5503 n5467 n5504 vss) n12 w=1.6u l=0.13u
MN5506 (n5504 n5497 vss vss) n12 w=1.6u l=0.13u
MP5507 (n5503 n5467 vdd vdd) p12 w=2.4u l=0.13u
MP5508 (n5503 n5497 vdd vdd) p12 w=2.4u l=0.13u
MN5511 (n5509 n5491 n5510 vss) n12 w=1.6u l=0.13u
MN5512 (n5510 n5497 vss vss) n12 w=1.6u l=0.13u
MP5513 (n5509 n5491 vdd vdd) p12 w=2.4u l=0.13u
MP5514 (n5509 n5497 vdd vdd) p12 w=2.4u l=0.13u
MN5517 (n5515 n5503 n5516 vss) n12 w=1.6u l=0.13u
MN5518 (n5516 n5509 vss vss) n12 w=1.6u l=0.13u
MP5519 (n5515 n5503 vdd vdd) p12 w=2.4u l=0.13u
MP5520 (n5515 n5509 vdd vdd) p12 w=2.4u l=0.13u
MN5522 (n5521 n5473 vss vss) n12 w=0.8u l=0.13u
MP5523 (n5521 n5473 vdd vdd) p12 w=2.4u l=0.13u
MN5525 (n5524 n5497 vss vss) n12 w=0.8u l=0.13u
MP5526 (n5524 n5497 vdd vdd) p12 w=2.4u l=0.13u
MN5529 (n5527 n5521 vss vss) n12 w=0.8u l=0.13u
MN5530 (n5527 n5524 vss vss) n12 w=0.8u l=0.13u
MP5531 (n5527 n5521 n5528 vdd) p12 w=4.8u l=0.13u
MP5532 (n5528 n5524 vdd vdd) p12 w=4.8u l=0.13u
MN5534 (n5533 n5527 vss vss) n12 w=0.8u l=0.13u
MP5535 (n5533 n5527 vdd vdd) p12 w=2.4u l=0.13u
MN5537 (n5536 cl2 vss vss) n12 w=0.8u l=0.13u
MP5538 (n5536 cl2 vdd vdd) p12 w=2.4u l=0.13u
MN5541 (n5539 cd2 n5540 vss) n12 w=1.6u l=0.13u
MN5542 (n5540 n5536 vss vss) n12 w=1.6u l=0.13u
MP5543 (n5539 cd2 vdd vdd) p12 w=2.4u l=0.13u
MP5544 (n5539 n5536 vdd vdd) p12 w=2.4u l=0.13u
MN5547 (n5545 cd2 n5546 vss) n12 w=1.6u l=0.13u
MN5548 (n5546 n5539 vss vss) n12 w=1.6u l=0.13u
MP5549 (n5545 cd2 vdd vdd) p12 w=2.4u l=0.13u
MP5550 (n5545 n5539 vdd vdd) p12 w=2.4u l=0.13u
MN5553 (n5551 n5536 n5552 vss) n12 w=1.6u l=0.13u
MN5554 (n5552 n5539 vss vss) n12 w=1.6u l=0.13u
MP5555 (n5551 n5536 vdd vdd) p12 w=2.4u l=0.13u
MP5556 (n5551 n5539 vdd vdd) p12 w=2.4u l=0.13u
MN5559 (n5557 n5545 n5558 vss) n12 w=1.6u l=0.13u
MN5560 (n5558 n5551 vss vss) n12 w=1.6u l=0.13u
MP5561 (n5557 n5545 vdd vdd) p12 w=2.4u l=0.13u
MP5562 (n5557 n5551 vdd vdd) p12 w=2.4u l=0.13u
MN5565 (n5563 n5533 n5564 vss) n12 w=1.6u l=0.13u
MN5566 (n5564 n5557 vss vss) n12 w=1.6u l=0.13u
MP5567 (n5563 n5533 vdd vdd) p12 w=2.4u l=0.13u
MP5568 (n5563 n5557 vdd vdd) p12 w=2.4u l=0.13u
MN5571 (n5569 n5533 n5570 vss) n12 w=1.6u l=0.13u
MN5572 (n5570 n5563 vss vss) n12 w=1.6u l=0.13u
MP5573 (n5569 n5533 vdd vdd) p12 w=2.4u l=0.13u
MP5574 (n5569 n5563 vdd vdd) p12 w=2.4u l=0.13u
MN5577 (n5575 n5557 n5576 vss) n12 w=1.6u l=0.13u
MN5578 (n5576 n5563 vss vss) n12 w=1.6u l=0.13u
MP5579 (n5575 n5557 vdd vdd) p12 w=2.4u l=0.13u
MP5580 (n5575 n5563 vdd vdd) p12 w=2.4u l=0.13u
MN5583 (n5581 n5569 n5582 vss) n12 w=1.6u l=0.13u
MN5584 (n5582 n5575 vss vss) n12 w=1.6u l=0.13u
MP5585 (n5581 n5569 vdd vdd) p12 w=2.4u l=0.13u
MP5586 (n5581 n5575 vdd vdd) p12 w=2.4u l=0.13u
MN5588 (n5587 n5539 vss vss) n12 w=0.8u l=0.13u
MP5589 (n5587 n5539 vdd vdd) p12 w=2.4u l=0.13u
MN5591 (n5590 n5563 vss vss) n12 w=0.8u l=0.13u
MP5592 (n5590 n5563 vdd vdd) p12 w=2.4u l=0.13u
MN5595 (n5593 n5587 vss vss) n12 w=0.8u l=0.13u
MN5596 (n5593 n5590 vss vss) n12 w=0.8u l=0.13u
MP5597 (n5593 n5587 n5594 vdd) p12 w=4.8u l=0.13u
MP5598 (n5594 n5590 vdd vdd) p12 w=4.8u l=0.13u
MN5600 (n5599 n5593 vss vss) n12 w=0.8u l=0.13u
MP5601 (n5599 n5593 vdd vdd) p12 w=2.4u l=0.13u
MN5603 (n5602 cl3 vss vss) n12 w=0.8u l=0.13u
MP5604 (n5602 cl3 vdd vdd) p12 w=2.4u l=0.13u
MN5607 (n5605 cd3 n5606 vss) n12 w=1.6u l=0.13u
MN5608 (n5606 n5602 vss vss) n12 w=1.6u l=0.13u
MP5609 (n5605 cd3 vdd vdd) p12 w=2.4u l=0.13u
MP5610 (n5605 n5602 vdd vdd) p12 w=2.4u l=0.13u
MN5613 (n5611 cd3 n5612 vss) n12 w=1.6u l=0.13u
MN5614 (n5612 n5605 vss vss) n12 w=1.6u l=0.13u
MP5615 (n5611 cd3 vdd vdd) p12 w=2.4u l=0.13u
MP5616 (n5611 n5605 vdd vdd) p12 w=2.4u l=0.13u
MN5619 (n5617 n5602 n5618 vss) n12 w=1.6u l=0.13u
MN5620 (n5618 n5605 vss vss) n12 w=1.6u l=0.13u
MP5621 (n5617 n5602 vdd vdd) p12 w=2.4u l=0.13u
MP5622 (n5617 n5605 vdd vdd) p12 w=2.4u l=0.13u
MN5625 (n5623 n5611 n5624 vss) n12 w=1.6u l=0.13u
MN5626 (n5624 n5617 vss vss) n12 w=1.6u l=0.13u
MP5627 (n5623 n5611 vdd vdd) p12 w=2.4u l=0.13u
MP5628 (n5623 n5617 vdd vdd) p12 w=2.4u l=0.13u
MN5631 (n5629 n5599 n5630 vss) n12 w=1.6u l=0.13u
MN5632 (n5630 n5623 vss vss) n12 w=1.6u l=0.13u
MP5633 (n5629 n5599 vdd vdd) p12 w=2.4u l=0.13u
MP5634 (n5629 n5623 vdd vdd) p12 w=2.4u l=0.13u
MN5637 (n5635 n5599 n5636 vss) n12 w=1.6u l=0.13u
MN5638 (n5636 n5629 vss vss) n12 w=1.6u l=0.13u
MP5639 (n5635 n5599 vdd vdd) p12 w=2.4u l=0.13u
MP5640 (n5635 n5629 vdd vdd) p12 w=2.4u l=0.13u
MN5643 (n5641 n5623 n5642 vss) n12 w=1.6u l=0.13u
MN5644 (n5642 n5629 vss vss) n12 w=1.6u l=0.13u
MP5645 (n5641 n5623 vdd vdd) p12 w=2.4u l=0.13u
MP5646 (n5641 n5629 vdd vdd) p12 w=2.4u l=0.13u
MN5649 (n5647 n5635 n5648 vss) n12 w=1.6u l=0.13u
MN5650 (n5648 n5641 vss vss) n12 w=1.6u l=0.13u
MP5651 (n5647 n5635 vdd vdd) p12 w=2.4u l=0.13u
MP5652 (n5647 n5641 vdd vdd) p12 w=2.4u l=0.13u
MN5654 (n5653 n5605 vss vss) n12 w=0.8u l=0.13u
MP5655 (n5653 n5605 vdd vdd) p12 w=2.4u l=0.13u
MN5657 (n5656 n5629 vss vss) n12 w=0.8u l=0.13u
MP5658 (n5656 n5629 vdd vdd) p12 w=2.4u l=0.13u
MN5661 (n5659 n5653 vss vss) n12 w=0.8u l=0.13u
MN5662 (n5659 n5656 vss vss) n12 w=0.8u l=0.13u
MP5663 (n5659 n5653 n5660 vdd) p12 w=4.8u l=0.13u
MP5664 (n5660 n5656 vdd vdd) p12 w=4.8u l=0.13u
MN5666 (n5665 n5659 vss vss) n12 w=0.8u l=0.13u
MP5667 (n5665 n5659 vdd vdd) p12 w=2.4u l=0.13u
MN5669 (n5668 cl4 vss vss) n12 w=0.8u l=0.13u
MP5670 (n5668 cl4 vdd vdd) p12 w=2.4u l=0.13u
MN5673 (n5671 cd4 n5672 vss) n12 w=1.6u l=0.13u
MN5674 (n5672 n5668 vss vss) n12 w=1.6u l=0.13u
MP5675 (n5671 cd4 vdd vdd) p12 w=2.4u l=0.13u
MP5676 (n5671 n5668 vdd vdd) p12 w=2.4u l=0.13u
MN5679 (n5677 cd4 n5678 vss) n12 w=1.6u l=0.13u
MN5680 (n5678 n5671 vss vss) n12 w=1.6u l=0.13u
MP5681 (n5677 cd4 vdd vdd) p12 w=2.4u l=0.13u
MP5682 (n5677 n5671 vdd vdd) p12 w=2.4u l=0.13u
MN5685 (n5683 n5668 n5684 vss) n12 w=1.6u l=0.13u
MN5686 (n5684 n5671 vss vss) n12 w=1.6u l=0.13u
MP5687 (n5683 n5668 vdd vdd) p12 w=2.4u l=0.13u
MP5688 (n5683 n5671 vdd vdd) p12 w=2.4u l=0.13u
MN5691 (n5689 n5677 n5690 vss) n12 w=1.6u l=0.13u
MN5692 (n5690 n5683 vss vss) n12 w=1.6u l=0.13u
MP5693 (n5689 n5677 vdd vdd) p12 w=2.4u l=0.13u
MP5694 (n5689 n5683 vdd vdd) p12 w=2.4u l=0.13u
MN5697 (n5695 n5665 n5696 vss) n12 w=1.6u l=0.13u
MN5698 (n5696 n5689 vss vss) n12 w=1.6u l=0.13u
MP5699 (n5695 n5665 vdd vdd) p12 w=2.4u l=0.13u
MP5700 (n5695 n5689 vdd vdd) p12 w=2.4u l=0.13u
MN5703 (n5701 n5665 n5702 vss) n12 w=1.6u l=0.13u
MN5704 (n5702 n5695 vss vss) n12 w=1.6u l=0.13u
MP5705 (n5701 n5665 vdd vdd) p12 w=2.4u l=0.13u
MP5706 (n5701 n5695 vdd vdd) p12 w=2.4u l=0.13u
MN5709 (n5707 n5689 n5708 vss) n12 w=1.6u l=0.13u
MN5710 (n5708 n5695 vss vss) n12 w=1.6u l=0.13u
MP5711 (n5707 n5689 vdd vdd) p12 w=2.4u l=0.13u
MP5712 (n5707 n5695 vdd vdd) p12 w=2.4u l=0.13u
MN5715 (n5713 n5701 n5714 vss) n12 w=1.6u l=0.13u
MN5716 (n5714 n5707 vss vss) n12 w=1.6u l=0.13u
MP5717 (n5713 n5701 vdd vdd) p12 w=2.4u l=0.13u
MP5718 (n5713 n5707 vdd vdd) p12 w=2.4u l=0.13u
MN5720 (n5719 n5671 vss vss) n12 w=0.8u l=0.13u
MP5721 (n5719 n5671 vdd vdd) p12 w=2.4u l=0.13u
MN5723 (n5722 n5695 vss vss) n12 w=0.8u l=0.13u
MP5724 (n5722 n5695 vdd vdd) p12 w=2.4u l=0.13u
MN5727 (n5725 n5719 vss vss) n12 w=0.8u l=0.13u
MN5728 (n5725 n5722 vss vss) n12 w=0.8u l=0.13u
MP5729 (n5725 n5719 n5726 vdd) p12 w=4.8u l=0.13u
MP5730 (n5726 n5722 vdd vdd) p12 w=4.8u l=0.13u
MN5732 (n5731 n5725 vss vss) n12 w=0.8u l=0.13u
MP5733 (n5731 n5725 vdd vdd) p12 w=2.4u l=0.13u
MN5735 (n5734 cl5 vss vss) n12 w=0.8u l=0.13u
MP5736 (n5734 cl5 vdd vdd) p12 w=2.4u l=0.13u
MN5739 (n5737 cd5 n5738 vss) n12 w=1.6u l=0.13u
MN5740 (n5738 n5734 vss vss) n12 w=1.6u l=0.13u
MP5741 (n5737 cd5 vdd vdd) p12 w=2.4u l=0.13u
MP5742 (n5737 n5734 vdd vdd) p12 w=2.4u l=0.13u
MN5745 (n5743 cd5 n5744 vss) n12 w=1.6u l=0.13u
MN5746 (n5744 n5737 vss vss) n12 w=1.6u l=0.13u
MP5747 (n5743 cd5 vdd vdd) p12 w=2.4u l=0.13u
MP5748 (n5743 n5737 vdd vdd) p12 w=2.4u l=0.13u
MN5751 (n5749 n5734 n5750 vss) n12 w=1.6u l=0.13u
MN5752 (n5750 n5737 vss vss) n12 w=1.6u l=0.13u
MP5753 (n5749 n5734 vdd vdd) p12 w=2.4u l=0.13u
MP5754 (n5749 n5737 vdd vdd) p12 w=2.4u l=0.13u
MN5757 (n5755 n5743 n5756 vss) n12 w=1.6u l=0.13u
MN5758 (n5756 n5749 vss vss) n12 w=1.6u l=0.13u
MP5759 (n5755 n5743 vdd vdd) p12 w=2.4u l=0.13u
MP5760 (n5755 n5749 vdd vdd) p12 w=2.4u l=0.13u
MN5763 (n5761 n5731 n5762 vss) n12 w=1.6u l=0.13u
MN5764 (n5762 n5755 vss vss) n12 w=1.6u l=0.13u
MP5765 (n5761 n5731 vdd vdd) p12 w=2.4u l=0.13u
MP5766 (n5761 n5755 vdd vdd) p12 w=2.4u l=0.13u
MN5769 (n5767 n5731 n5768 vss) n12 w=1.6u l=0.13u
MN5770 (n5768 n5761 vss vss) n12 w=1.6u l=0.13u
MP5771 (n5767 n5731 vdd vdd) p12 w=2.4u l=0.13u
MP5772 (n5767 n5761 vdd vdd) p12 w=2.4u l=0.13u
MN5775 (n5773 n5755 n5774 vss) n12 w=1.6u l=0.13u
MN5776 (n5774 n5761 vss vss) n12 w=1.6u l=0.13u
MP5777 (n5773 n5755 vdd vdd) p12 w=2.4u l=0.13u
MP5778 (n5773 n5761 vdd vdd) p12 w=2.4u l=0.13u
MN5781 (n5779 n5767 n5780 vss) n12 w=1.6u l=0.13u
MN5782 (n5780 n5773 vss vss) n12 w=1.6u l=0.13u
MP5783 (n5779 n5767 vdd vdd) p12 w=2.4u l=0.13u
MP5784 (n5779 n5773 vdd vdd) p12 w=2.4u l=0.13u
MN5786 (n5785 n5737 vss vss) n12 w=0.8u l=0.13u
MP5787 (n5785 n5737 vdd vdd) p12 w=2.4u l=0.13u
MN5789 (n5788 n5761 vss vss) n12 w=0.8u l=0.13u
MP5790 (n5788 n5761 vdd vdd) p12 w=2.4u l=0.13u
MN5793 (n5791 n5785 vss vss) n12 w=0.8u l=0.13u
MN5794 (n5791 n5788 vss vss) n12 w=0.8u l=0.13u
MP5795 (n5791 n5785 n5792 vdd) p12 w=4.8u l=0.13u
MP5796 (n5792 n5788 vdd vdd) p12 w=4.8u l=0.13u
MN5798 (n5797 n5791 vss vss) n12 w=0.8u l=0.13u
MP5799 (n5797 n5791 vdd vdd) p12 w=2.4u l=0.13u
MN5801 (n5800 cl6 vss vss) n12 w=0.8u l=0.13u
MP5802 (n5800 cl6 vdd vdd) p12 w=2.4u l=0.13u
MN5805 (n5803 cd6 n5804 vss) n12 w=1.6u l=0.13u
MN5806 (n5804 n5800 vss vss) n12 w=1.6u l=0.13u
MP5807 (n5803 cd6 vdd vdd) p12 w=2.4u l=0.13u
MP5808 (n5803 n5800 vdd vdd) p12 w=2.4u l=0.13u
MN5811 (n5809 cd6 n5810 vss) n12 w=1.6u l=0.13u
MN5812 (n5810 n5803 vss vss) n12 w=1.6u l=0.13u
MP5813 (n5809 cd6 vdd vdd) p12 w=2.4u l=0.13u
MP5814 (n5809 n5803 vdd vdd) p12 w=2.4u l=0.13u
MN5817 (n5815 n5800 n5816 vss) n12 w=1.6u l=0.13u
MN5818 (n5816 n5803 vss vss) n12 w=1.6u l=0.13u
MP5819 (n5815 n5800 vdd vdd) p12 w=2.4u l=0.13u
MP5820 (n5815 n5803 vdd vdd) p12 w=2.4u l=0.13u
MN5823 (n5821 n5809 n5822 vss) n12 w=1.6u l=0.13u
MN5824 (n5822 n5815 vss vss) n12 w=1.6u l=0.13u
MP5825 (n5821 n5809 vdd vdd) p12 w=2.4u l=0.13u
MP5826 (n5821 n5815 vdd vdd) p12 w=2.4u l=0.13u
MN5829 (n5827 n5797 n5828 vss) n12 w=1.6u l=0.13u
MN5830 (n5828 n5821 vss vss) n12 w=1.6u l=0.13u
MP5831 (n5827 n5797 vdd vdd) p12 w=2.4u l=0.13u
MP5832 (n5827 n5821 vdd vdd) p12 w=2.4u l=0.13u
MN5835 (n5833 n5797 n5834 vss) n12 w=1.6u l=0.13u
MN5836 (n5834 n5827 vss vss) n12 w=1.6u l=0.13u
MP5837 (n5833 n5797 vdd vdd) p12 w=2.4u l=0.13u
MP5838 (n5833 n5827 vdd vdd) p12 w=2.4u l=0.13u
MN5841 (n5839 n5821 n5840 vss) n12 w=1.6u l=0.13u
MN5842 (n5840 n5827 vss vss) n12 w=1.6u l=0.13u
MP5843 (n5839 n5821 vdd vdd) p12 w=2.4u l=0.13u
MP5844 (n5839 n5827 vdd vdd) p12 w=2.4u l=0.13u
MN5847 (n5845 n5833 n5846 vss) n12 w=1.6u l=0.13u
MN5848 (n5846 n5839 vss vss) n12 w=1.6u l=0.13u
MP5849 (n5845 n5833 vdd vdd) p12 w=2.4u l=0.13u
MP5850 (n5845 n5839 vdd vdd) p12 w=2.4u l=0.13u
MN5852 (n5851 n5803 vss vss) n12 w=0.8u l=0.13u
MP5853 (n5851 n5803 vdd vdd) p12 w=2.4u l=0.13u
MN5855 (n5854 n5827 vss vss) n12 w=0.8u l=0.13u
MP5856 (n5854 n5827 vdd vdd) p12 w=2.4u l=0.13u
MN5859 (n5857 n5851 vss vss) n12 w=0.8u l=0.13u
MN5860 (n5857 n5854 vss vss) n12 w=0.8u l=0.13u
MP5861 (n5857 n5851 n5858 vdd) p12 w=4.8u l=0.13u
MP5862 (n5858 n5854 vdd vdd) p12 w=4.8u l=0.13u
MN5864 (n5863 n5857 vss vss) n12 w=0.8u l=0.13u
MP5865 (n5863 n5857 vdd vdd) p12 w=2.4u l=0.13u
MN5867 (n5866 cl7 vss vss) n12 w=0.8u l=0.13u
MP5868 (n5866 cl7 vdd vdd) p12 w=2.4u l=0.13u
MN5871 (n5869 cd7 n5870 vss) n12 w=1.6u l=0.13u
MN5872 (n5870 n5866 vss vss) n12 w=1.6u l=0.13u
MP5873 (n5869 cd7 vdd vdd) p12 w=2.4u l=0.13u
MP5874 (n5869 n5866 vdd vdd) p12 w=2.4u l=0.13u
MN5877 (n5875 cd7 n5876 vss) n12 w=1.6u l=0.13u
MN5878 (n5876 n5869 vss vss) n12 w=1.6u l=0.13u
MP5879 (n5875 cd7 vdd vdd) p12 w=2.4u l=0.13u
MP5880 (n5875 n5869 vdd vdd) p12 w=2.4u l=0.13u
MN5883 (n5881 n5866 n5882 vss) n12 w=1.6u l=0.13u
MN5884 (n5882 n5869 vss vss) n12 w=1.6u l=0.13u
MP5885 (n5881 n5866 vdd vdd) p12 w=2.4u l=0.13u
MP5886 (n5881 n5869 vdd vdd) p12 w=2.4u l=0.13u
MN5889 (n5887 n5875 n5888 vss) n12 w=1.6u l=0.13u
MN5890 (n5888 n5881 vss vss) n12 w=1.6u l=0.13u
MP5891 (n5887 n5875 vdd vdd) p12 w=2.4u l=0.13u
MP5892 (n5887 n5881 vdd vdd) p12 w=2.4u l=0.13u
MN5895 (n5893 n5863 n5894 vss) n12 w=1.6u l=0.13u
MN5896 (n5894 n5887 vss vss) n12 w=1.6u l=0.13u
MP5897 (n5893 n5863 vdd vdd) p12 w=2.4u l=0.13u
MP5898 (n5893 n5887 vdd vdd) p12 w=2.4u l=0.13u
MN5901 (n5899 n5863 n5900 vss) n12 w=1.6u l=0.13u
MN5902 (n5900 n5893 vss vss) n12 w=1.6u l=0.13u
MP5903 (n5899 n5863 vdd vdd) p12 w=2.4u l=0.13u
MP5904 (n5899 n5893 vdd vdd) p12 w=2.4u l=0.13u
MN5907 (n5905 n5887 n5906 vss) n12 w=1.6u l=0.13u
MN5908 (n5906 n5893 vss vss) n12 w=1.6u l=0.13u
MP5909 (n5905 n5887 vdd vdd) p12 w=2.4u l=0.13u
MP5910 (n5905 n5893 vdd vdd) p12 w=2.4u l=0.13u
MN5913 (n5911 n5899 n5912 vss) n12 w=1.6u l=0.13u
MN5914 (n5912 n5905 vss vss) n12 w=1.6u l=0.13u
MP5915 (n5911 n5899 vdd vdd) p12 w=2.4u l=0.13u
MP5916 (n5911 n5905 vdd vdd) p12 w=2.4u l=0.13u
MN5918 (n5917 n5869 vss vss) n12 w=0.8u l=0.13u
MP5919 (n5917 n5869 vdd vdd) p12 w=2.4u l=0.13u
MN5921 (n5920 n5893 vss vss) n12 w=0.8u l=0.13u
MP5922 (n5920 n5893 vdd vdd) p12 w=2.4u l=0.13u
MN5925 (n5923 n5917 vss vss) n12 w=0.8u l=0.13u
MN5926 (n5923 n5920 vss vss) n12 w=0.8u l=0.13u
MP5927 (n5923 n5917 n5924 vdd) p12 w=4.8u l=0.13u
MP5928 (n5924 n5920 vdd vdd) p12 w=4.8u l=0.13u
MN5930 (n5929 n5923 vss vss) n12 w=0.8u l=0.13u
MP5931 (n5929 n5923 vdd vdd) p12 w=2.4u l=0.13u
MN5934 (n5932 n5515 vss vss) n12 w=0.8u l=0.13u
MN5935 (n5932 n5581 vss vss) n12 w=0.8u l=0.13u
MP5936 (n5932 n5515 n5933 vdd) p12 w=4.8u l=0.13u
MP5937 (n5933 n5581 vdd vdd) p12 w=4.8u l=0.13u
MN5939 (n5938 n5932 vss vss) n12 w=0.8u l=0.13u
MP5940 (n5938 n5932 vdd vdd) p12 w=2.4u l=0.13u
MN5943 (n5941 n5647 vss vss) n12 w=0.8u l=0.13u
MN5944 (n5941 n5713 vss vss) n12 w=0.8u l=0.13u
MP5945 (n5941 n5647 n5942 vdd) p12 w=4.8u l=0.13u
MP5946 (n5942 n5713 vdd vdd) p12 w=4.8u l=0.13u
MN5948 (n5947 n5941 vss vss) n12 w=0.8u l=0.13u
MP5949 (n5947 n5941 vdd vdd) p12 w=2.4u l=0.13u
MN5952 (n5950 n5779 vss vss) n12 w=0.8u l=0.13u
MN5953 (n5950 n5845 vss vss) n12 w=0.8u l=0.13u
MP5954 (n5950 n5779 n5951 vdd) p12 w=4.8u l=0.13u
MP5955 (n5951 n5845 vdd vdd) p12 w=4.8u l=0.13u
MN5957 (n5956 n5950 vss vss) n12 w=0.8u l=0.13u
MP5958 (n5956 n5950 vdd vdd) p12 w=2.4u l=0.13u
MN5961 (n5959 n5938 vss vss) n12 w=0.8u l=0.13u
MN5962 (n5959 n5947 vss vss) n12 w=0.8u l=0.13u
MP5963 (n5959 n5938 n5960 vdd) p12 w=4.8u l=0.13u
MP5964 (n5960 n5947 vdd vdd) p12 w=4.8u l=0.13u
MN5966 (n5965 n5959 vss vss) n12 w=0.8u l=0.13u
MP5967 (n5965 n5959 vdd vdd) p12 w=2.4u l=0.13u
MN5970 (n5968 n5911 vss vss) n12 w=0.8u l=0.13u
MN5971 (n5968 n5956 vss vss) n12 w=0.8u l=0.13u
MP5972 (n5968 n5911 n5969 vdd) p12 w=4.8u l=0.13u
MP5973 (n5969 n5956 vdd vdd) p12 w=4.8u l=0.13u
MN5975 (n5974 n5968 vss vss) n12 w=0.8u l=0.13u
MP5976 (n5974 n5968 vdd vdd) p12 w=2.4u l=0.13u
MN5979 (n5977 n5965 vss vss) n12 w=0.8u l=0.13u
MN5980 (n5977 n5974 vss vss) n12 w=0.8u l=0.13u
MP5981 (n5977 n5965 n5978 vdd) p12 w=4.8u l=0.13u
MP5982 (n5978 n5974 vdd vdd) p12 w=4.8u l=0.13u
MN5984 (n5983 n5977 vss vss) n12 w=0.8u l=0.13u
MP5985 (n5983 n5977 vdd vdd) p12 w=2.4u l=0.13u
MN5988 (n5986 n5929 n5987 vss) n12 w=1.6u l=0.13u
MN5989 (n5987 n5983 vss vss) n12 w=1.6u l=0.13u
MP5990 (n5986 n5929 vdd vdd) p12 w=2.4u l=0.13u
MP5991 (n5986 n5983 vdd vdd) p12 w=2.4u l=0.13u
MN5993 (n5992 n5986 vss vss) n12 w=0.8u l=0.13u
MP5994 (n5992 n5986 vdd vdd) p12 w=2.4u l=0.13u
MN5996 (n5995 n5425 vss vss) n12 w=0.8u l=0.13u
MP5997 (n5995 n5425 vdd vdd) p12 w=2.4u l=0.13u
MN5999 (n5998 n5995 vss vss) n12 w=0.8u l=0.13u
MP6000 (n5998 n5995 vdd vdd) p12 w=2.4u l=0.13u
MN6002 (n6001 n5998 vss vss) n12 w=0.8u l=0.13u
MP6003 (n6001 n5998 vdd vdd) p12 w=2.4u l=0.13u
MN6004 (slow_raw n6001 vss vss) n12 w=0.8u l=0.13u
MP6005 (slow_raw n6001 vdd vdd) p12 w=2.4u l=0.13u
MN6007 (n6006 n5992 vss vss) n12 w=0.8u l=0.13u
MP6008 (n6006 n5992 vdd vdd) p12 w=2.4u l=0.13u
MN6010 (n6009 n6006 vss vss) n12 w=0.8u l=0.13u
MP6011 (n6009 n6006 vdd vdd) p12 w=2.4u l=0.13u
MN6013 (n6012 n6009 vss vss) n12 w=0.8u l=0.13u
MP6014 (n6012 n6009 vdd vdd) p12 w=2.4u l=0.13u
MN6015 (fast_raw n6012 vss vss) n12 w=0.8u l=0.13u
MP6016 (fast_raw n6012 vdd vdd) p12 w=2.4u l=0.13u
MN6018 (n6017 measure vss vss) n12 w=0.8u l=0.13u
MP6019 (n6017 measure vdd vdd) p12 w=2.4u l=0.13u
MN6022 (n6020 n6017 vss vss) n12 w=0.8u l=0.13u
MN6023 (n6020 rst vss vss) n12 w=0.8u l=0.13u
MP6024 (n6020 n6017 n6021 vdd) p12 w=4.8u l=0.13u
MP6025 (n6021 rst vdd vdd) p12 w=4.8u l=0.13u
MN6027 (n6026 n6020 vss vss) n12 w=0.8u l=0.13u
MP6028 (n6026 n6020 vdd vdd) p12 w=2.4u l=0.13u
MN6030 (n6029 n6026 vss vss) n12 w=0.8u l=0.13u
MP6031 (n6029 n6026 vdd vdd) p12 w=2.4u l=0.13u
MN6040 (n6036 n22 n6037 vss) n12 w=3.2u l=0.13u
MP6041 (n6036 n22 vdd vdd) p12 w=2.4u l=0.13u
MN6042 (n6037 n102 n6038 vss) n12 w=3.2u l=0.13u
MP6043 (n6036 n102 vdd vdd) p12 w=2.4u l=0.13u
MN6044 (n6038 clk_highb6035 n6039 vss) n12 w=3.2u l=0.13u
MP6045 (n6036 clk_highb6035 vdd vdd) p12 w=2.4u l=0.13u
MN6046 (n6039 n6029 vss vss) n12 w=3.2u l=0.13u
MP6047 (n6036 n6029 vdd vdd) p12 w=2.4u l=0.13u
MN6052 (n6048 n19 n6049 vss) n12 w=3.2u l=0.13u
MP6053 (n6048 n19 vdd vdd) p12 w=2.4u l=0.13u
MN6054 (n6049 delay99 n6050 vss) n12 w=3.2u l=0.13u
MP6055 (n6048 delay99 vdd vdd) p12 w=2.4u l=0.13u
MN6056 (n6050 clk_lowb6033 n6051 vss) n12 w=3.2u l=0.13u
MP6057 (n6048 clk_lowb6033 vdd vdd) p12 w=2.4u l=0.13u
MN6058 (n6051 n6029 vss vss) n12 w=3.2u l=0.13u
MP6059 (n6048 n6029 vdd vdd) p12 w=2.4u l=0.13u
MN6060 (clk_low6032 n6036 vss vss) n12 w=8u l=0.13u
MP6061 (clk_low6032 n6036 vdd vdd) p12 w=24u l=0.13u
MN6062 (clk_lowb6033 clk_low6032 vss vss) n12 w=8u l=0.13u
MP6063 (clk_lowb6033 clk_low6032 vdd vdd) p12 w=24u l=0.13u
MN6064 (clk_high6034 n6048 vss vss) n12 w=8u l=0.13u
MP6065 (clk_high6034 n6048 vdd vdd) p12 w=24u l=0.13u
MN6066 (clk_highb6035 clk_high6034 vss vss) n12 w=8u l=0.13u
MP6067 (clk_highb6035 clk_high6034 vdd vdd) p12 w=24u l=0.13u
MN6072 (n5425 clk_low6032 storage6071 vss) n12 w=1.2u l=0.13u
MP6073 (n5425 clk_lowb6033 storage6071 vdd) p12 w=3.6u l=0.13u
MN6074 (qm6068 clk_high6034 storage6071 vss) n12 w=1.2u l=0.13u
MP6075 (qm6068 clk_highb6035 storage6071 vdd) p12 w=3.6u l=0.13u
MN6076 (qmb6069 storage6071 vss vss) n12 w=0.5u l=0.13u
MP6077 (qmb6069 storage6071 vdd vdd) p12 w=1.5u l=0.13u
MN6078 (qm6068 qmb6069 vss vss) n12 w=0.5u l=0.13u
MP6079 (qm6068 qmb6069 vdd vdd) p12 w=1.5u l=0.13u
MN6080 (storage6071 n6026 vss vss) n12 w=2u l=0.13u
MN6082 (qm6068 clk_high6034 storage6081 vss) n12 w=1.2u l=0.13u
MP6083 (qm6068 clk_highb6035 storage6081 vdd) p12 w=3.6u l=0.13u
MN6084 (slow_prev clk_low6032 storage6081 vss) n12 w=1.2u l=0.13u
MP6085 (slow_prev clk_lowb6033 storage6081 vdd) p12 w=3.6u l=0.13u
MN6086 (qb6070 storage6081 vss vss) n12 w=0.5u l=0.13u
MP6087 (qb6070 storage6081 vdd vdd) p12 w=1.5u l=0.13u
MN6088 (slow_prev qb6070 vss vss) n12 w=0.5u l=0.13u
MP6089 (slow_prev qb6070 vdd vdd) p12 w=1.5u l=0.13u
MN6090 (storage6081 n6026 vss vss) n12 w=2u l=0.13u
MN6095 (n5992 clk_low6032 storage6094 vss) n12 w=1.2u l=0.13u
MP6096 (n5992 clk_lowb6033 storage6094 vdd) p12 w=3.6u l=0.13u
MN6097 (qm6091 clk_high6034 storage6094 vss) n12 w=1.2u l=0.13u
MP6098 (qm6091 clk_highb6035 storage6094 vdd) p12 w=3.6u l=0.13u
MN6099 (qmb6092 storage6094 vss vss) n12 w=0.5u l=0.13u
MP6100 (qmb6092 storage6094 vdd vdd) p12 w=1.5u l=0.13u
MN6101 (qm6091 qmb6092 vss vss) n12 w=0.5u l=0.13u
MP6102 (qm6091 qmb6092 vdd vdd) p12 w=1.5u l=0.13u
MN6103 (storage6094 n6026 vss vss) n12 w=2u l=0.13u
MN6105 (qm6091 clk_high6034 storage6104 vss) n12 w=1.2u l=0.13u
MP6106 (qm6091 clk_highb6035 storage6104 vdd) p12 w=3.6u l=0.13u
MN6107 (fast_prev clk_low6032 storage6104 vss) n12 w=1.2u l=0.13u
MP6108 (fast_prev clk_lowb6033 storage6104 vdd) p12 w=3.6u l=0.13u
MN6109 (qb6093 storage6104 vss vss) n12 w=0.5u l=0.13u
MP6110 (qb6093 storage6104 vdd vdd) p12 w=1.5u l=0.13u
MN6111 (fast_prev qb6093 vss vss) n12 w=0.5u l=0.13u
MP6112 (fast_prev qb6093 vdd vdd) p12 w=1.5u l=0.13u
MN6113 (storage6104 n6026 vss vss) n12 w=2u l=0.13u
MN6116 (n6114 n5425 n6115 vss) n12 w=1.6u l=0.13u
MN6117 (n6115 slow_prev vss vss) n12 w=1.6u l=0.13u
MP6118 (n6114 n5425 vdd vdd) p12 w=2.4u l=0.13u
MP6119 (n6114 slow_prev vdd vdd) p12 w=2.4u l=0.13u
MN6121 (n6120 n6114 vss vss) n12 w=0.8u l=0.13u
MP6122 (n6120 n6114 vdd vdd) p12 w=2.4u l=0.13u
MN6125 (n6123 fast_prev n6124 vss) n12 w=1.6u l=0.13u
MN6126 (n6124 n5992 vss vss) n12 w=1.6u l=0.13u
MP6127 (n6123 fast_prev vdd vdd) p12 w=2.4u l=0.13u
MP6128 (n6123 n5992 vdd vdd) p12 w=2.4u l=0.13u
MN6130 (n6129 n6123 vss vss) n12 w=0.8u l=0.13u
MP6131 (n6129 n6123 vdd vdd) p12 w=2.4u l=0.13u
MN6133 (n6132 n6120 vss vss) n12 w=0.8u l=0.13u
MP6134 (n6132 n6120 vdd vdd) p12 w=2.4u l=0.13u
MN6136 (n6135 n6132 vss vss) n12 w=0.8u l=0.13u
MP6137 (n6135 n6132 vdd vdd) p12 w=2.4u l=0.13u
MN6139 (n6138 n6135 vss vss) n12 w=0.8u l=0.13u
MP6140 (n6138 n6135 vdd vdd) p12 w=2.4u l=0.13u
MN6141 (slow_qualified n6138 vss vss) n12 w=0.8u l=0.13u
MP6142 (slow_qualified n6138 vdd vdd) p12 w=2.4u l=0.13u
MN6144 (n6143 n6129 vss vss) n12 w=0.8u l=0.13u
MP6145 (n6143 n6129 vdd vdd) p12 w=2.4u l=0.13u
MN6147 (n6146 n6143 vss vss) n12 w=0.8u l=0.13u
MP6148 (n6146 n6143 vdd vdd) p12 w=2.4u l=0.13u
MN6150 (n6149 n6146 vss vss) n12 w=0.8u l=0.13u
MP6151 (n6149 n6146 vdd vdd) p12 w=2.4u l=0.13u
MN6152 (fast_qualified n6149 vss vss) n12 w=0.8u l=0.13u
MP6153 (fast_qualified n6149 vdd vdd) p12 w=2.4u l=0.13u
MN6156 (n6154 n6120 n6155 vss) n12 w=1.6u l=0.13u
MN6157 (n6155 n6129 vss vss) n12 w=1.6u l=0.13u
MP6158 (n6154 n6120 vdd vdd) p12 w=2.4u l=0.13u
MP6159 (n6154 n6129 vdd vdd) p12 w=2.4u l=0.13u
MN6161 (n6160 n6154 vss vss) n12 w=0.8u l=0.13u
MP6162 (n6160 n6154 vdd vdd) p12 w=2.4u l=0.13u
MN6165 (n6163 n6120 vss vss) n12 w=0.8u l=0.13u
MN6166 (n6163 n6129 vss vss) n12 w=0.8u l=0.13u
MP6167 (n6163 n6120 n6164 vdd) p12 w=4.8u l=0.13u
MP6168 (n6164 n6129 vdd vdd) p12 w=4.8u l=0.13u
MN6170 (n6169 n6163 vss vss) n12 w=0.8u l=0.13u
MP6171 (n6169 n6163 vdd vdd) p12 w=2.4u l=0.13u
MN6174 (n6172 cg7 vss vss) n12 w=0.8u l=0.13u
MN6175 (n6172 n6169 vss vss) n12 w=0.8u l=0.13u
MP6176 (n6172 cg7 n6173 vdd) p12 w=4.8u l=0.13u
MP6177 (n6173 n6169 vdd vdd) p12 w=4.8u l=0.13u
MN6179 (n6178 n6172 vss vss) n12 w=0.8u l=0.13u
MP6180 (n6178 n6172 vdd vdd) p12 w=2.4u l=0.13u
MN6183 (n6181 measure n6182 vss) n12 w=1.6u l=0.13u
MN6184 (n6182 n6178 vss vss) n12 w=1.6u l=0.13u
MP6185 (n6181 measure vdd vdd) p12 w=2.4u l=0.13u
MP6186 (n6181 n6178 vdd vdd) p12 w=2.4u l=0.13u
MN6188 (n6187 n6181 vss vss) n12 w=0.8u l=0.13u
MP6189 (n6187 n6181 vdd vdd) p12 w=2.4u l=0.13u
MN6191 (n6190 n6187 vss vss) n12 w=0.8u l=0.13u
MP6192 (n6190 n6187 vdd vdd) p12 w=2.4u l=0.13u
MN6194 (n6193 n6190 vss vss) n12 w=0.8u l=0.13u
MP6195 (n6193 n6190 vdd vdd) p12 w=2.4u l=0.13u
MN6197 (n6196 n6193 vss vss) n12 w=0.8u l=0.13u
MP6198 (n6196 n6193 vdd vdd) p12 w=2.4u l=0.13u
MN6199 (decision n6196 vss vss) n12 w=0.8u l=0.13u
MP6200 (decision n6196 vdd vdd) p12 w=2.4u l=0.13u
MN6203 (n6201 n6129 n6202 vss) n12 w=1.6u l=0.13u
MN6204 (n6202 n6187 vss vss) n12 w=1.6u l=0.13u
MP6205 (n6201 n6129 vdd vdd) p12 w=2.4u l=0.13u
MP6206 (n6201 n6187 vdd vdd) p12 w=2.4u l=0.13u
MN6209 (n6207 n6190 n6208 vss) n12 w=1.6u l=0.13u
MN6210 (n6208 was_fast vss vss) n12 w=1.6u l=0.13u
MP6211 (n6207 n6190 vdd vdd) p12 w=2.4u l=0.13u
MP6212 (n6207 was_fast vdd vdd) p12 w=2.4u l=0.13u
MN6215 (n6213 n6201 n6214 vss) n12 w=1.6u l=0.13u
MN6216 (n6214 n6207 vss vss) n12 w=1.6u l=0.13u
MP6217 (n6213 n6201 vdd vdd) p12 w=2.4u l=0.13u
MP6218 (n6213 n6207 vdd vdd) p12 w=2.4u l=0.13u
MN6223 (n6213 clk_low108 storage6222 vss) n12 w=1.2u l=0.13u
MP6224 (n6213 clk_lowb109 storage6222 vdd) p12 w=3.6u l=0.13u
MN6225 (qm6219 clk_high110 storage6222 vss) n12 w=1.2u l=0.13u
MP6226 (qm6219 clk_highb111 storage6222 vdd) p12 w=3.6u l=0.13u
MN6227 (qmb6220 storage6222 vss vss) n12 w=0.5u l=0.13u
MP6228 (qmb6220 storage6222 vdd vdd) p12 w=1.5u l=0.13u
MN6229 (qm6219 qmb6220 vss vss) n12 w=0.5u l=0.13u
MP6230 (qm6219 qmb6220 vdd vdd) p12 w=1.5u l=0.13u
MN6231 (storage6222 rst vss vss) n12 w=2u l=0.13u
MN6233 (qm6219 clk_high110 storage6232 vss) n12 w=1.2u l=0.13u
MP6234 (qm6219 clk_highb111 storage6232 vdd) p12 w=3.6u l=0.13u
MN6235 (was_fast clk_low108 storage6232 vss) n12 w=1.2u l=0.13u
MP6236 (was_fast clk_lowb109 storage6232 vdd) p12 w=3.6u l=0.13u
MN6237 (qb6221 storage6232 vss vss) n12 w=0.5u l=0.13u
MP6238 (qb6221 storage6232 vdd vdd) p12 w=1.5u l=0.13u
MN6239 (was_fast qb6221 vss vss) n12 w=0.5u l=0.13u
MP6240 (was_fast qb6221 vdd vdd) p12 w=1.5u l=0.13u
MN6241 (storage6232 rst vss vss) n12 w=2u l=0.13u
MN6244 (n6242 n6120 n6243 vss) n12 w=1.6u l=0.13u
MN6245 (n6243 n6187 vss vss) n12 w=1.6u l=0.13u
MP6246 (n6242 n6120 vdd vdd) p12 w=2.4u l=0.13u
MP6247 (n6242 n6187 vdd vdd) p12 w=2.4u l=0.13u
MN6250 (n6248 n6190 n6249 vss) n12 w=1.6u l=0.13u
MN6251 (n6249 was_slow vss vss) n12 w=1.6u l=0.13u
MP6252 (n6248 n6190 vdd vdd) p12 w=2.4u l=0.13u
MP6253 (n6248 was_slow vdd vdd) p12 w=2.4u l=0.13u
MN6256 (n6254 n6242 n6255 vss) n12 w=1.6u l=0.13u
MN6257 (n6255 n6248 vss vss) n12 w=1.6u l=0.13u
MP6258 (n6254 n6242 vdd vdd) p12 w=2.4u l=0.13u
MP6259 (n6254 n6248 vdd vdd) p12 w=2.4u l=0.13u
MN6264 (n6254 clk_low108 storage6263 vss) n12 w=1.2u l=0.13u
MP6265 (n6254 clk_lowb109 storage6263 vdd) p12 w=3.6u l=0.13u
MN6266 (qm6260 clk_high110 storage6263 vss) n12 w=1.2u l=0.13u
MP6267 (qm6260 clk_highb111 storage6263 vdd) p12 w=3.6u l=0.13u
MN6268 (qmb6261 storage6263 vss vss) n12 w=0.5u l=0.13u
MP6269 (qmb6261 storage6263 vdd vdd) p12 w=1.5u l=0.13u
MN6270 (qm6260 qmb6261 vss vss) n12 w=0.5u l=0.13u
MP6271 (qm6260 qmb6261 vdd vdd) p12 w=1.5u l=0.13u
MN6272 (storage6263 rst vss vss) n12 w=2u l=0.13u
MN6274 (qm6260 clk_high110 storage6273 vss) n12 w=1.2u l=0.13u
MP6275 (qm6260 clk_highb111 storage6273 vdd) p12 w=3.6u l=0.13u
MN6276 (was_slow clk_low108 storage6273 vss) n12 w=1.2u l=0.13u
MP6277 (was_slow clk_lowb109 storage6273 vdd) p12 w=3.6u l=0.13u
MN6278 (qb6262 storage6273 vss vss) n12 w=0.5u l=0.13u
MP6279 (qb6262 storage6273 vdd vdd) p12 w=1.5u l=0.13u
MN6280 (was_slow qb6262 vss vss) n12 w=0.5u l=0.13u
MP6281 (was_slow qb6262 vdd vdd) p12 w=1.5u l=0.13u
MN6282 (storage6273 rst vss vss) n12 w=2u l=0.13u
MN6284 (n6283 n6169 vss vss) n12 w=0.8u l=0.13u
MP6285 (n6283 n6169 vdd vdd) p12 w=2.4u l=0.13u
MN6288 (n6286 cg7 n6287 vss) n12 w=1.6u l=0.13u
MN6289 (n6287 n6283 vss vss) n12 w=1.6u l=0.13u
MP6290 (n6286 cg7 vdd vdd) p12 w=2.4u l=0.13u
MP6291 (n6286 n6283 vdd vdd) p12 w=2.4u l=0.13u
MN6293 (n6292 n6286 vss vss) n12 w=0.8u l=0.13u
MP6294 (n6292 n6286 vdd vdd) p12 w=2.4u l=0.13u
MN6297 (n6295 n6187 n6296 vss) n12 w=1.6u l=0.13u
MN6298 (n6296 n6292 vss vss) n12 w=1.6u l=0.13u
MP6299 (n6295 n6187 vdd vdd) p12 w=2.4u l=0.13u
MP6300 (n6295 n6292 vdd vdd) p12 w=2.4u l=0.13u
MN6303 (n6301 n6190 n6302 vss) n12 w=1.6u l=0.13u
MN6304 (n6302 was_near vss vss) n12 w=1.6u l=0.13u
MP6305 (n6301 n6190 vdd vdd) p12 w=2.4u l=0.13u
MP6306 (n6301 was_near vdd vdd) p12 w=2.4u l=0.13u
MN6309 (n6307 n6295 n6308 vss) n12 w=1.6u l=0.13u
MN6310 (n6308 n6301 vss vss) n12 w=1.6u l=0.13u
MP6311 (n6307 n6295 vdd vdd) p12 w=2.4u l=0.13u
MP6312 (n6307 n6301 vdd vdd) p12 w=2.4u l=0.13u
MN6317 (n6307 clk_low108 storage6316 vss) n12 w=1.2u l=0.13u
MP6318 (n6307 clk_lowb109 storage6316 vdd) p12 w=3.6u l=0.13u
MN6319 (qm6313 clk_high110 storage6316 vss) n12 w=1.2u l=0.13u
MP6320 (qm6313 clk_highb111 storage6316 vdd) p12 w=3.6u l=0.13u
MN6321 (qmb6314 storage6316 vss vss) n12 w=0.5u l=0.13u
MP6322 (qmb6314 storage6316 vdd vdd) p12 w=1.5u l=0.13u
MN6323 (qm6313 qmb6314 vss vss) n12 w=0.5u l=0.13u
MP6324 (qm6313 qmb6314 vdd vdd) p12 w=1.5u l=0.13u
MN6325 (storage6316 rst vss vss) n12 w=2u l=0.13u
MN6327 (qm6313 clk_high110 storage6326 vss) n12 w=1.2u l=0.13u
MP6328 (qm6313 clk_highb111 storage6326 vdd) p12 w=3.6u l=0.13u
MN6329 (was_near clk_low108 storage6326 vss) n12 w=1.2u l=0.13u
MP6330 (was_near clk_lowb109 storage6326 vdd) p12 w=3.6u l=0.13u
MN6331 (qb6315 storage6326 vss vss) n12 w=0.5u l=0.13u
MP6332 (qb6315 storage6326 vdd vdd) p12 w=1.5u l=0.13u
MN6333 (was_near qb6315 vss vss) n12 w=0.5u l=0.13u
MP6334 (was_near qb6315 vdd vdd) p12 w=1.5u l=0.13u
MN6335 (storage6326 rst vss vss) n12 w=2u l=0.13u
MN6338 (n6336 cl0 n6337 vss) n12 w=1.6u l=0.13u
MN6339 (n6337 n6187 vss vss) n12 w=1.6u l=0.13u
MP6340 (n6336 cl0 vdd vdd) p12 w=2.4u l=0.13u
MP6341 (n6336 n6187 vdd vdd) p12 w=2.4u l=0.13u
MN6344 (n6342 dl0 n6343 vss) n12 w=1.6u l=0.13u
MN6345 (n6343 n6190 vss vss) n12 w=1.6u l=0.13u
MP6346 (n6342 dl0 vdd vdd) p12 w=2.4u l=0.13u
MP6347 (n6342 n6190 vdd vdd) p12 w=2.4u l=0.13u
MN6350 (n6348 n6336 n6349 vss) n12 w=1.6u l=0.13u
MN6351 (n6349 n6342 vss vss) n12 w=1.6u l=0.13u
MP6352 (n6348 n6336 vdd vdd) p12 w=2.4u l=0.13u
MP6353 (n6348 n6342 vdd vdd) p12 w=2.4u l=0.13u
MN6358 (n6348 clk_low108 storage6357 vss) n12 w=1.2u l=0.13u
MP6359 (n6348 clk_lowb109 storage6357 vdd) p12 w=3.6u l=0.13u
MN6360 (qm6354 clk_high110 storage6357 vss) n12 w=1.2u l=0.13u
MP6361 (qm6354 clk_highb111 storage6357 vdd) p12 w=3.6u l=0.13u
MN6362 (qmb6355 storage6357 vss vss) n12 w=0.5u l=0.13u
MP6363 (qmb6355 storage6357 vdd vdd) p12 w=1.5u l=0.13u
MN6364 (qm6354 qmb6355 vss vss) n12 w=0.5u l=0.13u
MP6365 (qm6354 qmb6355 vdd vdd) p12 w=1.5u l=0.13u
MN6366 (storage6357 rst vss vss) n12 w=2u l=0.13u
MN6368 (qm6354 clk_high110 storage6367 vss) n12 w=1.2u l=0.13u
MP6369 (qm6354 clk_highb111 storage6367 vdd) p12 w=3.6u l=0.13u
MN6370 (dl0 clk_low108 storage6367 vss) n12 w=1.2u l=0.13u
MP6371 (dl0 clk_lowb109 storage6367 vdd) p12 w=3.6u l=0.13u
MN6372 (qb6356 storage6367 vss vss) n12 w=0.5u l=0.13u
MP6373 (qb6356 storage6367 vdd vdd) p12 w=1.5u l=0.13u
MN6374 (dl0 qb6356 vss vss) n12 w=0.5u l=0.13u
MP6375 (dl0 qb6356 vdd vdd) p12 w=1.5u l=0.13u
MN6376 (storage6367 rst vss vss) n12 w=2u l=0.13u
MN6379 (n6377 cl1 n6378 vss) n12 w=1.6u l=0.13u
MN6380 (n6378 n6187 vss vss) n12 w=1.6u l=0.13u
MP6381 (n6377 cl1 vdd vdd) p12 w=2.4u l=0.13u
MP6382 (n6377 n6187 vdd vdd) p12 w=2.4u l=0.13u
MN6385 (n6383 dl1 n6384 vss) n12 w=1.6u l=0.13u
MN6386 (n6384 n6190 vss vss) n12 w=1.6u l=0.13u
MP6387 (n6383 dl1 vdd vdd) p12 w=2.4u l=0.13u
MP6388 (n6383 n6190 vdd vdd) p12 w=2.4u l=0.13u
MN6391 (n6389 n6377 n6390 vss) n12 w=1.6u l=0.13u
MN6392 (n6390 n6383 vss vss) n12 w=1.6u l=0.13u
MP6393 (n6389 n6377 vdd vdd) p12 w=2.4u l=0.13u
MP6394 (n6389 n6383 vdd vdd) p12 w=2.4u l=0.13u
MN6399 (n6389 clk_low108 storage6398 vss) n12 w=1.2u l=0.13u
MP6400 (n6389 clk_lowb109 storage6398 vdd) p12 w=3.6u l=0.13u
MN6401 (qm6395 clk_high110 storage6398 vss) n12 w=1.2u l=0.13u
MP6402 (qm6395 clk_highb111 storage6398 vdd) p12 w=3.6u l=0.13u
MN6403 (qmb6396 storage6398 vss vss) n12 w=0.5u l=0.13u
MP6404 (qmb6396 storage6398 vdd vdd) p12 w=1.5u l=0.13u
MN6405 (qm6395 qmb6396 vss vss) n12 w=0.5u l=0.13u
MP6406 (qm6395 qmb6396 vdd vdd) p12 w=1.5u l=0.13u
MN6407 (storage6398 rst vss vss) n12 w=2u l=0.13u
MN6409 (qm6395 clk_high110 storage6408 vss) n12 w=1.2u l=0.13u
MP6410 (qm6395 clk_highb111 storage6408 vdd) p12 w=3.6u l=0.13u
MN6411 (dl1 clk_low108 storage6408 vss) n12 w=1.2u l=0.13u
MP6412 (dl1 clk_lowb109 storage6408 vdd) p12 w=3.6u l=0.13u
MN6413 (qb6397 storage6408 vss vss) n12 w=0.5u l=0.13u
MP6414 (qb6397 storage6408 vdd vdd) p12 w=1.5u l=0.13u
MN6415 (dl1 qb6397 vss vss) n12 w=0.5u l=0.13u
MP6416 (dl1 qb6397 vdd vdd) p12 w=1.5u l=0.13u
MN6417 (storage6408 rst vss vss) n12 w=2u l=0.13u
MN6420 (n6418 cl2 n6419 vss) n12 w=1.6u l=0.13u
MN6421 (n6419 n6187 vss vss) n12 w=1.6u l=0.13u
MP6422 (n6418 cl2 vdd vdd) p12 w=2.4u l=0.13u
MP6423 (n6418 n6187 vdd vdd) p12 w=2.4u l=0.13u
MN6426 (n6424 dl2 n6425 vss) n12 w=1.6u l=0.13u
MN6427 (n6425 n6190 vss vss) n12 w=1.6u l=0.13u
MP6428 (n6424 dl2 vdd vdd) p12 w=2.4u l=0.13u
MP6429 (n6424 n6190 vdd vdd) p12 w=2.4u l=0.13u
MN6432 (n6430 n6418 n6431 vss) n12 w=1.6u l=0.13u
MN6433 (n6431 n6424 vss vss) n12 w=1.6u l=0.13u
MP6434 (n6430 n6418 vdd vdd) p12 w=2.4u l=0.13u
MP6435 (n6430 n6424 vdd vdd) p12 w=2.4u l=0.13u
MN6440 (n6430 clk_low108 storage6439 vss) n12 w=1.2u l=0.13u
MP6441 (n6430 clk_lowb109 storage6439 vdd) p12 w=3.6u l=0.13u
MN6442 (qm6436 clk_high110 storage6439 vss) n12 w=1.2u l=0.13u
MP6443 (qm6436 clk_highb111 storage6439 vdd) p12 w=3.6u l=0.13u
MN6444 (qmb6437 storage6439 vss vss) n12 w=0.5u l=0.13u
MP6445 (qmb6437 storage6439 vdd vdd) p12 w=1.5u l=0.13u
MN6446 (qm6436 qmb6437 vss vss) n12 w=0.5u l=0.13u
MP6447 (qm6436 qmb6437 vdd vdd) p12 w=1.5u l=0.13u
MN6448 (storage6439 rst vss vss) n12 w=2u l=0.13u
MN6450 (qm6436 clk_high110 storage6449 vss) n12 w=1.2u l=0.13u
MP6451 (qm6436 clk_highb111 storage6449 vdd) p12 w=3.6u l=0.13u
MN6452 (dl2 clk_low108 storage6449 vss) n12 w=1.2u l=0.13u
MP6453 (dl2 clk_lowb109 storage6449 vdd) p12 w=3.6u l=0.13u
MN6454 (qb6438 storage6449 vss vss) n12 w=0.5u l=0.13u
MP6455 (qb6438 storage6449 vdd vdd) p12 w=1.5u l=0.13u
MN6456 (dl2 qb6438 vss vss) n12 w=0.5u l=0.13u
MP6457 (dl2 qb6438 vdd vdd) p12 w=1.5u l=0.13u
MN6458 (storage6449 rst vss vss) n12 w=2u l=0.13u
MN6461 (n6459 cl3 n6460 vss) n12 w=1.6u l=0.13u
MN6462 (n6460 n6187 vss vss) n12 w=1.6u l=0.13u
MP6463 (n6459 cl3 vdd vdd) p12 w=2.4u l=0.13u
MP6464 (n6459 n6187 vdd vdd) p12 w=2.4u l=0.13u
MN6467 (n6465 dl3 n6466 vss) n12 w=1.6u l=0.13u
MN6468 (n6466 n6190 vss vss) n12 w=1.6u l=0.13u
MP6469 (n6465 dl3 vdd vdd) p12 w=2.4u l=0.13u
MP6470 (n6465 n6190 vdd vdd) p12 w=2.4u l=0.13u
MN6473 (n6471 n6459 n6472 vss) n12 w=1.6u l=0.13u
MN6474 (n6472 n6465 vss vss) n12 w=1.6u l=0.13u
MP6475 (n6471 n6459 vdd vdd) p12 w=2.4u l=0.13u
MP6476 (n6471 n6465 vdd vdd) p12 w=2.4u l=0.13u
MN6481 (n6471 clk_low108 storage6480 vss) n12 w=1.2u l=0.13u
MP6482 (n6471 clk_lowb109 storage6480 vdd) p12 w=3.6u l=0.13u
MN6483 (qm6477 clk_high110 storage6480 vss) n12 w=1.2u l=0.13u
MP6484 (qm6477 clk_highb111 storage6480 vdd) p12 w=3.6u l=0.13u
MN6485 (qmb6478 storage6480 vss vss) n12 w=0.5u l=0.13u
MP6486 (qmb6478 storage6480 vdd vdd) p12 w=1.5u l=0.13u
MN6487 (qm6477 qmb6478 vss vss) n12 w=0.5u l=0.13u
MP6488 (qm6477 qmb6478 vdd vdd) p12 w=1.5u l=0.13u
MN6489 (storage6480 rst vss vss) n12 w=2u l=0.13u
MN6491 (qm6477 clk_high110 storage6490 vss) n12 w=1.2u l=0.13u
MP6492 (qm6477 clk_highb111 storage6490 vdd) p12 w=3.6u l=0.13u
MN6493 (dl3 clk_low108 storage6490 vss) n12 w=1.2u l=0.13u
MP6494 (dl3 clk_lowb109 storage6490 vdd) p12 w=3.6u l=0.13u
MN6495 (qb6479 storage6490 vss vss) n12 w=0.5u l=0.13u
MP6496 (qb6479 storage6490 vdd vdd) p12 w=1.5u l=0.13u
MN6497 (dl3 qb6479 vss vss) n12 w=0.5u l=0.13u
MP6498 (dl3 qb6479 vdd vdd) p12 w=1.5u l=0.13u
MN6499 (storage6490 rst vss vss) n12 w=2u l=0.13u
MN6502 (n6500 cl4 n6501 vss) n12 w=1.6u l=0.13u
MN6503 (n6501 n6187 vss vss) n12 w=1.6u l=0.13u
MP6504 (n6500 cl4 vdd vdd) p12 w=2.4u l=0.13u
MP6505 (n6500 n6187 vdd vdd) p12 w=2.4u l=0.13u
MN6508 (n6506 dl4 n6507 vss) n12 w=1.6u l=0.13u
MN6509 (n6507 n6190 vss vss) n12 w=1.6u l=0.13u
MP6510 (n6506 dl4 vdd vdd) p12 w=2.4u l=0.13u
MP6511 (n6506 n6190 vdd vdd) p12 w=2.4u l=0.13u
MN6514 (n6512 n6500 n6513 vss) n12 w=1.6u l=0.13u
MN6515 (n6513 n6506 vss vss) n12 w=1.6u l=0.13u
MP6516 (n6512 n6500 vdd vdd) p12 w=2.4u l=0.13u
MP6517 (n6512 n6506 vdd vdd) p12 w=2.4u l=0.13u
MN6522 (n6512 clk_low108 storage6521 vss) n12 w=1.2u l=0.13u
MP6523 (n6512 clk_lowb109 storage6521 vdd) p12 w=3.6u l=0.13u
MN6524 (qm6518 clk_high110 storage6521 vss) n12 w=1.2u l=0.13u
MP6525 (qm6518 clk_highb111 storage6521 vdd) p12 w=3.6u l=0.13u
MN6526 (qmb6519 storage6521 vss vss) n12 w=0.5u l=0.13u
MP6527 (qmb6519 storage6521 vdd vdd) p12 w=1.5u l=0.13u
MN6528 (qm6518 qmb6519 vss vss) n12 w=0.5u l=0.13u
MP6529 (qm6518 qmb6519 vdd vdd) p12 w=1.5u l=0.13u
MN6530 (storage6521 rst vss vss) n12 w=2u l=0.13u
MN6532 (qm6518 clk_high110 storage6531 vss) n12 w=1.2u l=0.13u
MP6533 (qm6518 clk_highb111 storage6531 vdd) p12 w=3.6u l=0.13u
MN6534 (dl4 clk_low108 storage6531 vss) n12 w=1.2u l=0.13u
MP6535 (dl4 clk_lowb109 storage6531 vdd) p12 w=3.6u l=0.13u
MN6536 (qb6520 storage6531 vss vss) n12 w=0.5u l=0.13u
MP6537 (qb6520 storage6531 vdd vdd) p12 w=1.5u l=0.13u
MN6538 (dl4 qb6520 vss vss) n12 w=0.5u l=0.13u
MP6539 (dl4 qb6520 vdd vdd) p12 w=1.5u l=0.13u
MN6540 (storage6531 rst vss vss) n12 w=2u l=0.13u
MN6543 (n6541 cl5 n6542 vss) n12 w=1.6u l=0.13u
MN6544 (n6542 n6187 vss vss) n12 w=1.6u l=0.13u
MP6545 (n6541 cl5 vdd vdd) p12 w=2.4u l=0.13u
MP6546 (n6541 n6187 vdd vdd) p12 w=2.4u l=0.13u
MN6549 (n6547 dl5 n6548 vss) n12 w=1.6u l=0.13u
MN6550 (n6548 n6190 vss vss) n12 w=1.6u l=0.13u
MP6551 (n6547 dl5 vdd vdd) p12 w=2.4u l=0.13u
MP6552 (n6547 n6190 vdd vdd) p12 w=2.4u l=0.13u
MN6555 (n6553 n6541 n6554 vss) n12 w=1.6u l=0.13u
MN6556 (n6554 n6547 vss vss) n12 w=1.6u l=0.13u
MP6557 (n6553 n6541 vdd vdd) p12 w=2.4u l=0.13u
MP6558 (n6553 n6547 vdd vdd) p12 w=2.4u l=0.13u
MN6563 (n6553 clk_low108 storage6562 vss) n12 w=1.2u l=0.13u
MP6564 (n6553 clk_lowb109 storage6562 vdd) p12 w=3.6u l=0.13u
MN6565 (qm6559 clk_high110 storage6562 vss) n12 w=1.2u l=0.13u
MP6566 (qm6559 clk_highb111 storage6562 vdd) p12 w=3.6u l=0.13u
MN6567 (qmb6560 storage6562 vss vss) n12 w=0.5u l=0.13u
MP6568 (qmb6560 storage6562 vdd vdd) p12 w=1.5u l=0.13u
MN6569 (qm6559 qmb6560 vss vss) n12 w=0.5u l=0.13u
MP6570 (qm6559 qmb6560 vdd vdd) p12 w=1.5u l=0.13u
MN6571 (storage6562 rst vss vss) n12 w=2u l=0.13u
MN6573 (qm6559 clk_high110 storage6572 vss) n12 w=1.2u l=0.13u
MP6574 (qm6559 clk_highb111 storage6572 vdd) p12 w=3.6u l=0.13u
MN6575 (dl5 clk_low108 storage6572 vss) n12 w=1.2u l=0.13u
MP6576 (dl5 clk_lowb109 storage6572 vdd) p12 w=3.6u l=0.13u
MN6577 (qb6561 storage6572 vss vss) n12 w=0.5u l=0.13u
MP6578 (qb6561 storage6572 vdd vdd) p12 w=1.5u l=0.13u
MN6579 (dl5 qb6561 vss vss) n12 w=0.5u l=0.13u
MP6580 (dl5 qb6561 vdd vdd) p12 w=1.5u l=0.13u
MN6581 (storage6572 rst vss vss) n12 w=2u l=0.13u
MN6584 (n6582 cl6 n6583 vss) n12 w=1.6u l=0.13u
MN6585 (n6583 n6187 vss vss) n12 w=1.6u l=0.13u
MP6586 (n6582 cl6 vdd vdd) p12 w=2.4u l=0.13u
MP6587 (n6582 n6187 vdd vdd) p12 w=2.4u l=0.13u
MN6590 (n6588 dl6 n6589 vss) n12 w=1.6u l=0.13u
MN6591 (n6589 n6190 vss vss) n12 w=1.6u l=0.13u
MP6592 (n6588 dl6 vdd vdd) p12 w=2.4u l=0.13u
MP6593 (n6588 n6190 vdd vdd) p12 w=2.4u l=0.13u
MN6596 (n6594 n6582 n6595 vss) n12 w=1.6u l=0.13u
MN6597 (n6595 n6588 vss vss) n12 w=1.6u l=0.13u
MP6598 (n6594 n6582 vdd vdd) p12 w=2.4u l=0.13u
MP6599 (n6594 n6588 vdd vdd) p12 w=2.4u l=0.13u
MN6604 (n6594 clk_low108 storage6603 vss) n12 w=1.2u l=0.13u
MP6605 (n6594 clk_lowb109 storage6603 vdd) p12 w=3.6u l=0.13u
MN6606 (qm6600 clk_high110 storage6603 vss) n12 w=1.2u l=0.13u
MP6607 (qm6600 clk_highb111 storage6603 vdd) p12 w=3.6u l=0.13u
MN6608 (qmb6601 storage6603 vss vss) n12 w=0.5u l=0.13u
MP6609 (qmb6601 storage6603 vdd vdd) p12 w=1.5u l=0.13u
MN6610 (qm6600 qmb6601 vss vss) n12 w=0.5u l=0.13u
MP6611 (qm6600 qmb6601 vdd vdd) p12 w=1.5u l=0.13u
MN6612 (storage6603 rst vss vss) n12 w=2u l=0.13u
MN6614 (qm6600 clk_high110 storage6613 vss) n12 w=1.2u l=0.13u
MP6615 (qm6600 clk_highb111 storage6613 vdd) p12 w=3.6u l=0.13u
MN6616 (dl6 clk_low108 storage6613 vss) n12 w=1.2u l=0.13u
MP6617 (dl6 clk_lowb109 storage6613 vdd) p12 w=3.6u l=0.13u
MN6618 (qb6602 storage6613 vss vss) n12 w=0.5u l=0.13u
MP6619 (qb6602 storage6613 vdd vdd) p12 w=1.5u l=0.13u
MN6620 (dl6 qb6602 vss vss) n12 w=0.5u l=0.13u
MP6621 (dl6 qb6602 vdd vdd) p12 w=1.5u l=0.13u
MN6622 (storage6613 rst vss vss) n12 w=2u l=0.13u
MN6625 (n6623 cl7 n6624 vss) n12 w=1.6u l=0.13u
MN6626 (n6624 n6187 vss vss) n12 w=1.6u l=0.13u
MP6627 (n6623 cl7 vdd vdd) p12 w=2.4u l=0.13u
MP6628 (n6623 n6187 vdd vdd) p12 w=2.4u l=0.13u
MN6631 (n6629 dl7 n6630 vss) n12 w=1.6u l=0.13u
MN6632 (n6630 n6190 vss vss) n12 w=1.6u l=0.13u
MP6633 (n6629 dl7 vdd vdd) p12 w=2.4u l=0.13u
MP6634 (n6629 n6190 vdd vdd) p12 w=2.4u l=0.13u
MN6637 (n6635 n6623 n6636 vss) n12 w=1.6u l=0.13u
MN6638 (n6636 n6629 vss vss) n12 w=1.6u l=0.13u
MP6639 (n6635 n6623 vdd vdd) p12 w=2.4u l=0.13u
MP6640 (n6635 n6629 vdd vdd) p12 w=2.4u l=0.13u
MN6645 (n6635 clk_low108 storage6644 vss) n12 w=1.2u l=0.13u
MP6646 (n6635 clk_lowb109 storage6644 vdd) p12 w=3.6u l=0.13u
MN6647 (qm6641 clk_high110 storage6644 vss) n12 w=1.2u l=0.13u
MP6648 (qm6641 clk_highb111 storage6644 vdd) p12 w=3.6u l=0.13u
MN6649 (qmb6642 storage6644 vss vss) n12 w=0.5u l=0.13u
MP6650 (qmb6642 storage6644 vdd vdd) p12 w=1.5u l=0.13u
MN6651 (qm6641 qmb6642 vss vss) n12 w=0.5u l=0.13u
MP6652 (qm6641 qmb6642 vdd vdd) p12 w=1.5u l=0.13u
MN6653 (storage6644 rst vss vss) n12 w=2u l=0.13u
MN6655 (qm6641 clk_high110 storage6654 vss) n12 w=1.2u l=0.13u
MP6656 (qm6641 clk_highb111 storage6654 vdd) p12 w=3.6u l=0.13u
MN6657 (dl7 clk_low108 storage6654 vss) n12 w=1.2u l=0.13u
MP6658 (dl7 clk_lowb109 storage6654 vdd) p12 w=3.6u l=0.13u
MN6659 (qb6643 storage6654 vss vss) n12 w=0.5u l=0.13u
MP6660 (qb6643 storage6654 vdd vdd) p12 w=1.5u l=0.13u
MN6661 (dl7 qb6643 vss vss) n12 w=0.5u l=0.13u
MP6662 (dl7 qb6643 vdd vdd) p12 w=1.5u l=0.13u
MN6663 (storage6654 rst vss vss) n12 w=2u l=0.13u
MN6666 (n6664 cg0 n6665 vss) n12 w=1.6u l=0.13u
MN6667 (n6665 n6187 vss vss) n12 w=1.6u l=0.13u
MP6668 (n6664 cg0 vdd vdd) p12 w=2.4u l=0.13u
MP6669 (n6664 n6187 vdd vdd) p12 w=2.4u l=0.13u
MN6672 (n6670 dg0 n6671 vss) n12 w=1.6u l=0.13u
MN6673 (n6671 n6190 vss vss) n12 w=1.6u l=0.13u
MP6674 (n6670 dg0 vdd vdd) p12 w=2.4u l=0.13u
MP6675 (n6670 n6190 vdd vdd) p12 w=2.4u l=0.13u
MN6678 (n6676 n6664 n6677 vss) n12 w=1.6u l=0.13u
MN6679 (n6677 n6670 vss vss) n12 w=1.6u l=0.13u
MP6680 (n6676 n6664 vdd vdd) p12 w=2.4u l=0.13u
MP6681 (n6676 n6670 vdd vdd) p12 w=2.4u l=0.13u
MN6686 (n6676 clk_low108 storage6685 vss) n12 w=1.2u l=0.13u
MP6687 (n6676 clk_lowb109 storage6685 vdd) p12 w=3.6u l=0.13u
MN6688 (qm6682 clk_high110 storage6685 vss) n12 w=1.2u l=0.13u
MP6689 (qm6682 clk_highb111 storage6685 vdd) p12 w=3.6u l=0.13u
MN6690 (qmb6683 storage6685 vss vss) n12 w=0.5u l=0.13u
MP6691 (qmb6683 storage6685 vdd vdd) p12 w=1.5u l=0.13u
MN6692 (qm6682 qmb6683 vss vss) n12 w=0.5u l=0.13u
MP6693 (qm6682 qmb6683 vdd vdd) p12 w=1.5u l=0.13u
MN6694 (storage6685 rst vss vss) n12 w=2u l=0.13u
MN6696 (qm6682 clk_high110 storage6695 vss) n12 w=1.2u l=0.13u
MP6697 (qm6682 clk_highb111 storage6695 vdd) p12 w=3.6u l=0.13u
MN6698 (dg0 clk_low108 storage6695 vss) n12 w=1.2u l=0.13u
MP6699 (dg0 clk_lowb109 storage6695 vdd) p12 w=3.6u l=0.13u
MN6700 (qb6684 storage6695 vss vss) n12 w=0.5u l=0.13u
MP6701 (qb6684 storage6695 vdd vdd) p12 w=1.5u l=0.13u
MN6702 (dg0 qb6684 vss vss) n12 w=0.5u l=0.13u
MP6703 (dg0 qb6684 vdd vdd) p12 w=1.5u l=0.13u
MN6704 (storage6695 rst vss vss) n12 w=2u l=0.13u
MN6707 (n6705 cg1 n6706 vss) n12 w=1.6u l=0.13u
MN6708 (n6706 n6187 vss vss) n12 w=1.6u l=0.13u
MP6709 (n6705 cg1 vdd vdd) p12 w=2.4u l=0.13u
MP6710 (n6705 n6187 vdd vdd) p12 w=2.4u l=0.13u
MN6713 (n6711 dg1 n6712 vss) n12 w=1.6u l=0.13u
MN6714 (n6712 n6190 vss vss) n12 w=1.6u l=0.13u
MP6715 (n6711 dg1 vdd vdd) p12 w=2.4u l=0.13u
MP6716 (n6711 n6190 vdd vdd) p12 w=2.4u l=0.13u
MN6719 (n6717 n6705 n6718 vss) n12 w=1.6u l=0.13u
MN6720 (n6718 n6711 vss vss) n12 w=1.6u l=0.13u
MP6721 (n6717 n6705 vdd vdd) p12 w=2.4u l=0.13u
MP6722 (n6717 n6711 vdd vdd) p12 w=2.4u l=0.13u
MN6727 (n6717 clk_low108 storage6726 vss) n12 w=1.2u l=0.13u
MP6728 (n6717 clk_lowb109 storage6726 vdd) p12 w=3.6u l=0.13u
MN6729 (qm6723 clk_high110 storage6726 vss) n12 w=1.2u l=0.13u
MP6730 (qm6723 clk_highb111 storage6726 vdd) p12 w=3.6u l=0.13u
MN6731 (qmb6724 storage6726 vss vss) n12 w=0.5u l=0.13u
MP6732 (qmb6724 storage6726 vdd vdd) p12 w=1.5u l=0.13u
MN6733 (qm6723 qmb6724 vss vss) n12 w=0.5u l=0.13u
MP6734 (qm6723 qmb6724 vdd vdd) p12 w=1.5u l=0.13u
MN6735 (storage6726 rst vss vss) n12 w=2u l=0.13u
MN6737 (qm6723 clk_high110 storage6736 vss) n12 w=1.2u l=0.13u
MP6738 (qm6723 clk_highb111 storage6736 vdd) p12 w=3.6u l=0.13u
MN6739 (dg1 clk_low108 storage6736 vss) n12 w=1.2u l=0.13u
MP6740 (dg1 clk_lowb109 storage6736 vdd) p12 w=3.6u l=0.13u
MN6741 (qb6725 storage6736 vss vss) n12 w=0.5u l=0.13u
MP6742 (qb6725 storage6736 vdd vdd) p12 w=1.5u l=0.13u
MN6743 (dg1 qb6725 vss vss) n12 w=0.5u l=0.13u
MP6744 (dg1 qb6725 vdd vdd) p12 w=1.5u l=0.13u
MN6745 (storage6736 rst vss vss) n12 w=2u l=0.13u
MN6748 (n6746 cg2 n6747 vss) n12 w=1.6u l=0.13u
MN6749 (n6747 n6187 vss vss) n12 w=1.6u l=0.13u
MP6750 (n6746 cg2 vdd vdd) p12 w=2.4u l=0.13u
MP6751 (n6746 n6187 vdd vdd) p12 w=2.4u l=0.13u
MN6754 (n6752 dg2 n6753 vss) n12 w=1.6u l=0.13u
MN6755 (n6753 n6190 vss vss) n12 w=1.6u l=0.13u
MP6756 (n6752 dg2 vdd vdd) p12 w=2.4u l=0.13u
MP6757 (n6752 n6190 vdd vdd) p12 w=2.4u l=0.13u
MN6760 (n6758 n6746 n6759 vss) n12 w=1.6u l=0.13u
MN6761 (n6759 n6752 vss vss) n12 w=1.6u l=0.13u
MP6762 (n6758 n6746 vdd vdd) p12 w=2.4u l=0.13u
MP6763 (n6758 n6752 vdd vdd) p12 w=2.4u l=0.13u
MN6768 (n6758 clk_low108 storage6767 vss) n12 w=1.2u l=0.13u
MP6769 (n6758 clk_lowb109 storage6767 vdd) p12 w=3.6u l=0.13u
MN6770 (qm6764 clk_high110 storage6767 vss) n12 w=1.2u l=0.13u
MP6771 (qm6764 clk_highb111 storage6767 vdd) p12 w=3.6u l=0.13u
MN6772 (qmb6765 storage6767 vss vss) n12 w=0.5u l=0.13u
MP6773 (qmb6765 storage6767 vdd vdd) p12 w=1.5u l=0.13u
MN6774 (qm6764 qmb6765 vss vss) n12 w=0.5u l=0.13u
MP6775 (qm6764 qmb6765 vdd vdd) p12 w=1.5u l=0.13u
MN6776 (storage6767 rst vss vss) n12 w=2u l=0.13u
MN6778 (qm6764 clk_high110 storage6777 vss) n12 w=1.2u l=0.13u
MP6779 (qm6764 clk_highb111 storage6777 vdd) p12 w=3.6u l=0.13u
MN6780 (dg2 clk_low108 storage6777 vss) n12 w=1.2u l=0.13u
MP6781 (dg2 clk_lowb109 storage6777 vdd) p12 w=3.6u l=0.13u
MN6782 (qb6766 storage6777 vss vss) n12 w=0.5u l=0.13u
MP6783 (qb6766 storage6777 vdd vdd) p12 w=1.5u l=0.13u
MN6784 (dg2 qb6766 vss vss) n12 w=0.5u l=0.13u
MP6785 (dg2 qb6766 vdd vdd) p12 w=1.5u l=0.13u
MN6786 (storage6777 rst vss vss) n12 w=2u l=0.13u
MN6789 (n6787 cg3 n6788 vss) n12 w=1.6u l=0.13u
MN6790 (n6788 n6187 vss vss) n12 w=1.6u l=0.13u
MP6791 (n6787 cg3 vdd vdd) p12 w=2.4u l=0.13u
MP6792 (n6787 n6187 vdd vdd) p12 w=2.4u l=0.13u
MN6795 (n6793 dg3 n6794 vss) n12 w=1.6u l=0.13u
MN6796 (n6794 n6190 vss vss) n12 w=1.6u l=0.13u
MP6797 (n6793 dg3 vdd vdd) p12 w=2.4u l=0.13u
MP6798 (n6793 n6190 vdd vdd) p12 w=2.4u l=0.13u
MN6801 (n6799 n6787 n6800 vss) n12 w=1.6u l=0.13u
MN6802 (n6800 n6793 vss vss) n12 w=1.6u l=0.13u
MP6803 (n6799 n6787 vdd vdd) p12 w=2.4u l=0.13u
MP6804 (n6799 n6793 vdd vdd) p12 w=2.4u l=0.13u
MN6809 (n6799 clk_low108 storage6808 vss) n12 w=1.2u l=0.13u
MP6810 (n6799 clk_lowb109 storage6808 vdd) p12 w=3.6u l=0.13u
MN6811 (qm6805 clk_high110 storage6808 vss) n12 w=1.2u l=0.13u
MP6812 (qm6805 clk_highb111 storage6808 vdd) p12 w=3.6u l=0.13u
MN6813 (qmb6806 storage6808 vss vss) n12 w=0.5u l=0.13u
MP6814 (qmb6806 storage6808 vdd vdd) p12 w=1.5u l=0.13u
MN6815 (qm6805 qmb6806 vss vss) n12 w=0.5u l=0.13u
MP6816 (qm6805 qmb6806 vdd vdd) p12 w=1.5u l=0.13u
MN6817 (storage6808 rst vss vss) n12 w=2u l=0.13u
MN6819 (qm6805 clk_high110 storage6818 vss) n12 w=1.2u l=0.13u
MP6820 (qm6805 clk_highb111 storage6818 vdd) p12 w=3.6u l=0.13u
MN6821 (dg3 clk_low108 storage6818 vss) n12 w=1.2u l=0.13u
MP6822 (dg3 clk_lowb109 storage6818 vdd) p12 w=3.6u l=0.13u
MN6823 (qb6807 storage6818 vss vss) n12 w=0.5u l=0.13u
MP6824 (qb6807 storage6818 vdd vdd) p12 w=1.5u l=0.13u
MN6825 (dg3 qb6807 vss vss) n12 w=0.5u l=0.13u
MP6826 (dg3 qb6807 vdd vdd) p12 w=1.5u l=0.13u
MN6827 (storage6818 rst vss vss) n12 w=2u l=0.13u
MN6830 (n6828 cg4 n6829 vss) n12 w=1.6u l=0.13u
MN6831 (n6829 n6187 vss vss) n12 w=1.6u l=0.13u
MP6832 (n6828 cg4 vdd vdd) p12 w=2.4u l=0.13u
MP6833 (n6828 n6187 vdd vdd) p12 w=2.4u l=0.13u
MN6836 (n6834 dg4 n6835 vss) n12 w=1.6u l=0.13u
MN6837 (n6835 n6190 vss vss) n12 w=1.6u l=0.13u
MP6838 (n6834 dg4 vdd vdd) p12 w=2.4u l=0.13u
MP6839 (n6834 n6190 vdd vdd) p12 w=2.4u l=0.13u
MN6842 (n6840 n6828 n6841 vss) n12 w=1.6u l=0.13u
MN6843 (n6841 n6834 vss vss) n12 w=1.6u l=0.13u
MP6844 (n6840 n6828 vdd vdd) p12 w=2.4u l=0.13u
MP6845 (n6840 n6834 vdd vdd) p12 w=2.4u l=0.13u
MN6850 (n6840 clk_low108 storage6849 vss) n12 w=1.2u l=0.13u
MP6851 (n6840 clk_lowb109 storage6849 vdd) p12 w=3.6u l=0.13u
MN6852 (qm6846 clk_high110 storage6849 vss) n12 w=1.2u l=0.13u
MP6853 (qm6846 clk_highb111 storage6849 vdd) p12 w=3.6u l=0.13u
MN6854 (qmb6847 storage6849 vss vss) n12 w=0.5u l=0.13u
MP6855 (qmb6847 storage6849 vdd vdd) p12 w=1.5u l=0.13u
MN6856 (qm6846 qmb6847 vss vss) n12 w=0.5u l=0.13u
MP6857 (qm6846 qmb6847 vdd vdd) p12 w=1.5u l=0.13u
MN6858 (storage6849 rst vss vss) n12 w=2u l=0.13u
MN6860 (qm6846 clk_high110 storage6859 vss) n12 w=1.2u l=0.13u
MP6861 (qm6846 clk_highb111 storage6859 vdd) p12 w=3.6u l=0.13u
MN6862 (dg4 clk_low108 storage6859 vss) n12 w=1.2u l=0.13u
MP6863 (dg4 clk_lowb109 storage6859 vdd) p12 w=3.6u l=0.13u
MN6864 (qb6848 storage6859 vss vss) n12 w=0.5u l=0.13u
MP6865 (qb6848 storage6859 vdd vdd) p12 w=1.5u l=0.13u
MN6866 (dg4 qb6848 vss vss) n12 w=0.5u l=0.13u
MP6867 (dg4 qb6848 vdd vdd) p12 w=1.5u l=0.13u
MN6868 (storage6859 rst vss vss) n12 w=2u l=0.13u
MN6871 (n6869 cg5 n6870 vss) n12 w=1.6u l=0.13u
MN6872 (n6870 n6187 vss vss) n12 w=1.6u l=0.13u
MP6873 (n6869 cg5 vdd vdd) p12 w=2.4u l=0.13u
MP6874 (n6869 n6187 vdd vdd) p12 w=2.4u l=0.13u
MN6877 (n6875 dg5 n6876 vss) n12 w=1.6u l=0.13u
MN6878 (n6876 n6190 vss vss) n12 w=1.6u l=0.13u
MP6879 (n6875 dg5 vdd vdd) p12 w=2.4u l=0.13u
MP6880 (n6875 n6190 vdd vdd) p12 w=2.4u l=0.13u
MN6883 (n6881 n6869 n6882 vss) n12 w=1.6u l=0.13u
MN6884 (n6882 n6875 vss vss) n12 w=1.6u l=0.13u
MP6885 (n6881 n6869 vdd vdd) p12 w=2.4u l=0.13u
MP6886 (n6881 n6875 vdd vdd) p12 w=2.4u l=0.13u
MN6891 (n6881 clk_low108 storage6890 vss) n12 w=1.2u l=0.13u
MP6892 (n6881 clk_lowb109 storage6890 vdd) p12 w=3.6u l=0.13u
MN6893 (qm6887 clk_high110 storage6890 vss) n12 w=1.2u l=0.13u
MP6894 (qm6887 clk_highb111 storage6890 vdd) p12 w=3.6u l=0.13u
MN6895 (qmb6888 storage6890 vss vss) n12 w=0.5u l=0.13u
MP6896 (qmb6888 storage6890 vdd vdd) p12 w=1.5u l=0.13u
MN6897 (qm6887 qmb6888 vss vss) n12 w=0.5u l=0.13u
MP6898 (qm6887 qmb6888 vdd vdd) p12 w=1.5u l=0.13u
MN6899 (storage6890 rst vss vss) n12 w=2u l=0.13u
MN6901 (qm6887 clk_high110 storage6900 vss) n12 w=1.2u l=0.13u
MP6902 (qm6887 clk_highb111 storage6900 vdd) p12 w=3.6u l=0.13u
MN6903 (dg5 clk_low108 storage6900 vss) n12 w=1.2u l=0.13u
MP6904 (dg5 clk_lowb109 storage6900 vdd) p12 w=3.6u l=0.13u
MN6905 (qb6889 storage6900 vss vss) n12 w=0.5u l=0.13u
MP6906 (qb6889 storage6900 vdd vdd) p12 w=1.5u l=0.13u
MN6907 (dg5 qb6889 vss vss) n12 w=0.5u l=0.13u
MP6908 (dg5 qb6889 vdd vdd) p12 w=1.5u l=0.13u
MN6909 (storage6900 rst vss vss) n12 w=2u l=0.13u
MN6912 (n6910 cg6 n6911 vss) n12 w=1.6u l=0.13u
MN6913 (n6911 n6187 vss vss) n12 w=1.6u l=0.13u
MP6914 (n6910 cg6 vdd vdd) p12 w=2.4u l=0.13u
MP6915 (n6910 n6187 vdd vdd) p12 w=2.4u l=0.13u
MN6918 (n6916 dg6 n6917 vss) n12 w=1.6u l=0.13u
MN6919 (n6917 n6190 vss vss) n12 w=1.6u l=0.13u
MP6920 (n6916 dg6 vdd vdd) p12 w=2.4u l=0.13u
MP6921 (n6916 n6190 vdd vdd) p12 w=2.4u l=0.13u
MN6924 (n6922 n6910 n6923 vss) n12 w=1.6u l=0.13u
MN6925 (n6923 n6916 vss vss) n12 w=1.6u l=0.13u
MP6926 (n6922 n6910 vdd vdd) p12 w=2.4u l=0.13u
MP6927 (n6922 n6916 vdd vdd) p12 w=2.4u l=0.13u
MN6932 (n6922 clk_low108 storage6931 vss) n12 w=1.2u l=0.13u
MP6933 (n6922 clk_lowb109 storage6931 vdd) p12 w=3.6u l=0.13u
MN6934 (qm6928 clk_high110 storage6931 vss) n12 w=1.2u l=0.13u
MP6935 (qm6928 clk_highb111 storage6931 vdd) p12 w=3.6u l=0.13u
MN6936 (qmb6929 storage6931 vss vss) n12 w=0.5u l=0.13u
MP6937 (qmb6929 storage6931 vdd vdd) p12 w=1.5u l=0.13u
MN6938 (qm6928 qmb6929 vss vss) n12 w=0.5u l=0.13u
MP6939 (qm6928 qmb6929 vdd vdd) p12 w=1.5u l=0.13u
MN6940 (storage6931 rst vss vss) n12 w=2u l=0.13u
MN6942 (qm6928 clk_high110 storage6941 vss) n12 w=1.2u l=0.13u
MP6943 (qm6928 clk_highb111 storage6941 vdd) p12 w=3.6u l=0.13u
MN6944 (dg6 clk_low108 storage6941 vss) n12 w=1.2u l=0.13u
MP6945 (dg6 clk_lowb109 storage6941 vdd) p12 w=3.6u l=0.13u
MN6946 (qb6930 storage6941 vss vss) n12 w=0.5u l=0.13u
MP6947 (qb6930 storage6941 vdd vdd) p12 w=1.5u l=0.13u
MN6948 (dg6 qb6930 vss vss) n12 w=0.5u l=0.13u
MP6949 (dg6 qb6930 vdd vdd) p12 w=1.5u l=0.13u
MN6950 (storage6941 rst vss vss) n12 w=2u l=0.13u
MN6953 (n6951 cg7 n6952 vss) n12 w=1.6u l=0.13u
MN6954 (n6952 n6187 vss vss) n12 w=1.6u l=0.13u
MP6955 (n6951 cg7 vdd vdd) p12 w=2.4u l=0.13u
MP6956 (n6951 n6187 vdd vdd) p12 w=2.4u l=0.13u
MN6959 (n6957 dg7 n6958 vss) n12 w=1.6u l=0.13u
MN6960 (n6958 n6190 vss vss) n12 w=1.6u l=0.13u
MP6961 (n6957 dg7 vdd vdd) p12 w=2.4u l=0.13u
MP6962 (n6957 n6190 vdd vdd) p12 w=2.4u l=0.13u
MN6965 (n6963 n6951 n6964 vss) n12 w=1.6u l=0.13u
MN6966 (n6964 n6957 vss vss) n12 w=1.6u l=0.13u
MP6967 (n6963 n6951 vdd vdd) p12 w=2.4u l=0.13u
MP6968 (n6963 n6957 vdd vdd) p12 w=2.4u l=0.13u
MN6973 (n6963 clk_low108 storage6972 vss) n12 w=1.2u l=0.13u
MP6974 (n6963 clk_lowb109 storage6972 vdd) p12 w=3.6u l=0.13u
MN6975 (qm6969 clk_high110 storage6972 vss) n12 w=1.2u l=0.13u
MP6976 (qm6969 clk_highb111 storage6972 vdd) p12 w=3.6u l=0.13u
MN6977 (qmb6970 storage6972 vss vss) n12 w=0.5u l=0.13u
MP6978 (qmb6970 storage6972 vdd vdd) p12 w=1.5u l=0.13u
MN6979 (qm6969 qmb6970 vss vss) n12 w=0.5u l=0.13u
MP6980 (qm6969 qmb6970 vdd vdd) p12 w=1.5u l=0.13u
MN6981 (storage6972 rst vss vss) n12 w=2u l=0.13u
MN6983 (qm6969 clk_high110 storage6982 vss) n12 w=1.2u l=0.13u
MP6984 (qm6969 clk_highb111 storage6982 vdd) p12 w=3.6u l=0.13u
MN6985 (dg7 clk_low108 storage6982 vss) n12 w=1.2u l=0.13u
MP6986 (dg7 clk_lowb109 storage6982 vdd) p12 w=3.6u l=0.13u
MN6987 (qb6971 storage6982 vss vss) n12 w=0.5u l=0.13u
MP6988 (qb6971 storage6982 vdd vdd) p12 w=1.5u l=0.13u
MN6989 (dg7 qb6971 vss vss) n12 w=0.5u l=0.13u
MP6990 (dg7 qb6971 vdd vdd) p12 w=1.5u l=0.13u
MN6991 (storage6982 rst vss vss) n12 w=2u l=0.13u
MN6994 (n6992 cd0 n6993 vss) n12 w=1.6u l=0.13u
MN6995 (n6993 n6187 vss vss) n12 w=1.6u l=0.13u
MP6996 (n6992 cd0 vdd vdd) p12 w=2.4u l=0.13u
MP6997 (n6992 n6187 vdd vdd) p12 w=2.4u l=0.13u
MN7000 (n6998 dd0 n6999 vss) n12 w=1.6u l=0.13u
MN7001 (n6999 n6190 vss vss) n12 w=1.6u l=0.13u
MP7002 (n6998 dd0 vdd vdd) p12 w=2.4u l=0.13u
MP7003 (n6998 n6190 vdd vdd) p12 w=2.4u l=0.13u
MN7006 (n7004 n6992 n7005 vss) n12 w=1.6u l=0.13u
MN7007 (n7005 n6998 vss vss) n12 w=1.6u l=0.13u
MP7008 (n7004 n6992 vdd vdd) p12 w=2.4u l=0.13u
MP7009 (n7004 n6998 vdd vdd) p12 w=2.4u l=0.13u
MN7014 (n7004 clk_low108 storage7013 vss) n12 w=1.2u l=0.13u
MP7015 (n7004 clk_lowb109 storage7013 vdd) p12 w=3.6u l=0.13u
MN7016 (qm7010 clk_high110 storage7013 vss) n12 w=1.2u l=0.13u
MP7017 (qm7010 clk_highb111 storage7013 vdd) p12 w=3.6u l=0.13u
MN7018 (qmb7011 storage7013 vss vss) n12 w=0.5u l=0.13u
MP7019 (qmb7011 storage7013 vdd vdd) p12 w=1.5u l=0.13u
MN7020 (qm7010 qmb7011 vss vss) n12 w=0.5u l=0.13u
MP7021 (qm7010 qmb7011 vdd vdd) p12 w=1.5u l=0.13u
MN7022 (storage7013 rst vss vss) n12 w=2u l=0.13u
MN7024 (qm7010 clk_high110 storage7023 vss) n12 w=1.2u l=0.13u
MP7025 (qm7010 clk_highb111 storage7023 vdd) p12 w=3.6u l=0.13u
MN7026 (dd0 clk_low108 storage7023 vss) n12 w=1.2u l=0.13u
MP7027 (dd0 clk_lowb109 storage7023 vdd) p12 w=3.6u l=0.13u
MN7028 (qb7012 storage7023 vss vss) n12 w=0.5u l=0.13u
MP7029 (qb7012 storage7023 vdd vdd) p12 w=1.5u l=0.13u
MN7030 (dd0 qb7012 vss vss) n12 w=0.5u l=0.13u
MP7031 (dd0 qb7012 vdd vdd) p12 w=1.5u l=0.13u
MN7032 (storage7023 rst vss vss) n12 w=2u l=0.13u
MN7035 (n7033 cd1 n7034 vss) n12 w=1.6u l=0.13u
MN7036 (n7034 n6187 vss vss) n12 w=1.6u l=0.13u
MP7037 (n7033 cd1 vdd vdd) p12 w=2.4u l=0.13u
MP7038 (n7033 n6187 vdd vdd) p12 w=2.4u l=0.13u
MN7041 (n7039 dd1 n7040 vss) n12 w=1.6u l=0.13u
MN7042 (n7040 n6190 vss vss) n12 w=1.6u l=0.13u
MP7043 (n7039 dd1 vdd vdd) p12 w=2.4u l=0.13u
MP7044 (n7039 n6190 vdd vdd) p12 w=2.4u l=0.13u
MN7047 (n7045 n7033 n7046 vss) n12 w=1.6u l=0.13u
MN7048 (n7046 n7039 vss vss) n12 w=1.6u l=0.13u
MP7049 (n7045 n7033 vdd vdd) p12 w=2.4u l=0.13u
MP7050 (n7045 n7039 vdd vdd) p12 w=2.4u l=0.13u
MN7055 (n7045 clk_low108 storage7054 vss) n12 w=1.2u l=0.13u
MP7056 (n7045 clk_lowb109 storage7054 vdd) p12 w=3.6u l=0.13u
MN7057 (qm7051 clk_high110 storage7054 vss) n12 w=1.2u l=0.13u
MP7058 (qm7051 clk_highb111 storage7054 vdd) p12 w=3.6u l=0.13u
MN7059 (qmb7052 storage7054 vss vss) n12 w=0.5u l=0.13u
MP7060 (qmb7052 storage7054 vdd vdd) p12 w=1.5u l=0.13u
MN7061 (qm7051 qmb7052 vss vss) n12 w=0.5u l=0.13u
MP7062 (qm7051 qmb7052 vdd vdd) p12 w=1.5u l=0.13u
MN7063 (storage7054 rst vss vss) n12 w=2u l=0.13u
MN7065 (qm7051 clk_high110 storage7064 vss) n12 w=1.2u l=0.13u
MP7066 (qm7051 clk_highb111 storage7064 vdd) p12 w=3.6u l=0.13u
MN7067 (dd1 clk_low108 storage7064 vss) n12 w=1.2u l=0.13u
MP7068 (dd1 clk_lowb109 storage7064 vdd) p12 w=3.6u l=0.13u
MN7069 (qb7053 storage7064 vss vss) n12 w=0.5u l=0.13u
MP7070 (qb7053 storage7064 vdd vdd) p12 w=1.5u l=0.13u
MN7071 (dd1 qb7053 vss vss) n12 w=0.5u l=0.13u
MP7072 (dd1 qb7053 vdd vdd) p12 w=1.5u l=0.13u
MN7073 (storage7064 rst vss vss) n12 w=2u l=0.13u
MN7076 (n7074 cd2 n7075 vss) n12 w=1.6u l=0.13u
MN7077 (n7075 n6187 vss vss) n12 w=1.6u l=0.13u
MP7078 (n7074 cd2 vdd vdd) p12 w=2.4u l=0.13u
MP7079 (n7074 n6187 vdd vdd) p12 w=2.4u l=0.13u
MN7082 (n7080 dd2 n7081 vss) n12 w=1.6u l=0.13u
MN7083 (n7081 n6190 vss vss) n12 w=1.6u l=0.13u
MP7084 (n7080 dd2 vdd vdd) p12 w=2.4u l=0.13u
MP7085 (n7080 n6190 vdd vdd) p12 w=2.4u l=0.13u
MN7088 (n7086 n7074 n7087 vss) n12 w=1.6u l=0.13u
MN7089 (n7087 n7080 vss vss) n12 w=1.6u l=0.13u
MP7090 (n7086 n7074 vdd vdd) p12 w=2.4u l=0.13u
MP7091 (n7086 n7080 vdd vdd) p12 w=2.4u l=0.13u
MN7096 (n7086 clk_low108 storage7095 vss) n12 w=1.2u l=0.13u
MP7097 (n7086 clk_lowb109 storage7095 vdd) p12 w=3.6u l=0.13u
MN7098 (qm7092 clk_high110 storage7095 vss) n12 w=1.2u l=0.13u
MP7099 (qm7092 clk_highb111 storage7095 vdd) p12 w=3.6u l=0.13u
MN7100 (qmb7093 storage7095 vss vss) n12 w=0.5u l=0.13u
MP7101 (qmb7093 storage7095 vdd vdd) p12 w=1.5u l=0.13u
MN7102 (qm7092 qmb7093 vss vss) n12 w=0.5u l=0.13u
MP7103 (qm7092 qmb7093 vdd vdd) p12 w=1.5u l=0.13u
MN7104 (storage7095 rst vss vss) n12 w=2u l=0.13u
MN7106 (qm7092 clk_high110 storage7105 vss) n12 w=1.2u l=0.13u
MP7107 (qm7092 clk_highb111 storage7105 vdd) p12 w=3.6u l=0.13u
MN7108 (dd2 clk_low108 storage7105 vss) n12 w=1.2u l=0.13u
MP7109 (dd2 clk_lowb109 storage7105 vdd) p12 w=3.6u l=0.13u
MN7110 (qb7094 storage7105 vss vss) n12 w=0.5u l=0.13u
MP7111 (qb7094 storage7105 vdd vdd) p12 w=1.5u l=0.13u
MN7112 (dd2 qb7094 vss vss) n12 w=0.5u l=0.13u
MP7113 (dd2 qb7094 vdd vdd) p12 w=1.5u l=0.13u
MN7114 (storage7105 rst vss vss) n12 w=2u l=0.13u
MN7117 (n7115 cd3 n7116 vss) n12 w=1.6u l=0.13u
MN7118 (n7116 n6187 vss vss) n12 w=1.6u l=0.13u
MP7119 (n7115 cd3 vdd vdd) p12 w=2.4u l=0.13u
MP7120 (n7115 n6187 vdd vdd) p12 w=2.4u l=0.13u
MN7123 (n7121 dd3 n7122 vss) n12 w=1.6u l=0.13u
MN7124 (n7122 n6190 vss vss) n12 w=1.6u l=0.13u
MP7125 (n7121 dd3 vdd vdd) p12 w=2.4u l=0.13u
MP7126 (n7121 n6190 vdd vdd) p12 w=2.4u l=0.13u
MN7129 (n7127 n7115 n7128 vss) n12 w=1.6u l=0.13u
MN7130 (n7128 n7121 vss vss) n12 w=1.6u l=0.13u
MP7131 (n7127 n7115 vdd vdd) p12 w=2.4u l=0.13u
MP7132 (n7127 n7121 vdd vdd) p12 w=2.4u l=0.13u
MN7137 (n7127 clk_low108 storage7136 vss) n12 w=1.2u l=0.13u
MP7138 (n7127 clk_lowb109 storage7136 vdd) p12 w=3.6u l=0.13u
MN7139 (qm7133 clk_high110 storage7136 vss) n12 w=1.2u l=0.13u
MP7140 (qm7133 clk_highb111 storage7136 vdd) p12 w=3.6u l=0.13u
MN7141 (qmb7134 storage7136 vss vss) n12 w=0.5u l=0.13u
MP7142 (qmb7134 storage7136 vdd vdd) p12 w=1.5u l=0.13u
MN7143 (qm7133 qmb7134 vss vss) n12 w=0.5u l=0.13u
MP7144 (qm7133 qmb7134 vdd vdd) p12 w=1.5u l=0.13u
MN7145 (storage7136 rst vss vss) n12 w=2u l=0.13u
MN7147 (qm7133 clk_high110 storage7146 vss) n12 w=1.2u l=0.13u
MP7148 (qm7133 clk_highb111 storage7146 vdd) p12 w=3.6u l=0.13u
MN7149 (dd3 clk_low108 storage7146 vss) n12 w=1.2u l=0.13u
MP7150 (dd3 clk_lowb109 storage7146 vdd) p12 w=3.6u l=0.13u
MN7151 (qb7135 storage7146 vss vss) n12 w=0.5u l=0.13u
MP7152 (qb7135 storage7146 vdd vdd) p12 w=1.5u l=0.13u
MN7153 (dd3 qb7135 vss vss) n12 w=0.5u l=0.13u
MP7154 (dd3 qb7135 vdd vdd) p12 w=1.5u l=0.13u
MN7155 (storage7146 rst vss vss) n12 w=2u l=0.13u
MN7158 (n7156 cd4 n7157 vss) n12 w=1.6u l=0.13u
MN7159 (n7157 n6187 vss vss) n12 w=1.6u l=0.13u
MP7160 (n7156 cd4 vdd vdd) p12 w=2.4u l=0.13u
MP7161 (n7156 n6187 vdd vdd) p12 w=2.4u l=0.13u
MN7164 (n7162 dd4 n7163 vss) n12 w=1.6u l=0.13u
MN7165 (n7163 n6190 vss vss) n12 w=1.6u l=0.13u
MP7166 (n7162 dd4 vdd vdd) p12 w=2.4u l=0.13u
MP7167 (n7162 n6190 vdd vdd) p12 w=2.4u l=0.13u
MN7170 (n7168 n7156 n7169 vss) n12 w=1.6u l=0.13u
MN7171 (n7169 n7162 vss vss) n12 w=1.6u l=0.13u
MP7172 (n7168 n7156 vdd vdd) p12 w=2.4u l=0.13u
MP7173 (n7168 n7162 vdd vdd) p12 w=2.4u l=0.13u
MN7178 (n7168 clk_low108 storage7177 vss) n12 w=1.2u l=0.13u
MP7179 (n7168 clk_lowb109 storage7177 vdd) p12 w=3.6u l=0.13u
MN7180 (qm7174 clk_high110 storage7177 vss) n12 w=1.2u l=0.13u
MP7181 (qm7174 clk_highb111 storage7177 vdd) p12 w=3.6u l=0.13u
MN7182 (qmb7175 storage7177 vss vss) n12 w=0.5u l=0.13u
MP7183 (qmb7175 storage7177 vdd vdd) p12 w=1.5u l=0.13u
MN7184 (qm7174 qmb7175 vss vss) n12 w=0.5u l=0.13u
MP7185 (qm7174 qmb7175 vdd vdd) p12 w=1.5u l=0.13u
MN7186 (storage7177 rst vss vss) n12 w=2u l=0.13u
MN7188 (qm7174 clk_high110 storage7187 vss) n12 w=1.2u l=0.13u
MP7189 (qm7174 clk_highb111 storage7187 vdd) p12 w=3.6u l=0.13u
MN7190 (dd4 clk_low108 storage7187 vss) n12 w=1.2u l=0.13u
MP7191 (dd4 clk_lowb109 storage7187 vdd) p12 w=3.6u l=0.13u
MN7192 (qb7176 storage7187 vss vss) n12 w=0.5u l=0.13u
MP7193 (qb7176 storage7187 vdd vdd) p12 w=1.5u l=0.13u
MN7194 (dd4 qb7176 vss vss) n12 w=0.5u l=0.13u
MP7195 (dd4 qb7176 vdd vdd) p12 w=1.5u l=0.13u
MN7196 (storage7187 rst vss vss) n12 w=2u l=0.13u
MN7199 (n7197 cd5 n7198 vss) n12 w=1.6u l=0.13u
MN7200 (n7198 n6187 vss vss) n12 w=1.6u l=0.13u
MP7201 (n7197 cd5 vdd vdd) p12 w=2.4u l=0.13u
MP7202 (n7197 n6187 vdd vdd) p12 w=2.4u l=0.13u
MN7205 (n7203 dd5 n7204 vss) n12 w=1.6u l=0.13u
MN7206 (n7204 n6190 vss vss) n12 w=1.6u l=0.13u
MP7207 (n7203 dd5 vdd vdd) p12 w=2.4u l=0.13u
MP7208 (n7203 n6190 vdd vdd) p12 w=2.4u l=0.13u
MN7211 (n7209 n7197 n7210 vss) n12 w=1.6u l=0.13u
MN7212 (n7210 n7203 vss vss) n12 w=1.6u l=0.13u
MP7213 (n7209 n7197 vdd vdd) p12 w=2.4u l=0.13u
MP7214 (n7209 n7203 vdd vdd) p12 w=2.4u l=0.13u
MN7219 (n7209 clk_low108 storage7218 vss) n12 w=1.2u l=0.13u
MP7220 (n7209 clk_lowb109 storage7218 vdd) p12 w=3.6u l=0.13u
MN7221 (qm7215 clk_high110 storage7218 vss) n12 w=1.2u l=0.13u
MP7222 (qm7215 clk_highb111 storage7218 vdd) p12 w=3.6u l=0.13u
MN7223 (qmb7216 storage7218 vss vss) n12 w=0.5u l=0.13u
MP7224 (qmb7216 storage7218 vdd vdd) p12 w=1.5u l=0.13u
MN7225 (qm7215 qmb7216 vss vss) n12 w=0.5u l=0.13u
MP7226 (qm7215 qmb7216 vdd vdd) p12 w=1.5u l=0.13u
MN7227 (storage7218 rst vss vss) n12 w=2u l=0.13u
MN7229 (qm7215 clk_high110 storage7228 vss) n12 w=1.2u l=0.13u
MP7230 (qm7215 clk_highb111 storage7228 vdd) p12 w=3.6u l=0.13u
MN7231 (dd5 clk_low108 storage7228 vss) n12 w=1.2u l=0.13u
MP7232 (dd5 clk_lowb109 storage7228 vdd) p12 w=3.6u l=0.13u
MN7233 (qb7217 storage7228 vss vss) n12 w=0.5u l=0.13u
MP7234 (qb7217 storage7228 vdd vdd) p12 w=1.5u l=0.13u
MN7235 (dd5 qb7217 vss vss) n12 w=0.5u l=0.13u
MP7236 (dd5 qb7217 vdd vdd) p12 w=1.5u l=0.13u
MN7237 (storage7228 rst vss vss) n12 w=2u l=0.13u
MN7240 (n7238 cd6 n7239 vss) n12 w=1.6u l=0.13u
MN7241 (n7239 n6187 vss vss) n12 w=1.6u l=0.13u
MP7242 (n7238 cd6 vdd vdd) p12 w=2.4u l=0.13u
MP7243 (n7238 n6187 vdd vdd) p12 w=2.4u l=0.13u
MN7246 (n7244 dd6 n7245 vss) n12 w=1.6u l=0.13u
MN7247 (n7245 n6190 vss vss) n12 w=1.6u l=0.13u
MP7248 (n7244 dd6 vdd vdd) p12 w=2.4u l=0.13u
MP7249 (n7244 n6190 vdd vdd) p12 w=2.4u l=0.13u
MN7252 (n7250 n7238 n7251 vss) n12 w=1.6u l=0.13u
MN7253 (n7251 n7244 vss vss) n12 w=1.6u l=0.13u
MP7254 (n7250 n7238 vdd vdd) p12 w=2.4u l=0.13u
MP7255 (n7250 n7244 vdd vdd) p12 w=2.4u l=0.13u
MN7260 (n7250 clk_low108 storage7259 vss) n12 w=1.2u l=0.13u
MP7261 (n7250 clk_lowb109 storage7259 vdd) p12 w=3.6u l=0.13u
MN7262 (qm7256 clk_high110 storage7259 vss) n12 w=1.2u l=0.13u
MP7263 (qm7256 clk_highb111 storage7259 vdd) p12 w=3.6u l=0.13u
MN7264 (qmb7257 storage7259 vss vss) n12 w=0.5u l=0.13u
MP7265 (qmb7257 storage7259 vdd vdd) p12 w=1.5u l=0.13u
MN7266 (qm7256 qmb7257 vss vss) n12 w=0.5u l=0.13u
MP7267 (qm7256 qmb7257 vdd vdd) p12 w=1.5u l=0.13u
MN7268 (storage7259 rst vss vss) n12 w=2u l=0.13u
MN7270 (qm7256 clk_high110 storage7269 vss) n12 w=1.2u l=0.13u
MP7271 (qm7256 clk_highb111 storage7269 vdd) p12 w=3.6u l=0.13u
MN7272 (dd6 clk_low108 storage7269 vss) n12 w=1.2u l=0.13u
MP7273 (dd6 clk_lowb109 storage7269 vdd) p12 w=3.6u l=0.13u
MN7274 (qb7258 storage7269 vss vss) n12 w=0.5u l=0.13u
MP7275 (qb7258 storage7269 vdd vdd) p12 w=1.5u l=0.13u
MN7276 (dd6 qb7258 vss vss) n12 w=0.5u l=0.13u
MP7277 (dd6 qb7258 vdd vdd) p12 w=1.5u l=0.13u
MN7278 (storage7269 rst vss vss) n12 w=2u l=0.13u
MN7281 (n7279 cd7 n7280 vss) n12 w=1.6u l=0.13u
MN7282 (n7280 n6187 vss vss) n12 w=1.6u l=0.13u
MP7283 (n7279 cd7 vdd vdd) p12 w=2.4u l=0.13u
MP7284 (n7279 n6187 vdd vdd) p12 w=2.4u l=0.13u
MN7287 (n7285 dd7 n7286 vss) n12 w=1.6u l=0.13u
MN7288 (n7286 n6190 vss vss) n12 w=1.6u l=0.13u
MP7289 (n7285 dd7 vdd vdd) p12 w=2.4u l=0.13u
MP7290 (n7285 n6190 vdd vdd) p12 w=2.4u l=0.13u
MN7293 (n7291 n7279 n7292 vss) n12 w=1.6u l=0.13u
MN7294 (n7292 n7285 vss vss) n12 w=1.6u l=0.13u
MP7295 (n7291 n7279 vdd vdd) p12 w=2.4u l=0.13u
MP7296 (n7291 n7285 vdd vdd) p12 w=2.4u l=0.13u
MN7301 (n7291 clk_low108 storage7300 vss) n12 w=1.2u l=0.13u
MP7302 (n7291 clk_lowb109 storage7300 vdd) p12 w=3.6u l=0.13u
MN7303 (qm7297 clk_high110 storage7300 vss) n12 w=1.2u l=0.13u
MP7304 (qm7297 clk_highb111 storage7300 vdd) p12 w=3.6u l=0.13u
MN7305 (qmb7298 storage7300 vss vss) n12 w=0.5u l=0.13u
MP7306 (qmb7298 storage7300 vdd vdd) p12 w=1.5u l=0.13u
MN7307 (qm7297 qmb7298 vss vss) n12 w=0.5u l=0.13u
MP7308 (qm7297 qmb7298 vdd vdd) p12 w=1.5u l=0.13u
MN7309 (storage7300 rst vss vss) n12 w=2u l=0.13u
MN7311 (qm7297 clk_high110 storage7310 vss) n12 w=1.2u l=0.13u
MP7312 (qm7297 clk_highb111 storage7310 vdd) p12 w=3.6u l=0.13u
MN7313 (dd7 clk_low108 storage7310 vss) n12 w=1.2u l=0.13u
MP7314 (dd7 clk_lowb109 storage7310 vdd) p12 w=3.6u l=0.13u
MN7315 (qb7299 storage7310 vss vss) n12 w=0.5u l=0.13u
MP7316 (qb7299 storage7310 vdd vdd) p12 w=1.5u l=0.13u
MN7317 (dd7 qb7299 vss vss) n12 w=0.5u l=0.13u
MP7318 (dd7 qb7299 vdd vdd) p12 w=1.5u l=0.13u
MN7319 (storage7310 rst vss vss) n12 w=2u l=0.13u
MN7321 (n7320 settle vss vss) n12 w=0.8u l=0.13u
MP7322 (n7320 settle vdd vdd) p12 w=2.4u l=0.13u
MN7325 (n7323 n7320 vss vss) n12 w=0.8u l=0.13u
MN7326 (n7323 rst vss vss) n12 w=0.8u l=0.13u
MP7327 (n7323 n7320 n7324 vdd) p12 w=4.8u l=0.13u
MP7328 (n7324 rst vdd vdd) p12 w=4.8u l=0.13u
MN7330 (n7329 n7323 vss vss) n12 w=0.8u l=0.13u
MP7331 (n7329 n7323 vdd vdd) p12 w=2.4u l=0.13u
MN7333 (n7332 settletick0 vss vss) n12 w=0.8u l=0.13u
MP7334 (n7332 settletick0 vdd vdd) p12 w=2.4u l=0.13u
MN7336 (n7335 n7329 vss vss) n12 w=0.8u l=0.13u
MP7337 (n7335 n7329 vdd vdd) p12 w=2.4u l=0.13u
MN7346 (n7342 n22 n7343 vss) n12 w=3.2u l=0.13u
MP7347 (n7342 n22 vdd vdd) p12 w=2.4u l=0.13u
MN7348 (n7343 n102 n7344 vss) n12 w=3.2u l=0.13u
MP7349 (n7342 n102 vdd vdd) p12 w=2.4u l=0.13u
MN7350 (n7344 clk_highb7341 n7345 vss) n12 w=3.2u l=0.13u
MP7351 (n7342 clk_highb7341 vdd vdd) p12 w=2.4u l=0.13u
MN7352 (n7345 n7335 vss vss) n12 w=3.2u l=0.13u
MP7353 (n7342 n7335 vdd vdd) p12 w=2.4u l=0.13u
MN7358 (n7354 n19 n7355 vss) n12 w=3.2u l=0.13u
MP7359 (n7354 n19 vdd vdd) p12 w=2.4u l=0.13u
MN7360 (n7355 delay99 n7356 vss) n12 w=3.2u l=0.13u
MP7361 (n7354 delay99 vdd vdd) p12 w=2.4u l=0.13u
MN7362 (n7356 clk_lowb7339 n7357 vss) n12 w=3.2u l=0.13u
MP7363 (n7354 clk_lowb7339 vdd vdd) p12 w=2.4u l=0.13u
MN7364 (n7357 n7335 vss vss) n12 w=3.2u l=0.13u
MP7365 (n7354 n7335 vdd vdd) p12 w=2.4u l=0.13u
MN7366 (clk_low7338 n7342 vss vss) n12 w=8u l=0.13u
MP7367 (clk_low7338 n7342 vdd vdd) p12 w=24u l=0.13u
MN7368 (clk_lowb7339 clk_low7338 vss vss) n12 w=8u l=0.13u
MP7369 (clk_lowb7339 clk_low7338 vdd vdd) p12 w=24u l=0.13u
MN7370 (clk_high7340 n7354 vss vss) n12 w=8u l=0.13u
MP7371 (clk_high7340 n7354 vdd vdd) p12 w=24u l=0.13u
MN7372 (clk_highb7341 clk_high7340 vss vss) n12 w=8u l=0.13u
MP7373 (clk_highb7341 clk_high7340 vdd vdd) p12 w=24u l=0.13u
MN7378 (n7332 clk_low7338 storage7377 vss) n12 w=1.2u l=0.13u
MP7379 (n7332 clk_lowb7339 storage7377 vdd) p12 w=3.6u l=0.13u
MN7380 (qm7374 clk_high7340 storage7377 vss) n12 w=1.2u l=0.13u
MP7381 (qm7374 clk_highb7341 storage7377 vdd) p12 w=3.6u l=0.13u
MN7382 (qmb7375 storage7377 vss vss) n12 w=0.5u l=0.13u
MP7383 (qmb7375 storage7377 vdd vdd) p12 w=1.5u l=0.13u
MN7384 (qm7374 qmb7375 vss vss) n12 w=0.5u l=0.13u
MP7385 (qm7374 qmb7375 vdd vdd) p12 w=1.5u l=0.13u
MN7386 (storage7377 n7329 vss vss) n12 w=2u l=0.13u
MN7388 (qm7374 clk_high7340 storage7387 vss) n12 w=1.2u l=0.13u
MP7389 (qm7374 clk_highb7341 storage7387 vdd) p12 w=3.6u l=0.13u
MN7390 (settletick0 clk_low7338 storage7387 vss) n12 w=1.2u l=0.13u
MP7391 (settletick0 clk_lowb7339 storage7387 vdd) p12 w=3.6u l=0.13u
MN7392 (qb7376 storage7387 vss vss) n12 w=0.5u l=0.13u
MP7393 (qb7376 storage7387 vdd vdd) p12 w=1.5u l=0.13u
MN7394 (settletick0 qb7376 vss vss) n12 w=0.5u l=0.13u
MP7395 (settletick0 qb7376 vdd vdd) p12 w=1.5u l=0.13u
MN7396 (storage7387 n7329 vss vss) n12 w=2u l=0.13u
MN7399 (n7397 settletick0 n7398 vss) n12 w=1.6u l=0.13u
MN7400 (n7398 settletick1 vss vss) n12 w=1.6u l=0.13u
MP7401 (n7397 settletick0 vdd vdd) p12 w=2.4u l=0.13u
MP7402 (n7397 settletick1 vdd vdd) p12 w=2.4u l=0.13u
MN7405 (n7403 n7397 n7404 vss) n12 w=1.6u l=0.13u
MN7406 (n7404 settletick0 vss vss) n12 w=1.6u l=0.13u
MP7407 (n7403 n7397 vdd vdd) p12 w=2.4u l=0.13u
MP7408 (n7403 settletick0 vdd vdd) p12 w=2.4u l=0.13u
MN7411 (n7409 n7397 n7410 vss) n12 w=1.6u l=0.13u
MN7412 (n7410 settletick1 vss vss) n12 w=1.6u l=0.13u
MP7413 (n7409 n7397 vdd vdd) p12 w=2.4u l=0.13u
MP7414 (n7409 settletick1 vdd vdd) p12 w=2.4u l=0.13u
MN7417 (n7415 n7403 n7416 vss) n12 w=1.6u l=0.13u
MN7418 (n7416 n7409 vss vss) n12 w=1.6u l=0.13u
MP7419 (n7415 n7403 vdd vdd) p12 w=2.4u l=0.13u
MP7420 (n7415 n7409 vdd vdd) p12 w=2.4u l=0.13u
MN7422 (n7421 n7397 vss vss) n12 w=0.8u l=0.13u
MP7423 (n7421 n7397 vdd vdd) p12 w=2.4u l=0.13u
MN7428 (n7415 clk_low7338 storage7427 vss) n12 w=1.2u l=0.13u
MP7429 (n7415 clk_lowb7339 storage7427 vdd) p12 w=3.6u l=0.13u
MN7430 (qm7424 clk_high7340 storage7427 vss) n12 w=1.2u l=0.13u
MP7431 (qm7424 clk_highb7341 storage7427 vdd) p12 w=3.6u l=0.13u
MN7432 (qmb7425 storage7427 vss vss) n12 w=0.5u l=0.13u
MP7433 (qmb7425 storage7427 vdd vdd) p12 w=1.5u l=0.13u
MN7434 (qm7424 qmb7425 vss vss) n12 w=0.5u l=0.13u
MP7435 (qm7424 qmb7425 vdd vdd) p12 w=1.5u l=0.13u
MN7436 (storage7427 n7329 vss vss) n12 w=2u l=0.13u
MN7438 (qm7424 clk_high7340 storage7437 vss) n12 w=1.2u l=0.13u
MP7439 (qm7424 clk_highb7341 storage7437 vdd) p12 w=3.6u l=0.13u
MN7440 (settletick1 clk_low7338 storage7437 vss) n12 w=1.2u l=0.13u
MP7441 (settletick1 clk_lowb7339 storage7437 vdd) p12 w=3.6u l=0.13u
MN7442 (qb7426 storage7437 vss vss) n12 w=0.5u l=0.13u
MP7443 (qb7426 storage7437 vdd vdd) p12 w=1.5u l=0.13u
MN7444 (settletick1 qb7426 vss vss) n12 w=0.5u l=0.13u
MP7445 (settletick1 qb7426 vdd vdd) p12 w=1.5u l=0.13u
MN7446 (storage7437 n7329 vss vss) n12 w=2u l=0.13u
MN7449 (n7447 n7421 n7448 vss) n12 w=1.6u l=0.13u
MN7450 (n7448 settletick2 vss vss) n12 w=1.6u l=0.13u
MP7451 (n7447 n7421 vdd vdd) p12 w=2.4u l=0.13u
MP7452 (n7447 settletick2 vdd vdd) p12 w=2.4u l=0.13u
MN7455 (n7453 n7421 n7454 vss) n12 w=1.6u l=0.13u
MN7456 (n7454 n7447 vss vss) n12 w=1.6u l=0.13u
MP7457 (n7453 n7421 vdd vdd) p12 w=2.4u l=0.13u
MP7458 (n7453 n7447 vdd vdd) p12 w=2.4u l=0.13u
MN7461 (n7459 n7447 n7460 vss) n12 w=1.6u l=0.13u
MN7462 (n7460 settletick2 vss vss) n12 w=1.6u l=0.13u
MP7463 (n7459 n7447 vdd vdd) p12 w=2.4u l=0.13u
MP7464 (n7459 settletick2 vdd vdd) p12 w=2.4u l=0.13u
MN7467 (n7465 n7453 n7466 vss) n12 w=1.6u l=0.13u
MN7468 (n7466 n7459 vss vss) n12 w=1.6u l=0.13u
MP7469 (n7465 n7453 vdd vdd) p12 w=2.4u l=0.13u
MP7470 (n7465 n7459 vdd vdd) p12 w=2.4u l=0.13u
MN7472 (n7471 n7447 vss vss) n12 w=0.8u l=0.13u
MP7473 (n7471 n7447 vdd vdd) p12 w=2.4u l=0.13u
MN7478 (n7465 clk_low7338 storage7477 vss) n12 w=1.2u l=0.13u
MP7479 (n7465 clk_lowb7339 storage7477 vdd) p12 w=3.6u l=0.13u
MN7480 (qm7474 clk_high7340 storage7477 vss) n12 w=1.2u l=0.13u
MP7481 (qm7474 clk_highb7341 storage7477 vdd) p12 w=3.6u l=0.13u
MN7482 (qmb7475 storage7477 vss vss) n12 w=0.5u l=0.13u
MP7483 (qmb7475 storage7477 vdd vdd) p12 w=1.5u l=0.13u
MN7484 (qm7474 qmb7475 vss vss) n12 w=0.5u l=0.13u
MP7485 (qm7474 qmb7475 vdd vdd) p12 w=1.5u l=0.13u
MN7486 (storage7477 n7329 vss vss) n12 w=2u l=0.13u
MN7488 (qm7474 clk_high7340 storage7487 vss) n12 w=1.2u l=0.13u
MP7489 (qm7474 clk_highb7341 storage7487 vdd) p12 w=3.6u l=0.13u
MN7490 (settletick2 clk_low7338 storage7487 vss) n12 w=1.2u l=0.13u
MP7491 (settletick2 clk_lowb7339 storage7487 vdd) p12 w=3.6u l=0.13u
MN7492 (qb7476 storage7487 vss vss) n12 w=0.5u l=0.13u
MP7493 (qb7476 storage7487 vdd vdd) p12 w=1.5u l=0.13u
MN7494 (settletick2 qb7476 vss vss) n12 w=0.5u l=0.13u
MP7495 (settletick2 qb7476 vdd vdd) p12 w=1.5u l=0.13u
MN7496 (storage7487 n7329 vss vss) n12 w=2u l=0.13u
MN7498 (n7497 settletick2 vss vss) n12 w=0.8u l=0.13u
MP7499 (n7497 settletick2 vdd vdd) p12 w=2.4u l=0.13u
MN7502 (n7500 settle n7501 vss) n12 w=1.6u l=0.13u
MN7503 (n7501 settletick0 vss vss) n12 w=1.6u l=0.13u
MP7504 (n7500 settle vdd vdd) p12 w=2.4u l=0.13u
MP7505 (n7500 settletick0 vdd vdd) p12 w=2.4u l=0.13u
MN7507 (n7506 n7500 vss vss) n12 w=0.8u l=0.13u
MP7508 (n7506 n7500 vdd vdd) p12 w=2.4u l=0.13u
MN7511 (n7509 n7497 n7510 vss) n12 w=1.6u l=0.13u
MN7512 (n7510 settletick1 vss vss) n12 w=1.6u l=0.13u
MP7513 (n7509 n7497 vdd vdd) p12 w=2.4u l=0.13u
MP7514 (n7509 settletick1 vdd vdd) p12 w=2.4u l=0.13u
MN7516 (n7515 n7509 vss vss) n12 w=0.8u l=0.13u
MP7517 (n7515 n7509 vdd vdd) p12 w=2.4u l=0.13u
MN7520 (n7518 n7506 n7519 vss) n12 w=1.6u l=0.13u
MN7521 (n7519 n7515 vss vss) n12 w=1.6u l=0.13u
MP7522 (n7518 n7506 vdd vdd) p12 w=2.4u l=0.13u
MP7523 (n7518 n7515 vdd vdd) p12 w=2.4u l=0.13u
MN7525 (n7524 n7518 vss vss) n12 w=0.8u l=0.13u
MP7526 (n7524 n7518 vdd vdd) p12 w=2.4u l=0.13u
MN7528 (n7527 arm vss vss) n12 w=0.8u l=0.13u
MP7529 (n7527 arm vdd vdd) p12 w=2.4u l=0.13u
MN7532 (n7530 n7527 vss vss) n12 w=0.8u l=0.13u
MN7533 (n7530 rst vss vss) n12 w=0.8u l=0.13u
MP7534 (n7530 n7527 n7531 vdd) p12 w=4.8u l=0.13u
MP7535 (n7531 rst vdd vdd) p12 w=4.8u l=0.13u
MN7537 (n7536 n7530 vss vss) n12 w=0.8u l=0.13u
MP7538 (n7536 n7530 vdd vdd) p12 w=2.4u l=0.13u
MN7540 (n7539 armtick0 vss vss) n12 w=0.8u l=0.13u
MP7541 (n7539 armtick0 vdd vdd) p12 w=2.4u l=0.13u
MN7543 (n7542 n7536 vss vss) n12 w=0.8u l=0.13u
MP7544 (n7542 n7536 vdd vdd) p12 w=2.4u l=0.13u
MN7553 (n7549 n22 n7550 vss) n12 w=3.2u l=0.13u
MP7554 (n7549 n22 vdd vdd) p12 w=2.4u l=0.13u
MN7555 (n7550 n102 n7551 vss) n12 w=3.2u l=0.13u
MP7556 (n7549 n102 vdd vdd) p12 w=2.4u l=0.13u
MN7557 (n7551 clk_highb7548 n7552 vss) n12 w=3.2u l=0.13u
MP7558 (n7549 clk_highb7548 vdd vdd) p12 w=2.4u l=0.13u
MN7559 (n7552 n7542 vss vss) n12 w=3.2u l=0.13u
MP7560 (n7549 n7542 vdd vdd) p12 w=2.4u l=0.13u
MN7565 (n7561 n19 n7562 vss) n12 w=3.2u l=0.13u
MP7566 (n7561 n19 vdd vdd) p12 w=2.4u l=0.13u
MN7567 (n7562 delay99 n7563 vss) n12 w=3.2u l=0.13u
MP7568 (n7561 delay99 vdd vdd) p12 w=2.4u l=0.13u
MN7569 (n7563 clk_lowb7546 n7564 vss) n12 w=3.2u l=0.13u
MP7570 (n7561 clk_lowb7546 vdd vdd) p12 w=2.4u l=0.13u
MN7571 (n7564 n7542 vss vss) n12 w=3.2u l=0.13u
MP7572 (n7561 n7542 vdd vdd) p12 w=2.4u l=0.13u
MN7573 (clk_low7545 n7549 vss vss) n12 w=8u l=0.13u
MP7574 (clk_low7545 n7549 vdd vdd) p12 w=24u l=0.13u
MN7575 (clk_lowb7546 clk_low7545 vss vss) n12 w=8u l=0.13u
MP7576 (clk_lowb7546 clk_low7545 vdd vdd) p12 w=24u l=0.13u
MN7577 (clk_high7547 n7561 vss vss) n12 w=8u l=0.13u
MP7578 (clk_high7547 n7561 vdd vdd) p12 w=24u l=0.13u
MN7579 (clk_highb7548 clk_high7547 vss vss) n12 w=8u l=0.13u
MP7580 (clk_highb7548 clk_high7547 vdd vdd) p12 w=24u l=0.13u
MN7585 (n7539 clk_low7545 storage7584 vss) n12 w=1.2u l=0.13u
MP7586 (n7539 clk_lowb7546 storage7584 vdd) p12 w=3.6u l=0.13u
MN7587 (qm7581 clk_high7547 storage7584 vss) n12 w=1.2u l=0.13u
MP7588 (qm7581 clk_highb7548 storage7584 vdd) p12 w=3.6u l=0.13u
MN7589 (qmb7582 storage7584 vss vss) n12 w=0.5u l=0.13u
MP7590 (qmb7582 storage7584 vdd vdd) p12 w=1.5u l=0.13u
MN7591 (qm7581 qmb7582 vss vss) n12 w=0.5u l=0.13u
MP7592 (qm7581 qmb7582 vdd vdd) p12 w=1.5u l=0.13u
MN7593 (storage7584 n7536 vss vss) n12 w=2u l=0.13u
MN7595 (qm7581 clk_high7547 storage7594 vss) n12 w=1.2u l=0.13u
MP7596 (qm7581 clk_highb7548 storage7594 vdd) p12 w=3.6u l=0.13u
MN7597 (armtick0 clk_low7545 storage7594 vss) n12 w=1.2u l=0.13u
MP7598 (armtick0 clk_lowb7546 storage7594 vdd) p12 w=3.6u l=0.13u
MN7599 (qb7583 storage7594 vss vss) n12 w=0.5u l=0.13u
MP7600 (qb7583 storage7594 vdd vdd) p12 w=1.5u l=0.13u
MN7601 (armtick0 qb7583 vss vss) n12 w=0.5u l=0.13u
MP7602 (armtick0 qb7583 vdd vdd) p12 w=1.5u l=0.13u
MN7603 (storage7594 n7536 vss vss) n12 w=2u l=0.13u
MN7606 (n7604 armtick0 n7605 vss) n12 w=1.6u l=0.13u
MN7607 (n7605 armtick1 vss vss) n12 w=1.6u l=0.13u
MP7608 (n7604 armtick0 vdd vdd) p12 w=2.4u l=0.13u
MP7609 (n7604 armtick1 vdd vdd) p12 w=2.4u l=0.13u
MN7612 (n7610 armtick0 n7611 vss) n12 w=1.6u l=0.13u
MN7613 (n7611 n7604 vss vss) n12 w=1.6u l=0.13u
MP7614 (n7610 armtick0 vdd vdd) p12 w=2.4u l=0.13u
MP7615 (n7610 n7604 vdd vdd) p12 w=2.4u l=0.13u
MN7618 (n7616 armtick1 n7617 vss) n12 w=1.6u l=0.13u
MN7619 (n7617 n7604 vss vss) n12 w=1.6u l=0.13u
MP7620 (n7616 armtick1 vdd vdd) p12 w=2.4u l=0.13u
MP7621 (n7616 n7604 vdd vdd) p12 w=2.4u l=0.13u
MN7624 (n7622 n7610 n7623 vss) n12 w=1.6u l=0.13u
MN7625 (n7623 n7616 vss vss) n12 w=1.6u l=0.13u
MP7626 (n7622 n7610 vdd vdd) p12 w=2.4u l=0.13u
MP7627 (n7622 n7616 vdd vdd) p12 w=2.4u l=0.13u
MN7629 (n7628 n7604 vss vss) n12 w=0.8u l=0.13u
MP7630 (n7628 n7604 vdd vdd) p12 w=2.4u l=0.13u
MN7635 (n7622 clk_low7545 storage7634 vss) n12 w=1.2u l=0.13u
MP7636 (n7622 clk_lowb7546 storage7634 vdd) p12 w=3.6u l=0.13u
MN7637 (qm7631 clk_high7547 storage7634 vss) n12 w=1.2u l=0.13u
MP7638 (qm7631 clk_highb7548 storage7634 vdd) p12 w=3.6u l=0.13u
MN7639 (qmb7632 storage7634 vss vss) n12 w=0.5u l=0.13u
MP7640 (qmb7632 storage7634 vdd vdd) p12 w=1.5u l=0.13u
MN7641 (qm7631 qmb7632 vss vss) n12 w=0.5u l=0.13u
MP7642 (qm7631 qmb7632 vdd vdd) p12 w=1.5u l=0.13u
MN7643 (storage7634 n7536 vss vss) n12 w=2u l=0.13u
MN7645 (qm7631 clk_high7547 storage7644 vss) n12 w=1.2u l=0.13u
MP7646 (qm7631 clk_highb7548 storage7644 vdd) p12 w=3.6u l=0.13u
MN7647 (armtick1 clk_low7545 storage7644 vss) n12 w=1.2u l=0.13u
MP7648 (armtick1 clk_lowb7546 storage7644 vdd) p12 w=3.6u l=0.13u
MN7649 (qb7633 storage7644 vss vss) n12 w=0.5u l=0.13u
MP7650 (qb7633 storage7644 vdd vdd) p12 w=1.5u l=0.13u
MN7651 (armtick1 qb7633 vss vss) n12 w=0.5u l=0.13u
MP7652 (armtick1 qb7633 vdd vdd) p12 w=1.5u l=0.13u
MN7653 (storage7644 n7536 vss vss) n12 w=2u l=0.13u
MN7656 (n7654 armtick2 n7655 vss) n12 w=1.6u l=0.13u
MN7657 (n7655 n7628 vss vss) n12 w=1.6u l=0.13u
MP7658 (n7654 armtick2 vdd vdd) p12 w=2.4u l=0.13u
MP7659 (n7654 n7628 vdd vdd) p12 w=2.4u l=0.13u
MN7662 (n7660 armtick2 n7661 vss) n12 w=1.6u l=0.13u
MN7663 (n7661 n7654 vss vss) n12 w=1.6u l=0.13u
MP7664 (n7660 armtick2 vdd vdd) p12 w=2.4u l=0.13u
MP7665 (n7660 n7654 vdd vdd) p12 w=2.4u l=0.13u
MN7668 (n7666 n7628 n7667 vss) n12 w=1.6u l=0.13u
MN7669 (n7667 n7654 vss vss) n12 w=1.6u l=0.13u
MP7670 (n7666 n7628 vdd vdd) p12 w=2.4u l=0.13u
MP7671 (n7666 n7654 vdd vdd) p12 w=2.4u l=0.13u
MN7674 (n7672 n7660 n7673 vss) n12 w=1.6u l=0.13u
MN7675 (n7673 n7666 vss vss) n12 w=1.6u l=0.13u
MP7676 (n7672 n7660 vdd vdd) p12 w=2.4u l=0.13u
MP7677 (n7672 n7666 vdd vdd) p12 w=2.4u l=0.13u
MN7679 (n7678 n7654 vss vss) n12 w=0.8u l=0.13u
MP7680 (n7678 n7654 vdd vdd) p12 w=2.4u l=0.13u
MN7685 (n7672 clk_low7545 storage7684 vss) n12 w=1.2u l=0.13u
MP7686 (n7672 clk_lowb7546 storage7684 vdd) p12 w=3.6u l=0.13u
MN7687 (qm7681 clk_high7547 storage7684 vss) n12 w=1.2u l=0.13u
MP7688 (qm7681 clk_highb7548 storage7684 vdd) p12 w=3.6u l=0.13u
MN7689 (qmb7682 storage7684 vss vss) n12 w=0.5u l=0.13u
MP7690 (qmb7682 storage7684 vdd vdd) p12 w=1.5u l=0.13u
MN7691 (qm7681 qmb7682 vss vss) n12 w=0.5u l=0.13u
MP7692 (qm7681 qmb7682 vdd vdd) p12 w=1.5u l=0.13u
MN7693 (storage7684 n7536 vss vss) n12 w=2u l=0.13u
MN7695 (qm7681 clk_high7547 storage7694 vss) n12 w=1.2u l=0.13u
MP7696 (qm7681 clk_highb7548 storage7694 vdd) p12 w=3.6u l=0.13u
MN7697 (armtick2 clk_low7545 storage7694 vss) n12 w=1.2u l=0.13u
MP7698 (armtick2 clk_lowb7546 storage7694 vdd) p12 w=3.6u l=0.13u
MN7699 (qb7683 storage7694 vss vss) n12 w=0.5u l=0.13u
MP7700 (qb7683 storage7694 vdd vdd) p12 w=1.5u l=0.13u
MN7701 (armtick2 qb7683 vss vss) n12 w=0.5u l=0.13u
MP7702 (armtick2 qb7683 vdd vdd) p12 w=1.5u l=0.13u
MN7703 (storage7694 n7536 vss vss) n12 w=2u l=0.13u
MN7706 (n7704 armtick3 n7705 vss) n12 w=1.6u l=0.13u
MN7707 (n7705 n7678 vss vss) n12 w=1.6u l=0.13u
MP7708 (n7704 armtick3 vdd vdd) p12 w=2.4u l=0.13u
MP7709 (n7704 n7678 vdd vdd) p12 w=2.4u l=0.13u
MN7712 (n7710 armtick3 n7711 vss) n12 w=1.6u l=0.13u
MN7713 (n7711 n7704 vss vss) n12 w=1.6u l=0.13u
MP7714 (n7710 armtick3 vdd vdd) p12 w=2.4u l=0.13u
MP7715 (n7710 n7704 vdd vdd) p12 w=2.4u l=0.13u
MN7718 (n7716 n7678 n7717 vss) n12 w=1.6u l=0.13u
MN7719 (n7717 n7704 vss vss) n12 w=1.6u l=0.13u
MP7720 (n7716 n7678 vdd vdd) p12 w=2.4u l=0.13u
MP7721 (n7716 n7704 vdd vdd) p12 w=2.4u l=0.13u
MN7724 (n7722 n7710 n7723 vss) n12 w=1.6u l=0.13u
MN7725 (n7723 n7716 vss vss) n12 w=1.6u l=0.13u
MP7726 (n7722 n7710 vdd vdd) p12 w=2.4u l=0.13u
MP7727 (n7722 n7716 vdd vdd) p12 w=2.4u l=0.13u
MN7729 (n7728 n7704 vss vss) n12 w=0.8u l=0.13u
MP7730 (n7728 n7704 vdd vdd) p12 w=2.4u l=0.13u
MN7735 (n7722 clk_low7545 storage7734 vss) n12 w=1.2u l=0.13u
MP7736 (n7722 clk_lowb7546 storage7734 vdd) p12 w=3.6u l=0.13u
MN7737 (qm7731 clk_high7547 storage7734 vss) n12 w=1.2u l=0.13u
MP7738 (qm7731 clk_highb7548 storage7734 vdd) p12 w=3.6u l=0.13u
MN7739 (qmb7732 storage7734 vss vss) n12 w=0.5u l=0.13u
MP7740 (qmb7732 storage7734 vdd vdd) p12 w=1.5u l=0.13u
MN7741 (qm7731 qmb7732 vss vss) n12 w=0.5u l=0.13u
MP7742 (qm7731 qmb7732 vdd vdd) p12 w=1.5u l=0.13u
MN7743 (storage7734 n7536 vss vss) n12 w=2u l=0.13u
MN7745 (qm7731 clk_high7547 storage7744 vss) n12 w=1.2u l=0.13u
MP7746 (qm7731 clk_highb7548 storage7744 vdd) p12 w=3.6u l=0.13u
MN7747 (armtick3 clk_low7545 storage7744 vss) n12 w=1.2u l=0.13u
MP7748 (armtick3 clk_lowb7546 storage7744 vdd) p12 w=3.6u l=0.13u
MN7749 (qb7733 storage7744 vss vss) n12 w=0.5u l=0.13u
MP7750 (qb7733 storage7744 vdd vdd) p12 w=1.5u l=0.13u
MN7751 (armtick3 qb7733 vss vss) n12 w=0.5u l=0.13u
MP7752 (armtick3 qb7733 vdd vdd) p12 w=1.5u l=0.13u
MN7753 (storage7744 n7536 vss vss) n12 w=2u l=0.13u
MN7756 (n7754 armtick4 n7755 vss) n12 w=1.6u l=0.13u
MN7757 (n7755 n7728 vss vss) n12 w=1.6u l=0.13u
MP7758 (n7754 armtick4 vdd vdd) p12 w=2.4u l=0.13u
MP7759 (n7754 n7728 vdd vdd) p12 w=2.4u l=0.13u
MN7762 (n7760 armtick4 n7761 vss) n12 w=1.6u l=0.13u
MN7763 (n7761 n7754 vss vss) n12 w=1.6u l=0.13u
MP7764 (n7760 armtick4 vdd vdd) p12 w=2.4u l=0.13u
MP7765 (n7760 n7754 vdd vdd) p12 w=2.4u l=0.13u
MN7768 (n7766 n7728 n7767 vss) n12 w=1.6u l=0.13u
MN7769 (n7767 n7754 vss vss) n12 w=1.6u l=0.13u
MP7770 (n7766 n7728 vdd vdd) p12 w=2.4u l=0.13u
MP7771 (n7766 n7754 vdd vdd) p12 w=2.4u l=0.13u
MN7774 (n7772 n7760 n7773 vss) n12 w=1.6u l=0.13u
MN7775 (n7773 n7766 vss vss) n12 w=1.6u l=0.13u
MP7776 (n7772 n7760 vdd vdd) p12 w=2.4u l=0.13u
MP7777 (n7772 n7766 vdd vdd) p12 w=2.4u l=0.13u
MN7779 (n7778 n7754 vss vss) n12 w=0.8u l=0.13u
MP7780 (n7778 n7754 vdd vdd) p12 w=2.4u l=0.13u
MN7785 (n7772 clk_low7545 storage7784 vss) n12 w=1.2u l=0.13u
MP7786 (n7772 clk_lowb7546 storage7784 vdd) p12 w=3.6u l=0.13u
MN7787 (qm7781 clk_high7547 storage7784 vss) n12 w=1.2u l=0.13u
MP7788 (qm7781 clk_highb7548 storage7784 vdd) p12 w=3.6u l=0.13u
MN7789 (qmb7782 storage7784 vss vss) n12 w=0.5u l=0.13u
MP7790 (qmb7782 storage7784 vdd vdd) p12 w=1.5u l=0.13u
MN7791 (qm7781 qmb7782 vss vss) n12 w=0.5u l=0.13u
MP7792 (qm7781 qmb7782 vdd vdd) p12 w=1.5u l=0.13u
MN7793 (storage7784 n7536 vss vss) n12 w=2u l=0.13u
MN7795 (qm7781 clk_high7547 storage7794 vss) n12 w=1.2u l=0.13u
MP7796 (qm7781 clk_highb7548 storage7794 vdd) p12 w=3.6u l=0.13u
MN7797 (armtick4 clk_low7545 storage7794 vss) n12 w=1.2u l=0.13u
MP7798 (armtick4 clk_lowb7546 storage7794 vdd) p12 w=3.6u l=0.13u
MN7799 (qb7783 storage7794 vss vss) n12 w=0.5u l=0.13u
MP7800 (qb7783 storage7794 vdd vdd) p12 w=1.5u l=0.13u
MN7801 (armtick4 qb7783 vss vss) n12 w=0.5u l=0.13u
MP7802 (armtick4 qb7783 vdd vdd) p12 w=1.5u l=0.13u
MN7803 (storage7794 n7536 vss vss) n12 w=2u l=0.13u
MN7806 (n7804 armtick5 n7805 vss) n12 w=1.6u l=0.13u
MN7807 (n7805 n7778 vss vss) n12 w=1.6u l=0.13u
MP7808 (n7804 armtick5 vdd vdd) p12 w=2.4u l=0.13u
MP7809 (n7804 n7778 vdd vdd) p12 w=2.4u l=0.13u
MN7812 (n7810 armtick5 n7811 vss) n12 w=1.6u l=0.13u
MN7813 (n7811 n7804 vss vss) n12 w=1.6u l=0.13u
MP7814 (n7810 armtick5 vdd vdd) p12 w=2.4u l=0.13u
MP7815 (n7810 n7804 vdd vdd) p12 w=2.4u l=0.13u
MN7818 (n7816 n7778 n7817 vss) n12 w=1.6u l=0.13u
MN7819 (n7817 n7804 vss vss) n12 w=1.6u l=0.13u
MP7820 (n7816 n7778 vdd vdd) p12 w=2.4u l=0.13u
MP7821 (n7816 n7804 vdd vdd) p12 w=2.4u l=0.13u
MN7824 (n7822 n7810 n7823 vss) n12 w=1.6u l=0.13u
MN7825 (n7823 n7816 vss vss) n12 w=1.6u l=0.13u
MP7826 (n7822 n7810 vdd vdd) p12 w=2.4u l=0.13u
MP7827 (n7822 n7816 vdd vdd) p12 w=2.4u l=0.13u
MN7829 (n7828 n7804 vss vss) n12 w=0.8u l=0.13u
MP7830 (n7828 n7804 vdd vdd) p12 w=2.4u l=0.13u
MN7835 (n7822 clk_low7545 storage7834 vss) n12 w=1.2u l=0.13u
MP7836 (n7822 clk_lowb7546 storage7834 vdd) p12 w=3.6u l=0.13u
MN7837 (qm7831 clk_high7547 storage7834 vss) n12 w=1.2u l=0.13u
MP7838 (qm7831 clk_highb7548 storage7834 vdd) p12 w=3.6u l=0.13u
MN7839 (qmb7832 storage7834 vss vss) n12 w=0.5u l=0.13u
MP7840 (qmb7832 storage7834 vdd vdd) p12 w=1.5u l=0.13u
MN7841 (qm7831 qmb7832 vss vss) n12 w=0.5u l=0.13u
MP7842 (qm7831 qmb7832 vdd vdd) p12 w=1.5u l=0.13u
MN7843 (storage7834 n7536 vss vss) n12 w=2u l=0.13u
MN7845 (qm7831 clk_high7547 storage7844 vss) n12 w=1.2u l=0.13u
MP7846 (qm7831 clk_highb7548 storage7844 vdd) p12 w=3.6u l=0.13u
MN7847 (armtick5 clk_low7545 storage7844 vss) n12 w=1.2u l=0.13u
MP7848 (armtick5 clk_lowb7546 storage7844 vdd) p12 w=3.6u l=0.13u
MN7849 (qb7833 storage7844 vss vss) n12 w=0.5u l=0.13u
MP7850 (qb7833 storage7844 vdd vdd) p12 w=1.5u l=0.13u
MN7851 (armtick5 qb7833 vss vss) n12 w=0.5u l=0.13u
MP7852 (armtick5 qb7833 vdd vdd) p12 w=1.5u l=0.13u
MN7853 (storage7844 n7536 vss vss) n12 w=2u l=0.13u
MN7856 (n7854 arm n7855 vss) n12 w=1.6u l=0.13u
MN7857 (n7855 epoch_valid vss vss) n12 w=1.6u l=0.13u
MP7858 (n7854 arm vdd vdd) p12 w=2.4u l=0.13u
MP7859 (n7854 epoch_valid vdd vdd) p12 w=2.4u l=0.13u
MN7861 (n7860 n7854 vss vss) n12 w=0.8u l=0.13u
MP7862 (n7860 n7854 vdd vdd) p12 w=2.4u l=0.13u
MN7864 (n7863 epoch_valid vss vss) n12 w=0.8u l=0.13u
MP7865 (n7863 epoch_valid vdd vdd) p12 w=2.4u l=0.13u
MN7868 (n7866 arm n7867 vss) n12 w=1.6u l=0.13u
MN7869 (n7867 armtick5 vss vss) n12 w=1.6u l=0.13u
MP7870 (n7866 arm vdd vdd) p12 w=2.4u l=0.13u
MP7871 (n7866 armtick5 vdd vdd) p12 w=2.4u l=0.13u
MN7873 (n7872 n7866 vss vss) n12 w=0.8u l=0.13u
MP7874 (n7872 n7866 vdd vdd) p12 w=2.4u l=0.13u
MN7877 (n7875 n7863 n7876 vss) n12 w=1.6u l=0.13u
MN7878 (n7876 n7872 vss vss) n12 w=1.6u l=0.13u
MP7879 (n7875 n7863 vdd vdd) p12 w=2.4u l=0.13u
MP7880 (n7875 n7872 vdd vdd) p12 w=2.4u l=0.13u
MN7882 (n7881 n7875 vss vss) n12 w=0.8u l=0.13u
MP7883 (n7881 n7875 vdd vdd) p12 w=2.4u l=0.13u
MN7885 (n7884 drain vss vss) n12 w=0.8u l=0.13u
MP7886 (n7884 drain vdd vdd) p12 w=2.4u l=0.13u
MN7889 (n7887 n7884 vss vss) n12 w=0.8u l=0.13u
MN7890 (n7887 rst vss vss) n12 w=0.8u l=0.13u
MP7891 (n7887 n7884 n7888 vdd) p12 w=4.8u l=0.13u
MP7892 (n7888 rst vdd vdd) p12 w=4.8u l=0.13u
MN7894 (n7893 n7887 vss vss) n12 w=0.8u l=0.13u
MP7895 (n7893 n7887 vdd vdd) p12 w=2.4u l=0.13u
MN7897 (n7896 draintick0 vss vss) n12 w=0.8u l=0.13u
MP7898 (n7896 draintick0 vdd vdd) p12 w=2.4u l=0.13u
MN7900 (n7899 n7893 vss vss) n12 w=0.8u l=0.13u
MP7901 (n7899 n7893 vdd vdd) p12 w=2.4u l=0.13u
MN7910 (n7906 n22 n7907 vss) n12 w=3.2u l=0.13u
MP7911 (n7906 n22 vdd vdd) p12 w=2.4u l=0.13u
MN7912 (n7907 n102 n7908 vss) n12 w=3.2u l=0.13u
MP7913 (n7906 n102 vdd vdd) p12 w=2.4u l=0.13u
MN7914 (n7908 clk_highb7905 n7909 vss) n12 w=3.2u l=0.13u
MP7915 (n7906 clk_highb7905 vdd vdd) p12 w=2.4u l=0.13u
MN7916 (n7909 n7899 vss vss) n12 w=3.2u l=0.13u
MP7917 (n7906 n7899 vdd vdd) p12 w=2.4u l=0.13u
MN7922 (n7918 n19 n7919 vss) n12 w=3.2u l=0.13u
MP7923 (n7918 n19 vdd vdd) p12 w=2.4u l=0.13u
MN7924 (n7919 delay99 n7920 vss) n12 w=3.2u l=0.13u
MP7925 (n7918 delay99 vdd vdd) p12 w=2.4u l=0.13u
MN7926 (n7920 clk_lowb7903 n7921 vss) n12 w=3.2u l=0.13u
MP7927 (n7918 clk_lowb7903 vdd vdd) p12 w=2.4u l=0.13u
MN7928 (n7921 n7899 vss vss) n12 w=3.2u l=0.13u
MP7929 (n7918 n7899 vdd vdd) p12 w=2.4u l=0.13u
MN7930 (clk_low7902 n7906 vss vss) n12 w=8u l=0.13u
MP7931 (clk_low7902 n7906 vdd vdd) p12 w=24u l=0.13u
MN7932 (clk_lowb7903 clk_low7902 vss vss) n12 w=8u l=0.13u
MP7933 (clk_lowb7903 clk_low7902 vdd vdd) p12 w=24u l=0.13u
MN7934 (clk_high7904 n7918 vss vss) n12 w=8u l=0.13u
MP7935 (clk_high7904 n7918 vdd vdd) p12 w=24u l=0.13u
MN7936 (clk_highb7905 clk_high7904 vss vss) n12 w=8u l=0.13u
MP7937 (clk_highb7905 clk_high7904 vdd vdd) p12 w=24u l=0.13u
MN7942 (n7896 clk_low7902 storage7941 vss) n12 w=1.2u l=0.13u
MP7943 (n7896 clk_lowb7903 storage7941 vdd) p12 w=3.6u l=0.13u
MN7944 (qm7938 clk_high7904 storage7941 vss) n12 w=1.2u l=0.13u
MP7945 (qm7938 clk_highb7905 storage7941 vdd) p12 w=3.6u l=0.13u
MN7946 (qmb7939 storage7941 vss vss) n12 w=0.5u l=0.13u
MP7947 (qmb7939 storage7941 vdd vdd) p12 w=1.5u l=0.13u
MN7948 (qm7938 qmb7939 vss vss) n12 w=0.5u l=0.13u
MP7949 (qm7938 qmb7939 vdd vdd) p12 w=1.5u l=0.13u
MN7950 (storage7941 n7893 vss vss) n12 w=2u l=0.13u
MN7952 (qm7938 clk_high7904 storage7951 vss) n12 w=1.2u l=0.13u
MP7953 (qm7938 clk_highb7905 storage7951 vdd) p12 w=3.6u l=0.13u
MN7954 (draintick0 clk_low7902 storage7951 vss) n12 w=1.2u l=0.13u
MP7955 (draintick0 clk_lowb7903 storage7951 vdd) p12 w=3.6u l=0.13u
MN7956 (qb7940 storage7951 vss vss) n12 w=0.5u l=0.13u
MP7957 (qb7940 storage7951 vdd vdd) p12 w=1.5u l=0.13u
MN7958 (draintick0 qb7940 vss vss) n12 w=0.5u l=0.13u
MP7959 (draintick0 qb7940 vdd vdd) p12 w=1.5u l=0.13u
MN7960 (storage7951 n7893 vss vss) n12 w=2u l=0.13u
MN7963 (n7961 draintick0 n7962 vss) n12 w=1.6u l=0.13u
MN7964 (n7962 draintick1 vss vss) n12 w=1.6u l=0.13u
MP7965 (n7961 draintick0 vdd vdd) p12 w=2.4u l=0.13u
MP7966 (n7961 draintick1 vdd vdd) p12 w=2.4u l=0.13u
MN7969 (n7967 draintick0 n7968 vss) n12 w=1.6u l=0.13u
MN7970 (n7968 n7961 vss vss) n12 w=1.6u l=0.13u
MP7971 (n7967 draintick0 vdd vdd) p12 w=2.4u l=0.13u
MP7972 (n7967 n7961 vdd vdd) p12 w=2.4u l=0.13u
MN7975 (n7973 draintick1 n7974 vss) n12 w=1.6u l=0.13u
MN7976 (n7974 n7961 vss vss) n12 w=1.6u l=0.13u
MP7977 (n7973 draintick1 vdd vdd) p12 w=2.4u l=0.13u
MP7978 (n7973 n7961 vdd vdd) p12 w=2.4u l=0.13u
MN7981 (n7979 n7967 n7980 vss) n12 w=1.6u l=0.13u
MN7982 (n7980 n7973 vss vss) n12 w=1.6u l=0.13u
MP7983 (n7979 n7967 vdd vdd) p12 w=2.4u l=0.13u
MP7984 (n7979 n7973 vdd vdd) p12 w=2.4u l=0.13u
MN7986 (n7985 n7961 vss vss) n12 w=0.8u l=0.13u
MP7987 (n7985 n7961 vdd vdd) p12 w=2.4u l=0.13u
MN7992 (n7979 clk_low7902 storage7991 vss) n12 w=1.2u l=0.13u
MP7993 (n7979 clk_lowb7903 storage7991 vdd) p12 w=3.6u l=0.13u
MN7994 (qm7988 clk_high7904 storage7991 vss) n12 w=1.2u l=0.13u
MP7995 (qm7988 clk_highb7905 storage7991 vdd) p12 w=3.6u l=0.13u
MN7996 (qmb7989 storage7991 vss vss) n12 w=0.5u l=0.13u
MP7997 (qmb7989 storage7991 vdd vdd) p12 w=1.5u l=0.13u
MN7998 (qm7988 qmb7989 vss vss) n12 w=0.5u l=0.13u
MP7999 (qm7988 qmb7989 vdd vdd) p12 w=1.5u l=0.13u
MN8000 (storage7991 n7893 vss vss) n12 w=2u l=0.13u
MN8002 (qm7988 clk_high7904 storage8001 vss) n12 w=1.2u l=0.13u
MP8003 (qm7988 clk_highb7905 storage8001 vdd) p12 w=3.6u l=0.13u
MN8004 (draintick1 clk_low7902 storage8001 vss) n12 w=1.2u l=0.13u
MP8005 (draintick1 clk_lowb7903 storage8001 vdd) p12 w=3.6u l=0.13u
MN8006 (qb7990 storage8001 vss vss) n12 w=0.5u l=0.13u
MP8007 (qb7990 storage8001 vdd vdd) p12 w=1.5u l=0.13u
MN8008 (draintick1 qb7990 vss vss) n12 w=0.5u l=0.13u
MP8009 (draintick1 qb7990 vdd vdd) p12 w=1.5u l=0.13u
MN8010 (storage8001 n7893 vss vss) n12 w=2u l=0.13u
MN8013 (n8011 drain n8012 vss) n12 w=1.6u l=0.13u
MN8014 (n8012 draintick0 vss vss) n12 w=1.6u l=0.13u
MP8015 (n8011 drain vdd vdd) p12 w=2.4u l=0.13u
MP8016 (n8011 draintick0 vdd vdd) p12 w=2.4u l=0.13u
MN8018 (n8017 n8011 vss vss) n12 w=0.8u l=0.13u
MP8019 (n8017 n8011 vdd vdd) p12 w=2.4u l=0.13u
MN8021 (n8020 measuretick0 vss vss) n12 w=0.8u l=0.13u
MP8022 (n8020 measuretick0 vdd vdd) p12 w=2.4u l=0.13u
MN8027 (n8020 clk_low6032 storage8026 vss) n12 w=1.2u l=0.13u
MP8028 (n8020 clk_lowb6033 storage8026 vdd) p12 w=3.6u l=0.13u
MN8029 (qm8023 clk_high6034 storage8026 vss) n12 w=1.2u l=0.13u
MP8030 (qm8023 clk_highb6035 storage8026 vdd) p12 w=3.6u l=0.13u
MN8031 (qmb8024 storage8026 vss vss) n12 w=0.5u l=0.13u
MP8032 (qmb8024 storage8026 vdd vdd) p12 w=1.5u l=0.13u
MN8033 (qm8023 qmb8024 vss vss) n12 w=0.5u l=0.13u
MP8034 (qm8023 qmb8024 vdd vdd) p12 w=1.5u l=0.13u
MN8035 (storage8026 n6026 vss vss) n12 w=2u l=0.13u
MN8037 (qm8023 clk_high6034 storage8036 vss) n12 w=1.2u l=0.13u
MP8038 (qm8023 clk_highb6035 storage8036 vdd) p12 w=3.6u l=0.13u
MN8039 (measuretick0 clk_low6032 storage8036 vss) n12 w=1.2u l=0.13u
MP8040 (measuretick0 clk_lowb6033 storage8036 vdd) p12 w=3.6u l=0.13u
MN8041 (qb8025 storage8036 vss vss) n12 w=0.5u l=0.13u
MP8042 (qb8025 storage8036 vdd vdd) p12 w=1.5u l=0.13u
MN8043 (measuretick0 qb8025 vss vss) n12 w=0.5u l=0.13u
MP8044 (measuretick0 qb8025 vdd vdd) p12 w=1.5u l=0.13u
MN8045 (storage8036 n6026 vss vss) n12 w=2u l=0.13u
MN8048 (n8046 measuretick0 n8047 vss) n12 w=1.6u l=0.13u
MN8049 (n8047 measuretick1 vss vss) n12 w=1.6u l=0.13u
MP8050 (n8046 measuretick0 vdd vdd) p12 w=2.4u l=0.13u
MP8051 (n8046 measuretick1 vdd vdd) p12 w=2.4u l=0.13u
MN8054 (n8052 measuretick0 n8053 vss) n12 w=1.6u l=0.13u
MN8055 (n8053 n8046 vss vss) n12 w=1.6u l=0.13u
MP8056 (n8052 measuretick0 vdd vdd) p12 w=2.4u l=0.13u
MP8057 (n8052 n8046 vdd vdd) p12 w=2.4u l=0.13u
MN8060 (n8058 measuretick1 n8059 vss) n12 w=1.6u l=0.13u
MN8061 (n8059 n8046 vss vss) n12 w=1.6u l=0.13u
MP8062 (n8058 measuretick1 vdd vdd) p12 w=2.4u l=0.13u
MP8063 (n8058 n8046 vdd vdd) p12 w=2.4u l=0.13u
MN8066 (n8064 n8052 n8065 vss) n12 w=1.6u l=0.13u
MN8067 (n8065 n8058 vss vss) n12 w=1.6u l=0.13u
MP8068 (n8064 n8052 vdd vdd) p12 w=2.4u l=0.13u
MP8069 (n8064 n8058 vdd vdd) p12 w=2.4u l=0.13u
MN8071 (n8070 n8046 vss vss) n12 w=0.8u l=0.13u
MP8072 (n8070 n8046 vdd vdd) p12 w=2.4u l=0.13u
MN8077 (n8064 clk_low6032 storage8076 vss) n12 w=1.2u l=0.13u
MP8078 (n8064 clk_lowb6033 storage8076 vdd) p12 w=3.6u l=0.13u
MN8079 (qm8073 clk_high6034 storage8076 vss) n12 w=1.2u l=0.13u
MP8080 (qm8073 clk_highb6035 storage8076 vdd) p12 w=3.6u l=0.13u
MN8081 (qmb8074 storage8076 vss vss) n12 w=0.5u l=0.13u
MP8082 (qmb8074 storage8076 vdd vdd) p12 w=1.5u l=0.13u
MN8083 (qm8073 qmb8074 vss vss) n12 w=0.5u l=0.13u
MP8084 (qm8073 qmb8074 vdd vdd) p12 w=1.5u l=0.13u
MN8085 (storage8076 n6026 vss vss) n12 w=2u l=0.13u
MN8087 (qm8073 clk_high6034 storage8086 vss) n12 w=1.2u l=0.13u
MP8088 (qm8073 clk_highb6035 storage8086 vdd) p12 w=3.6u l=0.13u
MN8089 (measuretick1 clk_low6032 storage8086 vss) n12 w=1.2u l=0.13u
MP8090 (measuretick1 clk_lowb6033 storage8086 vdd) p12 w=3.6u l=0.13u
MN8091 (qb8075 storage8086 vss vss) n12 w=0.5u l=0.13u
MP8092 (qb8075 storage8086 vdd vdd) p12 w=1.5u l=0.13u
MN8093 (measuretick1 qb8075 vss vss) n12 w=0.5u l=0.13u
MP8094 (measuretick1 qb8075 vdd vdd) p12 w=1.5u l=0.13u
MN8095 (storage8086 n6026 vss vss) n12 w=2u l=0.13u
MN8098 (n8096 measuretick2 n8097 vss) n12 w=1.6u l=0.13u
MN8099 (n8097 n8070 vss vss) n12 w=1.6u l=0.13u
MP8100 (n8096 measuretick2 vdd vdd) p12 w=2.4u l=0.13u
MP8101 (n8096 n8070 vdd vdd) p12 w=2.4u l=0.13u
MN8104 (n8102 measuretick2 n8103 vss) n12 w=1.6u l=0.13u
MN8105 (n8103 n8096 vss vss) n12 w=1.6u l=0.13u
MP8106 (n8102 measuretick2 vdd vdd) p12 w=2.4u l=0.13u
MP8107 (n8102 n8096 vdd vdd) p12 w=2.4u l=0.13u
MN8110 (n8108 n8070 n8109 vss) n12 w=1.6u l=0.13u
MN8111 (n8109 n8096 vss vss) n12 w=1.6u l=0.13u
MP8112 (n8108 n8070 vdd vdd) p12 w=2.4u l=0.13u
MP8113 (n8108 n8096 vdd vdd) p12 w=2.4u l=0.13u
MN8116 (n8114 n8102 n8115 vss) n12 w=1.6u l=0.13u
MN8117 (n8115 n8108 vss vss) n12 w=1.6u l=0.13u
MP8118 (n8114 n8102 vdd vdd) p12 w=2.4u l=0.13u
MP8119 (n8114 n8108 vdd vdd) p12 w=2.4u l=0.13u
MN8121 (n8120 n8096 vss vss) n12 w=0.8u l=0.13u
MP8122 (n8120 n8096 vdd vdd) p12 w=2.4u l=0.13u
MN8127 (n8114 clk_low6032 storage8126 vss) n12 w=1.2u l=0.13u
MP8128 (n8114 clk_lowb6033 storage8126 vdd) p12 w=3.6u l=0.13u
MN8129 (qm8123 clk_high6034 storage8126 vss) n12 w=1.2u l=0.13u
MP8130 (qm8123 clk_highb6035 storage8126 vdd) p12 w=3.6u l=0.13u
MN8131 (qmb8124 storage8126 vss vss) n12 w=0.5u l=0.13u
MP8132 (qmb8124 storage8126 vdd vdd) p12 w=1.5u l=0.13u
MN8133 (qm8123 qmb8124 vss vss) n12 w=0.5u l=0.13u
MP8134 (qm8123 qmb8124 vdd vdd) p12 w=1.5u l=0.13u
MN8135 (storage8126 n6026 vss vss) n12 w=2u l=0.13u
MN8137 (qm8123 clk_high6034 storage8136 vss) n12 w=1.2u l=0.13u
MP8138 (qm8123 clk_highb6035 storage8136 vdd) p12 w=3.6u l=0.13u
MN8139 (measuretick2 clk_low6032 storage8136 vss) n12 w=1.2u l=0.13u
MP8140 (measuretick2 clk_lowb6033 storage8136 vdd) p12 w=3.6u l=0.13u
MN8141 (qb8125 storage8136 vss vss) n12 w=0.5u l=0.13u
MP8142 (qb8125 storage8136 vdd vdd) p12 w=1.5u l=0.13u
MN8143 (measuretick2 qb8125 vss vss) n12 w=0.5u l=0.13u
MP8144 (measuretick2 qb8125 vdd vdd) p12 w=1.5u l=0.13u
MN8145 (storage8136 n6026 vss vss) n12 w=2u l=0.13u
MN8148 (n8146 measuretick3 n8147 vss) n12 w=1.6u l=0.13u
MN8149 (n8147 n8120 vss vss) n12 w=1.6u l=0.13u
MP8150 (n8146 measuretick3 vdd vdd) p12 w=2.4u l=0.13u
MP8151 (n8146 n8120 vdd vdd) p12 w=2.4u l=0.13u
MN8154 (n8152 measuretick3 n8153 vss) n12 w=1.6u l=0.13u
MN8155 (n8153 n8146 vss vss) n12 w=1.6u l=0.13u
MP8156 (n8152 measuretick3 vdd vdd) p12 w=2.4u l=0.13u
MP8157 (n8152 n8146 vdd vdd) p12 w=2.4u l=0.13u
MN8160 (n8158 n8120 n8159 vss) n12 w=1.6u l=0.13u
MN8161 (n8159 n8146 vss vss) n12 w=1.6u l=0.13u
MP8162 (n8158 n8120 vdd vdd) p12 w=2.4u l=0.13u
MP8163 (n8158 n8146 vdd vdd) p12 w=2.4u l=0.13u
MN8166 (n8164 n8152 n8165 vss) n12 w=1.6u l=0.13u
MN8167 (n8165 n8158 vss vss) n12 w=1.6u l=0.13u
MP8168 (n8164 n8152 vdd vdd) p12 w=2.4u l=0.13u
MP8169 (n8164 n8158 vdd vdd) p12 w=2.4u l=0.13u
MN8171 (n8170 n8146 vss vss) n12 w=0.8u l=0.13u
MP8172 (n8170 n8146 vdd vdd) p12 w=2.4u l=0.13u
MN8177 (n8164 clk_low6032 storage8176 vss) n12 w=1.2u l=0.13u
MP8178 (n8164 clk_lowb6033 storage8176 vdd) p12 w=3.6u l=0.13u
MN8179 (qm8173 clk_high6034 storage8176 vss) n12 w=1.2u l=0.13u
MP8180 (qm8173 clk_highb6035 storage8176 vdd) p12 w=3.6u l=0.13u
MN8181 (qmb8174 storage8176 vss vss) n12 w=0.5u l=0.13u
MP8182 (qmb8174 storage8176 vdd vdd) p12 w=1.5u l=0.13u
MN8183 (qm8173 qmb8174 vss vss) n12 w=0.5u l=0.13u
MP8184 (qm8173 qmb8174 vdd vdd) p12 w=1.5u l=0.13u
MN8185 (storage8176 n6026 vss vss) n12 w=2u l=0.13u
MN8187 (qm8173 clk_high6034 storage8186 vss) n12 w=1.2u l=0.13u
MP8188 (qm8173 clk_highb6035 storage8186 vdd) p12 w=3.6u l=0.13u
MN8189 (measuretick3 clk_low6032 storage8186 vss) n12 w=1.2u l=0.13u
MP8190 (measuretick3 clk_lowb6033 storage8186 vdd) p12 w=3.6u l=0.13u
MN8191 (qb8175 storage8186 vss vss) n12 w=0.5u l=0.13u
MP8192 (qb8175 storage8186 vdd vdd) p12 w=1.5u l=0.13u
MN8193 (measuretick3 qb8175 vss vss) n12 w=0.5u l=0.13u
MP8194 (measuretick3 qb8175 vdd vdd) p12 w=1.5u l=0.13u
MN8195 (storage8186 n6026 vss vss) n12 w=2u l=0.13u
MN8198 (n8196 measuretick4 n8197 vss) n12 w=1.6u l=0.13u
MN8199 (n8197 n8170 vss vss) n12 w=1.6u l=0.13u
MP8200 (n8196 measuretick4 vdd vdd) p12 w=2.4u l=0.13u
MP8201 (n8196 n8170 vdd vdd) p12 w=2.4u l=0.13u
MN8204 (n8202 measuretick4 n8203 vss) n12 w=1.6u l=0.13u
MN8205 (n8203 n8196 vss vss) n12 w=1.6u l=0.13u
MP8206 (n8202 measuretick4 vdd vdd) p12 w=2.4u l=0.13u
MP8207 (n8202 n8196 vdd vdd) p12 w=2.4u l=0.13u
MN8210 (n8208 n8170 n8209 vss) n12 w=1.6u l=0.13u
MN8211 (n8209 n8196 vss vss) n12 w=1.6u l=0.13u
MP8212 (n8208 n8170 vdd vdd) p12 w=2.4u l=0.13u
MP8213 (n8208 n8196 vdd vdd) p12 w=2.4u l=0.13u
MN8216 (n8214 n8202 n8215 vss) n12 w=1.6u l=0.13u
MN8217 (n8215 n8208 vss vss) n12 w=1.6u l=0.13u
MP8218 (n8214 n8202 vdd vdd) p12 w=2.4u l=0.13u
MP8219 (n8214 n8208 vdd vdd) p12 w=2.4u l=0.13u
MN8221 (n8220 n8196 vss vss) n12 w=0.8u l=0.13u
MP8222 (n8220 n8196 vdd vdd) p12 w=2.4u l=0.13u
MN8227 (n8214 clk_low6032 storage8226 vss) n12 w=1.2u l=0.13u
MP8228 (n8214 clk_lowb6033 storage8226 vdd) p12 w=3.6u l=0.13u
MN8229 (qm8223 clk_high6034 storage8226 vss) n12 w=1.2u l=0.13u
MP8230 (qm8223 clk_highb6035 storage8226 vdd) p12 w=3.6u l=0.13u
MN8231 (qmb8224 storage8226 vss vss) n12 w=0.5u l=0.13u
MP8232 (qmb8224 storage8226 vdd vdd) p12 w=1.5u l=0.13u
MN8233 (qm8223 qmb8224 vss vss) n12 w=0.5u l=0.13u
MP8234 (qm8223 qmb8224 vdd vdd) p12 w=1.5u l=0.13u
MN8235 (storage8226 n6026 vss vss) n12 w=2u l=0.13u
MN8237 (qm8223 clk_high6034 storage8236 vss) n12 w=1.2u l=0.13u
MP8238 (qm8223 clk_highb6035 storage8236 vdd) p12 w=3.6u l=0.13u
MN8239 (measuretick4 clk_low6032 storage8236 vss) n12 w=1.2u l=0.13u
MP8240 (measuretick4 clk_lowb6033 storage8236 vdd) p12 w=3.6u l=0.13u
MN8241 (qb8225 storage8236 vss vss) n12 w=0.5u l=0.13u
MP8242 (qb8225 storage8236 vdd vdd) p12 w=1.5u l=0.13u
MN8243 (measuretick4 qb8225 vss vss) n12 w=0.5u l=0.13u
MP8244 (measuretick4 qb8225 vdd vdd) p12 w=1.5u l=0.13u
MN8245 (storage8236 n6026 vss vss) n12 w=2u l=0.13u
MN8248 (n8246 measuretick5 n8247 vss) n12 w=1.6u l=0.13u
MN8249 (n8247 n8220 vss vss) n12 w=1.6u l=0.13u
MP8250 (n8246 measuretick5 vdd vdd) p12 w=2.4u l=0.13u
MP8251 (n8246 n8220 vdd vdd) p12 w=2.4u l=0.13u
MN8254 (n8252 measuretick5 n8253 vss) n12 w=1.6u l=0.13u
MN8255 (n8253 n8246 vss vss) n12 w=1.6u l=0.13u
MP8256 (n8252 measuretick5 vdd vdd) p12 w=2.4u l=0.13u
MP8257 (n8252 n8246 vdd vdd) p12 w=2.4u l=0.13u
MN8260 (n8258 n8220 n8259 vss) n12 w=1.6u l=0.13u
MN8261 (n8259 n8246 vss vss) n12 w=1.6u l=0.13u
MP8262 (n8258 n8220 vdd vdd) p12 w=2.4u l=0.13u
MP8263 (n8258 n8246 vdd vdd) p12 w=2.4u l=0.13u
MN8266 (n8264 n8252 n8265 vss) n12 w=1.6u l=0.13u
MN8267 (n8265 n8258 vss vss) n12 w=1.6u l=0.13u
MP8268 (n8264 n8252 vdd vdd) p12 w=2.4u l=0.13u
MP8269 (n8264 n8258 vdd vdd) p12 w=2.4u l=0.13u
MN8271 (n8270 n8246 vss vss) n12 w=0.8u l=0.13u
MP8272 (n8270 n8246 vdd vdd) p12 w=2.4u l=0.13u
MN8277 (n8264 clk_low6032 storage8276 vss) n12 w=1.2u l=0.13u
MP8278 (n8264 clk_lowb6033 storage8276 vdd) p12 w=3.6u l=0.13u
MN8279 (qm8273 clk_high6034 storage8276 vss) n12 w=1.2u l=0.13u
MP8280 (qm8273 clk_highb6035 storage8276 vdd) p12 w=3.6u l=0.13u
MN8281 (qmb8274 storage8276 vss vss) n12 w=0.5u l=0.13u
MP8282 (qmb8274 storage8276 vdd vdd) p12 w=1.5u l=0.13u
MN8283 (qm8273 qmb8274 vss vss) n12 w=0.5u l=0.13u
MP8284 (qm8273 qmb8274 vdd vdd) p12 w=1.5u l=0.13u
MN8285 (storage8276 n6026 vss vss) n12 w=2u l=0.13u
MN8287 (qm8273 clk_high6034 storage8286 vss) n12 w=1.2u l=0.13u
MP8288 (qm8273 clk_highb6035 storage8286 vdd) p12 w=3.6u l=0.13u
MN8289 (measuretick5 clk_low6032 storage8286 vss) n12 w=1.2u l=0.13u
MP8290 (measuretick5 clk_lowb6033 storage8286 vdd) p12 w=3.6u l=0.13u
MN8291 (qb8275 storage8286 vss vss) n12 w=0.5u l=0.13u
MP8292 (qb8275 storage8286 vdd vdd) p12 w=1.5u l=0.13u
MN8293 (measuretick5 qb8275 vss vss) n12 w=0.5u l=0.13u
MP8294 (measuretick5 qb8275 vdd vdd) p12 w=1.5u l=0.13u
MN8295 (storage8286 n6026 vss vss) n12 w=2u l=0.13u
MN8298 (n8296 measuretick6 n8297 vss) n12 w=1.6u l=0.13u
MN8299 (n8297 n8270 vss vss) n12 w=1.6u l=0.13u
MP8300 (n8296 measuretick6 vdd vdd) p12 w=2.4u l=0.13u
MP8301 (n8296 n8270 vdd vdd) p12 w=2.4u l=0.13u
MN8304 (n8302 measuretick6 n8303 vss) n12 w=1.6u l=0.13u
MN8305 (n8303 n8296 vss vss) n12 w=1.6u l=0.13u
MP8306 (n8302 measuretick6 vdd vdd) p12 w=2.4u l=0.13u
MP8307 (n8302 n8296 vdd vdd) p12 w=2.4u l=0.13u
MN8310 (n8308 n8270 n8309 vss) n12 w=1.6u l=0.13u
MN8311 (n8309 n8296 vss vss) n12 w=1.6u l=0.13u
MP8312 (n8308 n8270 vdd vdd) p12 w=2.4u l=0.13u
MP8313 (n8308 n8296 vdd vdd) p12 w=2.4u l=0.13u
MN8316 (n8314 n8302 n8315 vss) n12 w=1.6u l=0.13u
MN8317 (n8315 n8308 vss vss) n12 w=1.6u l=0.13u
MP8318 (n8314 n8302 vdd vdd) p12 w=2.4u l=0.13u
MP8319 (n8314 n8308 vdd vdd) p12 w=2.4u l=0.13u
MN8321 (n8320 n8296 vss vss) n12 w=0.8u l=0.13u
MP8322 (n8320 n8296 vdd vdd) p12 w=2.4u l=0.13u
MN8327 (n8314 clk_low6032 storage8326 vss) n12 w=1.2u l=0.13u
MP8328 (n8314 clk_lowb6033 storage8326 vdd) p12 w=3.6u l=0.13u
MN8329 (qm8323 clk_high6034 storage8326 vss) n12 w=1.2u l=0.13u
MP8330 (qm8323 clk_highb6035 storage8326 vdd) p12 w=3.6u l=0.13u
MN8331 (qmb8324 storage8326 vss vss) n12 w=0.5u l=0.13u
MP8332 (qmb8324 storage8326 vdd vdd) p12 w=1.5u l=0.13u
MN8333 (qm8323 qmb8324 vss vss) n12 w=0.5u l=0.13u
MP8334 (qm8323 qmb8324 vdd vdd) p12 w=1.5u l=0.13u
MN8335 (storage8326 n6026 vss vss) n12 w=2u l=0.13u
MN8337 (qm8323 clk_high6034 storage8336 vss) n12 w=1.2u l=0.13u
MP8338 (qm8323 clk_highb6035 storage8336 vdd) p12 w=3.6u l=0.13u
MN8339 (measuretick6 clk_low6032 storage8336 vss) n12 w=1.2u l=0.13u
MP8340 (measuretick6 clk_lowb6033 storage8336 vdd) p12 w=3.6u l=0.13u
MN8341 (qb8325 storage8336 vss vss) n12 w=0.5u l=0.13u
MP8342 (qb8325 storage8336 vdd vdd) p12 w=1.5u l=0.13u
MN8343 (measuretick6 qb8325 vss vss) n12 w=0.5u l=0.13u
MP8344 (measuretick6 qb8325 vdd vdd) p12 w=1.5u l=0.13u
MN8345 (storage8336 n6026 vss vss) n12 w=2u l=0.13u
MN8348 (n8346 measuretick7 n8347 vss) n12 w=1.6u l=0.13u
MN8349 (n8347 n8320 vss vss) n12 w=1.6u l=0.13u
MP8350 (n8346 measuretick7 vdd vdd) p12 w=2.4u l=0.13u
MP8351 (n8346 n8320 vdd vdd) p12 w=2.4u l=0.13u
MN8354 (n8352 measuretick7 n8353 vss) n12 w=1.6u l=0.13u
MN8355 (n8353 n8346 vss vss) n12 w=1.6u l=0.13u
MP8356 (n8352 measuretick7 vdd vdd) p12 w=2.4u l=0.13u
MP8357 (n8352 n8346 vdd vdd) p12 w=2.4u l=0.13u
MN8360 (n8358 n8320 n8359 vss) n12 w=1.6u l=0.13u
MN8361 (n8359 n8346 vss vss) n12 w=1.6u l=0.13u
MP8362 (n8358 n8320 vdd vdd) p12 w=2.4u l=0.13u
MP8363 (n8358 n8346 vdd vdd) p12 w=2.4u l=0.13u
MN8366 (n8364 n8352 n8365 vss) n12 w=1.6u l=0.13u
MN8367 (n8365 n8358 vss vss) n12 w=1.6u l=0.13u
MP8368 (n8364 n8352 vdd vdd) p12 w=2.4u l=0.13u
MP8369 (n8364 n8358 vdd vdd) p12 w=2.4u l=0.13u
MN8371 (n8370 n8346 vss vss) n12 w=0.8u l=0.13u
MP8372 (n8370 n8346 vdd vdd) p12 w=2.4u l=0.13u
MN8377 (n8364 clk_low6032 storage8376 vss) n12 w=1.2u l=0.13u
MP8378 (n8364 clk_lowb6033 storage8376 vdd) p12 w=3.6u l=0.13u
MN8379 (qm8373 clk_high6034 storage8376 vss) n12 w=1.2u l=0.13u
MP8380 (qm8373 clk_highb6035 storage8376 vdd) p12 w=3.6u l=0.13u
MN8381 (qmb8374 storage8376 vss vss) n12 w=0.5u l=0.13u
MP8382 (qmb8374 storage8376 vdd vdd) p12 w=1.5u l=0.13u
MN8383 (qm8373 qmb8374 vss vss) n12 w=0.5u l=0.13u
MP8384 (qm8373 qmb8374 vdd vdd) p12 w=1.5u l=0.13u
MN8385 (storage8376 n6026 vss vss) n12 w=2u l=0.13u
MN8387 (qm8373 clk_high6034 storage8386 vss) n12 w=1.2u l=0.13u
MP8388 (qm8373 clk_highb6035 storage8386 vdd) p12 w=3.6u l=0.13u
MN8389 (measuretick7 clk_low6032 storage8386 vss) n12 w=1.2u l=0.13u
MP8390 (measuretick7 clk_lowb6033 storage8386 vdd) p12 w=3.6u l=0.13u
MN8391 (qb8375 storage8386 vss vss) n12 w=0.5u l=0.13u
MP8392 (qb8375 storage8386 vdd vdd) p12 w=1.5u l=0.13u
MN8393 (measuretick7 qb8375 vss vss) n12 w=0.5u l=0.13u
MP8394 (measuretick7 qb8375 vdd vdd) p12 w=1.5u l=0.13u
MN8395 (storage8386 n6026 vss vss) n12 w=2u l=0.13u
MN8398 (n8396 measure n8397 vss) n12 w=1.6u l=0.13u
MN8399 (n8397 measuretick7 vss vss) n12 w=1.6u l=0.13u
MP8400 (n8396 measure vdd vdd) p12 w=2.4u l=0.13u
MP8401 (n8396 measuretick7 vdd vdd) p12 w=2.4u l=0.13u
MN8403 (n8402 n8396 vss vss) n12 w=0.8u l=0.13u
MP8404 (n8402 n8396 vdd vdd) p12 w=2.4u l=0.13u
MN8407 (n8405 measuretick6 n8406 vss) n12 w=1.6u l=0.13u
MN8408 (n8406 n8402 vss vss) n12 w=1.6u l=0.13u
MP8409 (n8405 measuretick6 vdd vdd) p12 w=2.4u l=0.13u
MP8410 (n8405 n8402 vdd vdd) p12 w=2.4u l=0.13u
MN8412 (n8411 n8405 vss vss) n12 w=0.8u l=0.13u
MP8413 (n8411 n8405 vdd vdd) p12 w=2.4u l=0.13u
MN8415 (n8414 n8411 vss vss) n12 w=0.8u l=0.13u
MP8416 (n8414 n8411 vdd vdd) p12 w=2.4u l=0.13u
MN8418 (n8417 n8414 vss vss) n12 w=0.8u l=0.13u
MP8419 (n8417 n8414 vdd vdd) p12 w=2.4u l=0.13u
MN8421 (n8420 n8417 vss vss) n12 w=0.8u l=0.13u
MP8422 (n8420 n8417 vdd vdd) p12 w=2.4u l=0.13u
MN8423 (measure_watchdog n8420 vss vss) n12 w=0.8u l=0.13u
MP8424 (measure_watchdog n8420 vdd vdd) p12 w=2.4u l=0.13u
MN8427 (n8425 step1 vss vss) n12 w=0.8u l=0.13u
MN8428 (n8425 step2 vss vss) n12 w=0.8u l=0.13u
MP8429 (n8425 step1 n8426 vdd) p12 w=4.8u l=0.13u
MP8430 (n8426 step2 vdd vdd) p12 w=4.8u l=0.13u
MN8432 (n8431 n8425 vss vss) n12 w=0.8u l=0.13u
MP8433 (n8431 n8425 vdd vdd) p12 w=2.4u l=0.13u
MN8436 (n8434 step4 vss vss) n12 w=0.8u l=0.13u
MN8437 (n8434 step8 vss vss) n12 w=0.8u l=0.13u
MP8438 (n8434 step4 n8435 vdd) p12 w=4.8u l=0.13u
MP8439 (n8435 step8 vdd vdd) p12 w=4.8u l=0.13u
MN8441 (n8440 n8434 vss vss) n12 w=0.8u l=0.13u
MP8442 (n8440 n8434 vdd vdd) p12 w=2.4u l=0.13u
MN8445 (n8443 n8431 vss vss) n12 w=0.8u l=0.13u
MN8446 (n8443 n8440 vss vss) n12 w=0.8u l=0.13u
MP8447 (n8443 n8431 n8444 vdd) p12 w=4.8u l=0.13u
MP8448 (n8444 n8440 vdd vdd) p12 w=4.8u l=0.13u
MN8450 (n8449 n8443 vss vss) n12 w=0.8u l=0.13u
MP8451 (n8449 n8443 vdd vdd) p12 w=2.4u l=0.13u
MN8453 (n8452 n8449 vss vss) n12 w=0.8u l=0.13u
MP8454 (n8452 n8449 vdd vdd) p12 w=2.4u l=0.13u
MN8456 (n8455 s1 vss vss) n12 w=0.8u l=0.13u
MP8457 (n8455 s1 vdd vdd) p12 w=2.4u l=0.13u
MN8459 (n8458 s2 vss vss) n12 w=0.8u l=0.13u
MP8460 (n8458 s2 vdd vdd) p12 w=2.4u l=0.13u
MN8462 (n8461 s3 vss vss) n12 w=0.8u l=0.13u
MP8463 (n8461 s3 vdd vdd) p12 w=2.4u l=0.13u
MN8465 (n8464 s4 vss vss) n12 w=0.8u l=0.13u
MP8466 (n8464 s4 vdd vdd) p12 w=2.4u l=0.13u
MN8469 (n8467 n8455 n8468 vss) n12 w=1.6u l=0.13u
MN8470 (n8468 s0 vss vss) n12 w=1.6u l=0.13u
MP8471 (n8467 n8455 vdd vdd) p12 w=2.4u l=0.13u
MP8472 (n8467 s0 vdd vdd) p12 w=2.4u l=0.13u
MN8474 (n8473 n8467 vss vss) n12 w=0.8u l=0.13u
MP8475 (n8473 n8467 vdd vdd) p12 w=2.4u l=0.13u
MN8478 (n8476 n8458 n8477 vss) n12 w=1.6u l=0.13u
MN8479 (n8477 n8461 vss vss) n12 w=1.6u l=0.13u
MP8480 (n8476 n8458 vdd vdd) p12 w=2.4u l=0.13u
MP8481 (n8476 n8461 vdd vdd) p12 w=2.4u l=0.13u
MN8483 (n8482 n8476 vss vss) n12 w=0.8u l=0.13u
MP8484 (n8482 n8476 vdd vdd) p12 w=2.4u l=0.13u
MN8487 (n8485 n8473 n8486 vss) n12 w=1.6u l=0.13u
MN8488 (n8486 n8482 vss vss) n12 w=1.6u l=0.13u
MP8489 (n8485 n8473 vdd vdd) p12 w=2.4u l=0.13u
MP8490 (n8485 n8482 vdd vdd) p12 w=2.4u l=0.13u
MN8492 (n8491 n8485 vss vss) n12 w=0.8u l=0.13u
MP8493 (n8491 n8485 vdd vdd) p12 w=2.4u l=0.13u
MN8496 (n8494 n8464 n8495 vss) n12 w=1.6u l=0.13u
MN8497 (n8495 n8491 vss vss) n12 w=1.6u l=0.13u
MP8498 (n8494 n8464 vdd vdd) p12 w=2.4u l=0.13u
MP8499 (n8494 n8491 vdd vdd) p12 w=2.4u l=0.13u
MN8501 (n8500 n8494 vss vss) n12 w=0.8u l=0.13u
MP8502 (n8500 n8494 vdd vdd) p12 w=2.4u l=0.13u
MN8505 (n8503 s0 n8504 vss) n12 w=1.6u l=0.13u
MN8506 (n8504 s1 vss vss) n12 w=1.6u l=0.13u
MP8507 (n8503 s0 vdd vdd) p12 w=2.4u l=0.13u
MP8508 (n8503 s1 vdd vdd) p12 w=2.4u l=0.13u
MN8510 (n8509 n8503 vss vss) n12 w=0.8u l=0.13u
MP8511 (n8509 n8503 vdd vdd) p12 w=2.4u l=0.13u
MN8514 (n8512 s2 n8513 vss) n12 w=1.6u l=0.13u
MN8515 (n8513 s3 vss vss) n12 w=1.6u l=0.13u
MP8516 (n8512 s2 vdd vdd) p12 w=2.4u l=0.13u
MP8517 (n8512 s3 vdd vdd) p12 w=2.4u l=0.13u
MN8519 (n8518 n8512 vss vss) n12 w=0.8u l=0.13u
MP8520 (n8518 n8512 vdd vdd) p12 w=2.4u l=0.13u
MN8523 (n8521 n8509 n8522 vss) n12 w=1.6u l=0.13u
MN8524 (n8522 n8518 vss vss) n12 w=1.6u l=0.13u
MP8525 (n8521 n8509 vdd vdd) p12 w=2.4u l=0.13u
MP8526 (n8521 n8518 vdd vdd) p12 w=2.4u l=0.13u
MN8528 (n8527 n8521 vss vss) n12 w=0.8u l=0.13u
MP8529 (n8527 n8521 vdd vdd) p12 w=2.4u l=0.13u
MN8532 (n8530 n8527 n8531 vss) n12 w=1.6u l=0.13u
MN8533 (n8531 s4 vss vss) n12 w=1.6u l=0.13u
MP8534 (n8530 n8527 vdd vdd) p12 w=2.4u l=0.13u
MP8535 (n8530 s4 vdd vdd) p12 w=2.4u l=0.13u
MN8537 (n8536 n8530 vss vss) n12 w=0.8u l=0.13u
MP8538 (n8536 n8530 vdd vdd) p12 w=2.4u l=0.13u
MN8541 (n8539 n8500 n8540 vss) n12 w=1.6u l=0.13u
MN8542 (n8540 was_fast vss vss) n12 w=1.6u l=0.13u
MP8543 (n8539 n8500 vdd vdd) p12 w=2.4u l=0.13u
MP8544 (n8539 was_fast vdd vdd) p12 w=2.4u l=0.13u
MN8546 (n8545 n8539 vss vss) n12 w=0.8u l=0.13u
MP8547 (n8545 n8539 vdd vdd) p12 w=2.4u l=0.13u
MN8550 (n8548 n8536 n8549 vss) n12 w=1.6u l=0.13u
MN8551 (n8549 was_slow vss vss) n12 w=1.6u l=0.13u
MP8552 (n8548 n8536 vdd vdd) p12 w=2.4u l=0.13u
MP8553 (n8548 was_slow vdd vdd) p12 w=2.4u l=0.13u
MN8555 (n8554 n8548 vss vss) n12 w=0.8u l=0.13u
MP8556 (n8554 n8548 vdd vdd) p12 w=2.4u l=0.13u
MN8559 (n8557 n8545 vss vss) n12 w=0.8u l=0.13u
MN8560 (n8557 n8554 vss vss) n12 w=0.8u l=0.13u
MP8561 (n8557 n8545 n8558 vdd) p12 w=4.8u l=0.13u
MP8562 (n8558 n8554 vdd vdd) p12 w=4.8u l=0.13u
MN8564 (n8563 n8557 vss vss) n12 w=0.8u l=0.13u
MP8565 (n8563 n8557 vdd vdd) p12 w=2.4u l=0.13u
MN8568 (n8566 n8452 vss vss) n12 w=0.8u l=0.13u
MN8569 (n8566 was_near vss vss) n12 w=0.8u l=0.13u
MP8570 (n8566 n8452 n8567 vdd) p12 w=4.8u l=0.13u
MP8571 (n8567 was_near vdd vdd) p12 w=4.8u l=0.13u
MN8573 (n8572 n8566 vss vss) n12 w=0.8u l=0.13u
MP8574 (n8572 n8566 vdd vdd) p12 w=2.4u l=0.13u
MN8576 (n8575 n8563 vss vss) n12 w=0.8u l=0.13u
MP8577 (n8575 n8563 vdd vdd) p12 w=2.4u l=0.13u
MN8580 (n8578 n8017 n8579 vss) n12 w=1.6u l=0.13u
MN8581 (n8579 n8572 vss vss) n12 w=1.6u l=0.13u
MP8582 (n8578 n8017 vdd vdd) p12 w=2.4u l=0.13u
MP8583 (n8578 n8572 vdd vdd) p12 w=2.4u l=0.13u
MN8585 (n8584 n8578 vss vss) n12 w=0.8u l=0.13u
MP8586 (n8584 n8578 vdd vdd) p12 w=2.4u l=0.13u
MN8589 (n8587 n8575 n8588 vss) n12 w=1.6u l=0.13u
MN8590 (n8588 n8584 vss vss) n12 w=1.6u l=0.13u
MP8591 (n8587 n8575 vdd vdd) p12 w=2.4u l=0.13u
MP8592 (n8587 n8584 vdd vdd) p12 w=2.4u l=0.13u
MN8594 (n8593 n8587 vss vss) n12 w=0.8u l=0.13u
MP8595 (n8593 n8587 vdd vdd) p12 w=2.4u l=0.13u
MN8598 (n8596 measure n8597 vss) n12 w=1.6u l=0.13u
MN8599 (n8597 n6160 vss vss) n12 w=1.6u l=0.13u
MP8600 (n8596 measure vdd vdd) p12 w=2.4u l=0.13u
MP8601 (n8596 n6160 vdd vdd) p12 w=2.4u l=0.13u
MN8603 (n8602 n8596 vss vss) n12 w=0.8u l=0.13u
MP8604 (n8602 n8596 vdd vdd) p12 w=2.4u l=0.13u
MN8607 (n8605 n8563 n8606 vss) n12 w=1.6u l=0.13u
MN8608 (n8606 n8584 vss vss) n12 w=1.6u l=0.13u
MP8609 (n8605 n8563 vdd vdd) p12 w=2.4u l=0.13u
MP8610 (n8605 n8584 vdd vdd) p12 w=2.4u l=0.13u
MN8612 (n8611 n8605 vss vss) n12 w=0.8u l=0.13u
MP8613 (n8611 n8605 vdd vdd) p12 w=2.4u l=0.13u
MN8616 (n8614 n7881 vss vss) n12 w=0.8u l=0.13u
MN8617 (n8614 n8411 vss vss) n12 w=0.8u l=0.13u
MP8618 (n8614 n7881 n8615 vdd) p12 w=4.8u l=0.13u
MP8619 (n8615 n8411 vdd vdd) p12 w=4.8u l=0.13u
MN8621 (n8620 n8614 vss vss) n12 w=0.8u l=0.13u
MP8622 (n8620 n8614 vdd vdd) p12 w=2.4u l=0.13u
MN8625 (n8623 n8602 vss vss) n12 w=0.8u l=0.13u
MN8626 (n8623 n8611 vss vss) n12 w=0.8u l=0.13u
MP8627 (n8623 n8602 n8624 vdd) p12 w=4.8u l=0.13u
MP8628 (n8624 n8611 vdd vdd) p12 w=4.8u l=0.13u
MN8630 (n8629 n8623 vss vss) n12 w=0.8u l=0.13u
MP8631 (n8629 n8623 vdd vdd) p12 w=2.4u l=0.13u
MN8634 (n8632 n8620 vss vss) n12 w=0.8u l=0.13u
MN8635 (n8632 n8629 vss vss) n12 w=0.8u l=0.13u
MP8636 (n8632 n8620 n8633 vdd) p12 w=4.8u l=0.13u
MP8637 (n8633 n8629 vdd vdd) p12 w=4.8u l=0.13u
MN8639 (n8638 n8632 vss vss) n12 w=0.8u l=0.13u
MP8640 (n8638 n8632 vdd vdd) p12 w=2.4u l=0.13u
MN8643 (n8641 n6187 vss vss) n12 w=0.8u l=0.13u
MN8644 (n8641 n8638 vss vss) n12 w=0.8u l=0.13u
MP8645 (n8641 n6187 n8642 vdd) p12 w=4.8u l=0.13u
MP8646 (n8642 n8638 vdd vdd) p12 w=4.8u l=0.13u
MN8648 (n8647 n8641 vss vss) n12 w=0.8u l=0.13u
MP8649 (n8647 n8641 vdd vdd) p12 w=2.4u l=0.13u
MN8651 (n8650 n8647 vss vss) n12 w=0.8u l=0.13u
MP8652 (n8650 n8647 vdd vdd) p12 w=2.4u l=0.13u
MN8655 (n8653 n6187 vss vss) n12 w=0.8u l=0.13u
MN8656 (n8653 n7524 vss vss) n12 w=0.8u l=0.13u
MP8657 (n8653 n6187 n8654 vdd) p12 w=4.8u l=0.13u
MP8658 (n8654 n7524 vdd vdd) p12 w=4.8u l=0.13u
MN8660 (n8659 n8653 vss vss) n12 w=0.8u l=0.13u
MP8661 (n8659 n8653 vdd vdd) p12 w=2.4u l=0.13u
MN8664 (n8662 n8638 vss vss) n12 w=0.8u l=0.13u
MN8665 (n8662 n8659 vss vss) n12 w=0.8u l=0.13u
MP8666 (n8662 n8638 n8663 vdd) p12 w=4.8u l=0.13u
MP8667 (n8663 n8659 vdd vdd) p12 w=4.8u l=0.13u
MN8669 (n8668 n8662 vss vss) n12 w=0.8u l=0.13u
MP8670 (n8668 n8662 vdd vdd) p12 w=2.4u l=0.13u
MN8673 (n8671 n8650 n8672 vss) n12 w=1.6u l=0.13u
MN8674 (n8672 n8668 vss vss) n12 w=1.6u l=0.13u
MP8675 (n8671 n8650 vdd vdd) p12 w=2.4u l=0.13u
MP8676 (n8671 n8668 vdd vdd) p12 w=2.4u l=0.13u
MN8678 (n8677 n8668 vss vss) n12 w=0.8u l=0.13u
MP8679 (n8677 n8668 vdd vdd) p12 w=2.4u l=0.13u
MN8682 (n8680 count_run n8681 vss) n12 w=1.6u l=0.13u
MN8683 (n8681 n8677 vss vss) n12 w=1.6u l=0.13u
MP8684 (n8680 count_run vdd vdd) p12 w=2.4u l=0.13u
MP8685 (n8680 n8677 vdd vdd) p12 w=2.4u l=0.13u
MN8688 (n8686 n8671 n8687 vss) n12 w=1.6u l=0.13u
MN8689 (n8687 n8680 vss vss) n12 w=1.6u l=0.13u
MP8690 (n8686 n8671 vdd vdd) p12 w=2.4u l=0.13u
MP8691 (n8686 n8680 vdd vdd) p12 w=2.4u l=0.13u
MN8696 (n8686 clk_low108 storage8695 vss) n12 w=1.2u l=0.13u
MP8697 (n8686 clk_lowb109 storage8695 vdd) p12 w=3.6u l=0.13u
MN8698 (qm8692 clk_high110 storage8695 vss) n12 w=1.2u l=0.13u
MP8699 (qm8692 clk_highb111 storage8695 vdd) p12 w=3.6u l=0.13u
MN8700 (qmb8693 storage8695 vss vss) n12 w=0.5u l=0.13u
MP8701 (qmb8693 storage8695 vdd vdd) p12 w=1.5u l=0.13u
MN8702 (qm8692 qmb8693 vss vss) n12 w=0.5u l=0.13u
MP8703 (qm8692 qmb8693 vdd vdd) p12 w=1.5u l=0.13u
MN8704 (storage8695 rst vss vss) n12 w=2u l=0.13u
MN8706 (qm8692 clk_high110 storage8705 vss) n12 w=1.2u l=0.13u
MP8707 (qm8692 clk_highb111 storage8705 vdd) p12 w=3.6u l=0.13u
MN8708 (count_run clk_low108 storage8705 vss) n12 w=1.2u l=0.13u
MP8709 (count_run clk_lowb109 storage8705 vdd) p12 w=3.6u l=0.13u
MN8710 (qb8694 storage8705 vss vss) n12 w=0.5u l=0.13u
MP8711 (qb8694 storage8705 vdd vdd) p12 w=1.5u l=0.13u
MN8712 (count_run qb8694 vss vss) n12 w=0.5u l=0.13u
MP8713 (count_run qb8694 vdd vdd) p12 w=1.5u l=0.13u
MN8714 (storage8705 rst vss vss) n12 w=2u l=0.13u
MN8716 (n8715 n8593 vss vss) n12 w=0.8u l=0.13u
MP8717 (n8715 n8593 vdd vdd) p12 w=2.4u l=0.13u
MN8720 (n8718 done n8719 vss) n12 w=1.6u l=0.13u
MN8721 (n8719 n8715 vss vss) n12 w=1.6u l=0.13u
MP8722 (n8718 done vdd vdd) p12 w=2.4u l=0.13u
MP8723 (n8718 n8715 vdd vdd) p12 w=2.4u l=0.13u
MN8726 (n8724 n8715 n8725 vss) n12 w=1.6u l=0.13u
MN8727 (n8725 n8718 vss vss) n12 w=1.6u l=0.13u
MP8728 (n8724 n8715 vdd vdd) p12 w=2.4u l=0.13u
MP8729 (n8724 n8718 vdd vdd) p12 w=2.4u l=0.13u
MN8734 (n8724 clk_low108 storage8733 vss) n12 w=1.2u l=0.13u
MP8735 (n8724 clk_lowb109 storage8733 vdd) p12 w=3.6u l=0.13u
MN8736 (qm8730 clk_high110 storage8733 vss) n12 w=1.2u l=0.13u
MP8737 (qm8730 clk_highb111 storage8733 vdd) p12 w=3.6u l=0.13u
MN8738 (qmb8731 storage8733 vss vss) n12 w=0.5u l=0.13u
MP8739 (qmb8731 storage8733 vdd vdd) p12 w=1.5u l=0.13u
MN8740 (qm8730 qmb8731 vss vss) n12 w=0.5u l=0.13u
MP8741 (qm8730 qmb8731 vdd vdd) p12 w=1.5u l=0.13u
MN8742 (storage8733 rst vss vss) n12 w=2u l=0.13u
MN8744 (qm8730 clk_high110 storage8743 vss) n12 w=1.2u l=0.13u
MP8745 (qm8730 clk_highb111 storage8743 vdd) p12 w=3.6u l=0.13u
MN8746 (done clk_low108 storage8743 vss) n12 w=1.2u l=0.13u
MP8747 (done clk_lowb109 storage8743 vdd) p12 w=3.6u l=0.13u
MN8748 (qb8732 storage8743 vss vss) n12 w=0.5u l=0.13u
MP8749 (qb8732 storage8743 vdd vdd) p12 w=1.5u l=0.13u
MN8750 (done qb8732 vss vss) n12 w=0.5u l=0.13u
MP8751 (done qb8732 vdd vdd) p12 w=1.5u l=0.13u
MN8752 (storage8743 rst vss vss) n12 w=2u l=0.13u
MN8754 (n8753 n8638 vss vss) n12 w=0.8u l=0.13u
MP8755 (n8753 n8638 vdd vdd) p12 w=2.4u l=0.13u
MN8758 (n8756 fail n8757 vss) n12 w=1.6u l=0.13u
MN8759 (n8757 n8753 vss vss) n12 w=1.6u l=0.13u
MP8760 (n8756 fail vdd vdd) p12 w=2.4u l=0.13u
MP8761 (n8756 n8753 vdd vdd) p12 w=2.4u l=0.13u
MN8764 (n8762 n8753 n8763 vss) n12 w=1.6u l=0.13u
MN8765 (n8763 n8756 vss vss) n12 w=1.6u l=0.13u
MP8766 (n8762 n8753 vdd vdd) p12 w=2.4u l=0.13u
MP8767 (n8762 n8756 vdd vdd) p12 w=2.4u l=0.13u
MN8772 (n8762 clk_low108 storage8771 vss) n12 w=1.2u l=0.13u
MP8773 (n8762 clk_lowb109 storage8771 vdd) p12 w=3.6u l=0.13u
MN8774 (qm8768 clk_high110 storage8771 vss) n12 w=1.2u l=0.13u
MP8775 (qm8768 clk_highb111 storage8771 vdd) p12 w=3.6u l=0.13u
MN8776 (qmb8769 storage8771 vss vss) n12 w=0.5u l=0.13u
MP8777 (qmb8769 storage8771 vdd vdd) p12 w=1.5u l=0.13u
MN8778 (qm8768 qmb8769 vss vss) n12 w=0.5u l=0.13u
MP8779 (qm8768 qmb8769 vdd vdd) p12 w=1.5u l=0.13u
MN8780 (storage8771 rst vss vss) n12 w=2u l=0.13u
MN8782 (qm8768 clk_high110 storage8781 vss) n12 w=1.2u l=0.13u
MP8783 (qm8768 clk_highb111 storage8781 vdd) p12 w=3.6u l=0.13u
MN8784 (fail clk_low108 storage8781 vss) n12 w=1.2u l=0.13u
MP8785 (fail clk_lowb109 storage8781 vdd) p12 w=3.6u l=0.13u
MN8786 (qb8770 storage8781 vss vss) n12 w=0.5u l=0.13u
MP8787 (qb8770 storage8781 vdd vdd) p12 w=1.5u l=0.13u
MN8788 (fail qb8770 vss vss) n12 w=0.5u l=0.13u
MP8789 (fail qb8770 vdd vdd) p12 w=1.5u l=0.13u
MN8790 (storage8781 rst vss vss) n12 w=2u l=0.13u
MN8792 (n8791 n8572 vss vss) n12 w=0.8u l=0.13u
MP8793 (n8791 n8572 vdd vdd) p12 w=2.4u l=0.13u
MN8796 (n8794 n8017 n8795 vss) n12 w=1.6u l=0.13u
MN8797 (n8795 n8791 vss vss) n12 w=1.6u l=0.13u
MP8798 (n8794 n8017 vdd vdd) p12 w=2.4u l=0.13u
MP8799 (n8794 n8791 vdd vdd) p12 w=2.4u l=0.13u
MN8801 (n8800 n8794 vss vss) n12 w=0.8u l=0.13u
MP8802 (n8800 n8794 vdd vdd) p12 w=2.4u l=0.13u
MN8805 (n8803 n66 vss vss) n12 w=0.8u l=0.13u
MN8806 (n8803 n8800 vss vss) n12 w=0.8u l=0.13u
MP8807 (n8803 n66 n8804 vdd) p12 w=4.8u l=0.13u
MP8808 (n8804 n8800 vdd vdd) p12 w=4.8u l=0.13u
MN8810 (n8809 n8803 vss vss) n12 w=0.8u l=0.13u
MP8811 (n8809 n8803 vdd vdd) p12 w=2.4u l=0.13u
MN8814 (n8812 n8593 vss vss) n12 w=0.8u l=0.13u
MN8815 (n8812 n8638 vss vss) n12 w=0.8u l=0.13u
MP8816 (n8812 n8593 n8813 vdd) p12 w=4.8u l=0.13u
MP8817 (n8813 n8638 vdd vdd) p12 w=4.8u l=0.13u
MN8819 (n8818 n8812 vss vss) n12 w=0.8u l=0.13u
MP8820 (n8818 n8812 vdd vdd) p12 w=2.4u l=0.13u
MN8823 (n8821 n8809 vss vss) n12 w=0.8u l=0.13u
MN8824 (n8821 n8818 vss vss) n12 w=0.8u l=0.13u
MP8825 (n8821 n8809 n8822 vdd) p12 w=4.8u l=0.13u
MP8826 (n8822 n8818 vdd vdd) p12 w=4.8u l=0.13u
MN8828 (n8827 n8821 vss vss) n12 w=0.8u l=0.13u
MP8829 (n8827 n8821 vdd vdd) p12 w=2.4u l=0.13u
MN8831 (n8830 n7524 vss vss) n12 w=0.8u l=0.13u
MP8832 (n8830 n7524 vdd vdd) p12 w=2.4u l=0.13u
MN8835 (n8833 n7524 vss vss) n12 w=0.8u l=0.13u
MN8836 (n8833 n8827 vss vss) n12 w=0.8u l=0.13u
MP8837 (n8833 n7524 n8834 vdd) p12 w=4.8u l=0.13u
MP8838 (n8834 n8827 vdd vdd) p12 w=4.8u l=0.13u
MN8840 (n8839 n8833 vss vss) n12 w=0.8u l=0.13u
MP8841 (n8839 n8833 vdd vdd) p12 w=2.4u l=0.13u
MN8844 (n8842 n8830 n8843 vss) n12 w=1.6u l=0.13u
MN8845 (n8843 n8839 vss vss) n12 w=1.6u l=0.13u
MP8846 (n8842 n8830 vdd vdd) p12 w=2.4u l=0.13u
MP8847 (n8842 n8839 vdd vdd) p12 w=2.4u l=0.13u
MN8849 (n8848 n8839 vss vss) n12 w=0.8u l=0.13u
MP8850 (n8848 n8839 vdd vdd) p12 w=2.4u l=0.13u
MN8853 (n8851 count_rst n8852 vss) n12 w=1.6u l=0.13u
MN8854 (n8852 n8848 vss vss) n12 w=1.6u l=0.13u
MP8855 (n8851 count_rst vdd vdd) p12 w=2.4u l=0.13u
MP8856 (n8851 n8848 vdd vdd) p12 w=2.4u l=0.13u
MN8859 (n8857 n8842 n8858 vss) n12 w=1.6u l=0.13u
MN8860 (n8858 n8851 vss vss) n12 w=1.6u l=0.13u
MP8861 (n8857 n8842 vdd vdd) p12 w=2.4u l=0.13u
MP8862 (n8857 n8851 vdd vdd) p12 w=2.4u l=0.13u
MN8866 (n8865 n8857 vss vss) n12 w=0.8u l=0.13u
MP8867 (n8865 n8857 vdd vdd) p12 w=2.4u l=0.13u
MN8870 (n8865 clk_low108 storage8869 vss) n12 w=1.2u l=0.13u
MP8871 (n8865 clk_lowb109 storage8869 vdd) p12 w=3.6u l=0.13u
MN8872 (qm8863 clk_high110 storage8869 vss) n12 w=1.2u l=0.13u
MP8873 (qm8863 clk_highb111 storage8869 vdd) p12 w=3.6u l=0.13u
MN8874 (qmb8864 storage8869 vss vss) n12 w=0.5u l=0.13u
MP8875 (qmb8864 storage8869 vdd vdd) p12 w=1.5u l=0.13u
MN8876 (qm8863 qmb8864 vss vss) n12 w=0.5u l=0.13u
MP8877 (qm8863 qmb8864 vdd vdd) p12 w=1.5u l=0.13u
MN8878 (storage8869 rst vss vss) n12 w=2u l=0.13u
MN8880 (qm8863 clk_high110 storage8879 vss) n12 w=1.2u l=0.13u
MP8881 (qm8863 clk_highb111 storage8879 vdd) p12 w=3.6u l=0.13u
MN8882 (qneg8868 clk_low108 storage8879 vss) n12 w=1.2u l=0.13u
MP8883 (qneg8868 clk_lowb109 storage8879 vdd) p12 w=3.6u l=0.13u
MN8884 (count_rst storage8879 vss vss) n12 w=0.5u l=0.13u
MP8885 (count_rst storage8879 vdd vdd) p12 w=1.5u l=0.13u
MN8886 (qneg8868 count_rst vss vss) n12 w=0.5u l=0.13u
MP8887 (qneg8868 count_rst vdd vdd) p12 w=1.5u l=0.13u
MN8888 (storage8879 rst vss vss) n12 w=2u l=0.13u
MN8891 (n8889 s0 n8890 vss) n12 w=1.6u l=0.13u
MN8892 (n8890 step1 vss vss) n12 w=1.6u l=0.13u
MP8893 (n8889 s0 vdd vdd) p12 w=2.4u l=0.13u
MP8894 (n8889 step1 vdd vdd) p12 w=2.4u l=0.13u
MN8897 (n8895 n8889 n8896 vss) n12 w=1.6u l=0.13u
MN8898 (n8896 s0 vss vss) n12 w=1.6u l=0.13u
MP8899 (n8895 n8889 vdd vdd) p12 w=2.4u l=0.13u
MP8900 (n8895 s0 vdd vdd) p12 w=2.4u l=0.13u
MN8903 (n8901 n8889 n8902 vss) n12 w=1.6u l=0.13u
MN8904 (n8902 step1 vss vss) n12 w=1.6u l=0.13u
MP8905 (n8901 n8889 vdd vdd) p12 w=2.4u l=0.13u
MP8906 (n8901 step1 vdd vdd) p12 w=2.4u l=0.13u
MN8909 (n8907 n8895 n8908 vss) n12 w=1.6u l=0.13u
MN8910 (n8908 n8901 vss vss) n12 w=1.6u l=0.13u
MP8911 (n8907 n8895 vdd vdd) p12 w=2.4u l=0.13u
MP8912 (n8907 n8901 vdd vdd) p12 w=2.4u l=0.13u
MN8915 (n8913 n8800 n8914 vss) n12 w=1.6u l=0.13u
MN8916 (n8914 n8907 vss vss) n12 w=1.6u l=0.13u
MP8917 (n8913 n8800 vdd vdd) p12 w=2.4u l=0.13u
MP8918 (n8913 n8907 vdd vdd) p12 w=2.4u l=0.13u
MN8920 (n8919 n8800 vss vss) n12 w=0.8u l=0.13u
MP8921 (n8919 n8800 vdd vdd) p12 w=2.4u l=0.13u
MN8924 (n8922 n8919 n8923 vss) n12 w=1.6u l=0.13u
MN8925 (n8923 s0 vss vss) n12 w=1.6u l=0.13u
MP8926 (n8922 n8919 vdd vdd) p12 w=2.4u l=0.13u
MP8927 (n8922 s0 vdd vdd) p12 w=2.4u l=0.13u
MN8930 (n8928 n8913 n8929 vss) n12 w=1.6u l=0.13u
MN8931 (n8929 n8922 vss vss) n12 w=1.6u l=0.13u
MP8932 (n8928 n8913 vdd vdd) p12 w=2.4u l=0.13u
MP8933 (n8928 n8922 vdd vdd) p12 w=2.4u l=0.13u
MN8938 (n8928 clk_low108 storage8937 vss) n12 w=1.2u l=0.13u
MP8939 (n8928 clk_lowb109 storage8937 vdd) p12 w=3.6u l=0.13u
MN8940 (qm8934 clk_high110 storage8937 vss) n12 w=1.2u l=0.13u
MP8941 (qm8934 clk_highb111 storage8937 vdd) p12 w=3.6u l=0.13u
MN8942 (qmb8935 storage8937 vss vss) n12 w=0.5u l=0.13u
MP8943 (qmb8935 storage8937 vdd vdd) p12 w=1.5u l=0.13u
MN8944 (qm8934 qmb8935 vss vss) n12 w=0.5u l=0.13u
MP8945 (qm8934 qmb8935 vdd vdd) p12 w=1.5u l=0.13u
MN8946 (storage8937 rst vss vss) n12 w=2u l=0.13u
MN8948 (qm8934 clk_high110 storage8947 vss) n12 w=1.2u l=0.13u
MP8949 (qm8934 clk_highb111 storage8947 vdd) p12 w=3.6u l=0.13u
MN8950 (s0 clk_low108 storage8947 vss) n12 w=1.2u l=0.13u
MP8951 (s0 clk_lowb109 storage8947 vdd) p12 w=3.6u l=0.13u
MN8952 (qb8936 storage8947 vss vss) n12 w=0.5u l=0.13u
MP8953 (qb8936 storage8947 vdd vdd) p12 w=1.5u l=0.13u
MN8954 (s0 qb8936 vss vss) n12 w=0.5u l=0.13u
MP8955 (s0 qb8936 vdd vdd) p12 w=1.5u l=0.13u
MN8956 (storage8947 rst vss vss) n12 w=2u l=0.13u
MN8958 (n8957 s0 vss vss) n12 w=0.8u l=0.13u
MP8959 (n8957 s0 vdd vdd) p12 w=2.4u l=0.13u
MN8962 (n8960 n8957 n8961 vss) n12 w=1.6u l=0.13u
MN8963 (n8961 step1 vss vss) n12 w=1.6u l=0.13u
MP8964 (n8960 n8957 vdd vdd) p12 w=2.4u l=0.13u
MP8965 (n8960 step1 vdd vdd) p12 w=2.4u l=0.13u
MN8967 (n8966 n8960 vss vss) n12 w=0.8u l=0.13u
MP8968 (n8966 n8960 vdd vdd) p12 w=2.4u l=0.13u
MN8970 (n8969 n8889 vss vss) n12 w=0.8u l=0.13u
MP8971 (n8969 n8889 vdd vdd) p12 w=2.4u l=0.13u
MN8974 (n8972 n8966 vss vss) n12 w=0.8u l=0.13u
MN8975 (n8972 step2 vss vss) n12 w=0.8u l=0.13u
MP8976 (n8972 n8966 n8973 vdd) p12 w=4.8u l=0.13u
MP8977 (n8973 step2 vdd vdd) p12 w=4.8u l=0.13u
MN8979 (n8978 n8972 vss vss) n12 w=0.8u l=0.13u
MP8980 (n8978 n8972 vdd vdd) p12 w=2.4u l=0.13u
MN8983 (n8981 n8969 vss vss) n12 w=0.8u l=0.13u
MN8984 (n8981 step2 vss vss) n12 w=0.8u l=0.13u
MP8985 (n8981 n8969 n8982 vdd) p12 w=4.8u l=0.13u
MP8986 (n8982 step2 vdd vdd) p12 w=4.8u l=0.13u
MN8988 (n8987 n8981 vss vss) n12 w=0.8u l=0.13u
MP8989 (n8987 n8981 vdd vdd) p12 w=2.4u l=0.13u
MN8992 (n8990 n8978 n8991 vss) n12 w=1.6u l=0.13u
MN8993 (n8991 was_fast vss vss) n12 w=1.6u l=0.13u
MP8994 (n8990 n8978 vdd vdd) p12 w=2.4u l=0.13u
MP8995 (n8990 was_fast vdd vdd) p12 w=2.4u l=0.13u
MN8997 (n8996 was_fast vss vss) n12 w=0.8u l=0.13u
MP8998 (n8996 was_fast vdd vdd) p12 w=2.4u l=0.13u
MN9001 (n8999 n8987 n9000 vss) n12 w=1.6u l=0.13u
MN9002 (n9000 n8996 vss vss) n12 w=1.6u l=0.13u
MP9003 (n8999 n8987 vdd vdd) p12 w=2.4u l=0.13u
MP9004 (n8999 n8996 vdd vdd) p12 w=2.4u l=0.13u
MN9007 (n9005 n8990 n9006 vss) n12 w=1.6u l=0.13u
MN9008 (n9006 n8999 vss vss) n12 w=1.6u l=0.13u
MP9009 (n9005 n8990 vdd vdd) p12 w=2.4u l=0.13u
MP9010 (n9005 n8999 vdd vdd) p12 w=2.4u l=0.13u
MN9013 (n9011 n9005 n9012 vss) n12 w=1.6u l=0.13u
MN9014 (n9012 s1 vss vss) n12 w=1.6u l=0.13u
MP9015 (n9011 n9005 vdd vdd) p12 w=2.4u l=0.13u
MP9016 (n9011 s1 vdd vdd) p12 w=2.4u l=0.13u
MN9019 (n9017 n9005 n9018 vss) n12 w=1.6u l=0.13u
MN9020 (n9018 n9011 vss vss) n12 w=1.6u l=0.13u
MP9021 (n9017 n9005 vdd vdd) p12 w=2.4u l=0.13u
MP9022 (n9017 n9011 vdd vdd) p12 w=2.4u l=0.13u
MN9025 (n9023 n9011 n9024 vss) n12 w=1.6u l=0.13u
MN9026 (n9024 s1 vss vss) n12 w=1.6u l=0.13u
MP9027 (n9023 n9011 vdd vdd) p12 w=2.4u l=0.13u
MP9028 (n9023 s1 vdd vdd) p12 w=2.4u l=0.13u
MN9031 (n9029 n9017 n9030 vss) n12 w=1.6u l=0.13u
MN9032 (n9030 n9023 vss vss) n12 w=1.6u l=0.13u
MP9033 (n9029 n9017 vdd vdd) p12 w=2.4u l=0.13u
MP9034 (n9029 n9023 vdd vdd) p12 w=2.4u l=0.13u
MN9037 (n9035 n8800 n9036 vss) n12 w=1.6u l=0.13u
MN9038 (n9036 n9029 vss vss) n12 w=1.6u l=0.13u
MP9039 (n9035 n8800 vdd vdd) p12 w=2.4u l=0.13u
MP9040 (n9035 n9029 vdd vdd) p12 w=2.4u l=0.13u
MN9043 (n9041 n8919 n9042 vss) n12 w=1.6u l=0.13u
MN9044 (n9042 s1 vss vss) n12 w=1.6u l=0.13u
MP9045 (n9041 n8919 vdd vdd) p12 w=2.4u l=0.13u
MP9046 (n9041 s1 vdd vdd) p12 w=2.4u l=0.13u
MN9049 (n9047 n9035 n9048 vss) n12 w=1.6u l=0.13u
MN9050 (n9048 n9041 vss vss) n12 w=1.6u l=0.13u
MP9051 (n9047 n9035 vdd vdd) p12 w=2.4u l=0.13u
MP9052 (n9047 n9041 vdd vdd) p12 w=2.4u l=0.13u
MN9057 (n9047 clk_low108 storage9056 vss) n12 w=1.2u l=0.13u
MP9058 (n9047 clk_lowb109 storage9056 vdd) p12 w=3.6u l=0.13u
MN9059 (qm9053 clk_high110 storage9056 vss) n12 w=1.2u l=0.13u
MP9060 (qm9053 clk_highb111 storage9056 vdd) p12 w=3.6u l=0.13u
MN9061 (qmb9054 storage9056 vss vss) n12 w=0.5u l=0.13u
MP9062 (qmb9054 storage9056 vdd vdd) p12 w=1.5u l=0.13u
MN9063 (qm9053 qmb9054 vss vss) n12 w=0.5u l=0.13u
MP9064 (qm9053 qmb9054 vdd vdd) p12 w=1.5u l=0.13u
MN9065 (storage9056 rst vss vss) n12 w=2u l=0.13u
MN9067 (qm9053 clk_high110 storage9066 vss) n12 w=1.2u l=0.13u
MP9068 (qm9053 clk_highb111 storage9066 vdd) p12 w=3.6u l=0.13u
MN9069 (s1 clk_low108 storage9066 vss) n12 w=1.2u l=0.13u
MP9070 (s1 clk_lowb109 storage9066 vdd) p12 w=3.6u l=0.13u
MN9071 (qb9055 storage9066 vss vss) n12 w=0.5u l=0.13u
MP9072 (qb9055 storage9066 vdd vdd) p12 w=1.5u l=0.13u
MN9073 (s1 qb9055 vss vss) n12 w=0.5u l=0.13u
MP9074 (s1 qb9055 vdd vdd) p12 w=1.5u l=0.13u
MN9075 (storage9066 rst vss vss) n12 w=2u l=0.13u
MN9078 (n9076 n8455 n9077 vss) n12 w=1.6u l=0.13u
MN9079 (n9077 n8966 vss vss) n12 w=1.6u l=0.13u
MP9080 (n9076 n8455 vdd vdd) p12 w=2.4u l=0.13u
MP9081 (n9076 n8966 vdd vdd) p12 w=2.4u l=0.13u
MN9083 (n9082 n9076 vss vss) n12 w=0.8u l=0.13u
MP9084 (n9082 n9076 vdd vdd) p12 w=2.4u l=0.13u
MN9087 (n9085 n8969 n9086 vss) n12 w=1.6u l=0.13u
MN9088 (n9086 s1 vss vss) n12 w=1.6u l=0.13u
MP9089 (n9085 n8969 vdd vdd) p12 w=2.4u l=0.13u
MP9090 (n9085 s1 vdd vdd) p12 w=2.4u l=0.13u
MN9092 (n9091 n9085 vss vss) n12 w=0.8u l=0.13u
MP9093 (n9091 n9085 vdd vdd) p12 w=2.4u l=0.13u
MN9096 (n9094 n8455 n9095 vss) n12 w=1.6u l=0.13u
MN9097 (n9095 step2 vss vss) n12 w=1.6u l=0.13u
MP9098 (n9094 n8455 vdd vdd) p12 w=2.4u l=0.13u
MP9099 (n9094 step2 vdd vdd) p12 w=2.4u l=0.13u
MN9101 (n9100 n9094 vss vss) n12 w=0.8u l=0.13u
MP9102 (n9100 n9094 vdd vdd) p12 w=2.4u l=0.13u
MN9105 (n9103 s1 n9104 vss) n12 w=1.6u l=0.13u
MN9106 (n9104 step2 vss vss) n12 w=1.6u l=0.13u
MP9107 (n9103 s1 vdd vdd) p12 w=2.4u l=0.13u
MP9108 (n9103 step2 vdd vdd) p12 w=2.4u l=0.13u
MN9110 (n9109 n9103 vss vss) n12 w=0.8u l=0.13u
MP9111 (n9109 n9103 vdd vdd) p12 w=2.4u l=0.13u
MN9114 (n9112 n9082 vss vss) n12 w=0.8u l=0.13u
MN9115 (n9112 n9100 vss vss) n12 w=0.8u l=0.13u
MP9116 (n9112 n9082 n9113 vdd) p12 w=4.8u l=0.13u
MP9117 (n9113 n9100 vdd vdd) p12 w=4.8u l=0.13u
MN9119 (n9118 n9112 vss vss) n12 w=0.8u l=0.13u
MP9120 (n9118 n9112 vdd vdd) p12 w=2.4u l=0.13u
MN9123 (n9121 n9118 vss vss) n12 w=0.8u l=0.13u
MN9124 (n9121 step4 vss vss) n12 w=0.8u l=0.13u
MP9125 (n9121 n9118 n9122 vdd) p12 w=4.8u l=0.13u
MP9126 (n9122 step4 vdd vdd) p12 w=4.8u l=0.13u
MN9128 (n9127 n9121 vss vss) n12 w=0.8u l=0.13u
MP9129 (n9127 n9121 vdd vdd) p12 w=2.4u l=0.13u
MN9132 (n9130 n9091 vss vss) n12 w=0.8u l=0.13u
MN9133 (n9130 n9109 vss vss) n12 w=0.8u l=0.13u
MP9134 (n9130 n9091 n9131 vdd) p12 w=4.8u l=0.13u
MP9135 (n9131 n9109 vdd vdd) p12 w=4.8u l=0.13u
MN9137 (n9136 n9130 vss vss) n12 w=0.8u l=0.13u
MP9138 (n9136 n9130 vdd vdd) p12 w=2.4u l=0.13u
MN9141 (n9139 n9136 vss vss) n12 w=0.8u l=0.13u
MN9142 (n9139 step4 vss vss) n12 w=0.8u l=0.13u
MP9143 (n9139 n9136 n9140 vdd) p12 w=4.8u l=0.13u
MP9144 (n9140 step4 vdd vdd) p12 w=4.8u l=0.13u
MN9146 (n9145 n9139 vss vss) n12 w=0.8u l=0.13u
MP9147 (n9145 n9139 vdd vdd) p12 w=2.4u l=0.13u
MN9150 (n9148 n9127 n9149 vss) n12 w=1.6u l=0.13u
MN9151 (n9149 was_fast vss vss) n12 w=1.6u l=0.13u
MP9152 (n9148 n9127 vdd vdd) p12 w=2.4u l=0.13u
MP9153 (n9148 was_fast vdd vdd) p12 w=2.4u l=0.13u
MN9156 (n9154 n8996 n9155 vss) n12 w=1.6u l=0.13u
MN9157 (n9155 n9145 vss vss) n12 w=1.6u l=0.13u
MP9158 (n9154 n8996 vdd vdd) p12 w=2.4u l=0.13u
MP9159 (n9154 n9145 vdd vdd) p12 w=2.4u l=0.13u
MN9162 (n9160 n9148 n9161 vss) n12 w=1.6u l=0.13u
MN9163 (n9161 n9154 vss vss) n12 w=1.6u l=0.13u
MP9164 (n9160 n9148 vdd vdd) p12 w=2.4u l=0.13u
MP9165 (n9160 n9154 vdd vdd) p12 w=2.4u l=0.13u
MN9168 (n9166 n9160 n9167 vss) n12 w=1.6u l=0.13u
MN9169 (n9167 s2 vss vss) n12 w=1.6u l=0.13u
MP9170 (n9166 n9160 vdd vdd) p12 w=2.4u l=0.13u
MP9171 (n9166 s2 vdd vdd) p12 w=2.4u l=0.13u
MN9174 (n9172 n9160 n9173 vss) n12 w=1.6u l=0.13u
MN9175 (n9173 n9166 vss vss) n12 w=1.6u l=0.13u
MP9176 (n9172 n9160 vdd vdd) p12 w=2.4u l=0.13u
MP9177 (n9172 n9166 vdd vdd) p12 w=2.4u l=0.13u
MN9180 (n9178 n9166 n9179 vss) n12 w=1.6u l=0.13u
MN9181 (n9179 s2 vss vss) n12 w=1.6u l=0.13u
MP9182 (n9178 n9166 vdd vdd) p12 w=2.4u l=0.13u
MP9183 (n9178 s2 vdd vdd) p12 w=2.4u l=0.13u
MN9186 (n9184 n9172 n9185 vss) n12 w=1.6u l=0.13u
MN9187 (n9185 n9178 vss vss) n12 w=1.6u l=0.13u
MP9188 (n9184 n9172 vdd vdd) p12 w=2.4u l=0.13u
MP9189 (n9184 n9178 vdd vdd) p12 w=2.4u l=0.13u
MN9192 (n9190 n8800 n9191 vss) n12 w=1.6u l=0.13u
MN9193 (n9191 n9184 vss vss) n12 w=1.6u l=0.13u
MP9194 (n9190 n8800 vdd vdd) p12 w=2.4u l=0.13u
MP9195 (n9190 n9184 vdd vdd) p12 w=2.4u l=0.13u
MN9198 (n9196 n8919 n9197 vss) n12 w=1.6u l=0.13u
MN9199 (n9197 s2 vss vss) n12 w=1.6u l=0.13u
MP9200 (n9196 n8919 vdd vdd) p12 w=2.4u l=0.13u
MP9201 (n9196 s2 vdd vdd) p12 w=2.4u l=0.13u
MN9204 (n9202 n9190 n9203 vss) n12 w=1.6u l=0.13u
MN9205 (n9203 n9196 vss vss) n12 w=1.6u l=0.13u
MP9206 (n9202 n9190 vdd vdd) p12 w=2.4u l=0.13u
MP9207 (n9202 n9196 vdd vdd) p12 w=2.4u l=0.13u
MN9212 (n9202 clk_low108 storage9211 vss) n12 w=1.2u l=0.13u
MP9213 (n9202 clk_lowb109 storage9211 vdd) p12 w=3.6u l=0.13u
MN9214 (qm9208 clk_high110 storage9211 vss) n12 w=1.2u l=0.13u
MP9215 (qm9208 clk_highb111 storage9211 vdd) p12 w=3.6u l=0.13u
MN9216 (qmb9209 storage9211 vss vss) n12 w=0.5u l=0.13u
MP9217 (qmb9209 storage9211 vdd vdd) p12 w=1.5u l=0.13u
MN9218 (qm9208 qmb9209 vss vss) n12 w=0.5u l=0.13u
MP9219 (qm9208 qmb9209 vdd vdd) p12 w=1.5u l=0.13u
MN9220 (storage9211 rst vss vss) n12 w=2u l=0.13u
MN9222 (qm9208 clk_high110 storage9221 vss) n12 w=1.2u l=0.13u
MP9223 (qm9208 clk_highb111 storage9221 vdd) p12 w=3.6u l=0.13u
MN9224 (s2 clk_low108 storage9221 vss) n12 w=1.2u l=0.13u
MP9225 (s2 clk_lowb109 storage9221 vdd) p12 w=3.6u l=0.13u
MN9226 (qb9210 storage9221 vss vss) n12 w=0.5u l=0.13u
MP9227 (qb9210 storage9221 vdd vdd) p12 w=1.5u l=0.13u
MN9228 (s2 qb9210 vss vss) n12 w=0.5u l=0.13u
MP9229 (s2 qb9210 vdd vdd) p12 w=1.5u l=0.13u
MN9230 (storage9221 rst vss vss) n12 w=2u l=0.13u
MN9233 (n9231 n8455 n9232 vss) n12 w=1.6u l=0.13u
MN9234 (n9232 n8458 vss vss) n12 w=1.6u l=0.13u
MP9235 (n9231 n8455 vdd vdd) p12 w=2.4u l=0.13u
MP9236 (n9231 n8458 vdd vdd) p12 w=2.4u l=0.13u
MN9238 (n9237 n9231 vss vss) n12 w=0.8u l=0.13u
MP9239 (n9237 n9231 vdd vdd) p12 w=2.4u l=0.13u
MN9242 (n9240 n8966 n9241 vss) n12 w=1.6u l=0.13u
MN9243 (n9241 n9237 vss vss) n12 w=1.6u l=0.13u
MP9244 (n9240 n8966 vdd vdd) p12 w=2.4u l=0.13u
MP9245 (n9240 n9237 vdd vdd) p12 w=2.4u l=0.13u
MN9247 (n9246 n9240 vss vss) n12 w=0.8u l=0.13u
MP9248 (n9246 n9240 vdd vdd) p12 w=2.4u l=0.13u
MN9251 (n9249 s1 n9250 vss) n12 w=1.6u l=0.13u
MN9252 (n9250 s2 vss vss) n12 w=1.6u l=0.13u
MP9253 (n9249 s1 vdd vdd) p12 w=2.4u l=0.13u
MP9254 (n9249 s2 vdd vdd) p12 w=2.4u l=0.13u
MN9256 (n9255 n9249 vss vss) n12 w=0.8u l=0.13u
MP9257 (n9255 n9249 vdd vdd) p12 w=2.4u l=0.13u
MN9260 (n9258 n8969 n9259 vss) n12 w=1.6u l=0.13u
MN9261 (n9259 n9255 vss vss) n12 w=1.6u l=0.13u
MP9262 (n9258 n8969 vdd vdd) p12 w=2.4u l=0.13u
MP9263 (n9258 n9255 vdd vdd) p12 w=2.4u l=0.13u
MN9265 (n9264 n9258 vss vss) n12 w=0.8u l=0.13u
MP9266 (n9264 n9258 vdd vdd) p12 w=2.4u l=0.13u
MN9269 (n9267 n8458 n9268 vss) n12 w=1.6u l=0.13u
MN9270 (n9268 n9100 vss vss) n12 w=1.6u l=0.13u
MP9271 (n9267 n8458 vdd vdd) p12 w=2.4u l=0.13u
MP9272 (n9267 n9100 vdd vdd) p12 w=2.4u l=0.13u
MN9274 (n9273 n9267 vss vss) n12 w=0.8u l=0.13u
MP9275 (n9273 n9267 vdd vdd) p12 w=2.4u l=0.13u
MN9278 (n9276 n9109 n9277 vss) n12 w=1.6u l=0.13u
MN9279 (n9277 s2 vss vss) n12 w=1.6u l=0.13u
MP9280 (n9276 n9109 vdd vdd) p12 w=2.4u l=0.13u
MP9281 (n9276 s2 vdd vdd) p12 w=2.4u l=0.13u
MN9283 (n9282 n9276 vss vss) n12 w=0.8u l=0.13u
MP9284 (n9282 n9276 vdd vdd) p12 w=2.4u l=0.13u
MN9287 (n9285 n8458 n9286 vss) n12 w=1.6u l=0.13u
MN9288 (n9286 step4 vss vss) n12 w=1.6u l=0.13u
MP9289 (n9285 n8458 vdd vdd) p12 w=2.4u l=0.13u
MP9290 (n9285 step4 vdd vdd) p12 w=2.4u l=0.13u
MN9292 (n9291 n9285 vss vss) n12 w=0.8u l=0.13u
MP9293 (n9291 n9285 vdd vdd) p12 w=2.4u l=0.13u
MN9296 (n9294 s2 n9295 vss) n12 w=1.6u l=0.13u
MN9297 (n9295 step4 vss vss) n12 w=1.6u l=0.13u
MP9298 (n9294 s2 vdd vdd) p12 w=2.4u l=0.13u
MP9299 (n9294 step4 vdd vdd) p12 w=2.4u l=0.13u
MN9301 (n9300 n9294 vss vss) n12 w=0.8u l=0.13u
MP9302 (n9300 n9294 vdd vdd) p12 w=2.4u l=0.13u
MN9305 (n9303 n9246 vss vss) n12 w=0.8u l=0.13u
MN9306 (n9303 n9273 vss vss) n12 w=0.8u l=0.13u
MP9307 (n9303 n9246 n9304 vdd) p12 w=4.8u l=0.13u
MP9308 (n9304 n9273 vdd vdd) p12 w=4.8u l=0.13u
MN9310 (n9309 n9303 vss vss) n12 w=0.8u l=0.13u
MP9311 (n9309 n9303 vdd vdd) p12 w=2.4u l=0.13u
MN9314 (n9312 n9291 vss vss) n12 w=0.8u l=0.13u
MN9315 (n9312 step8 vss vss) n12 w=0.8u l=0.13u
MP9316 (n9312 n9291 n9313 vdd) p12 w=4.8u l=0.13u
MP9317 (n9313 step8 vdd vdd) p12 w=4.8u l=0.13u
MN9319 (n9318 n9312 vss vss) n12 w=0.8u l=0.13u
MP9320 (n9318 n9312 vdd vdd) p12 w=2.4u l=0.13u
MN9323 (n9321 n9309 vss vss) n12 w=0.8u l=0.13u
MN9324 (n9321 n9318 vss vss) n12 w=0.8u l=0.13u
MP9325 (n9321 n9309 n9322 vdd) p12 w=4.8u l=0.13u
MP9326 (n9322 n9318 vdd vdd) p12 w=4.8u l=0.13u
MN9328 (n9327 n9321 vss vss) n12 w=0.8u l=0.13u
MP9329 (n9327 n9321 vdd vdd) p12 w=2.4u l=0.13u
MN9332 (n9330 n9264 vss vss) n12 w=0.8u l=0.13u
MN9333 (n9330 n9282 vss vss) n12 w=0.8u l=0.13u
MP9334 (n9330 n9264 n9331 vdd) p12 w=4.8u l=0.13u
MP9335 (n9331 n9282 vdd vdd) p12 w=4.8u l=0.13u
MN9337 (n9336 n9330 vss vss) n12 w=0.8u l=0.13u
MP9338 (n9336 n9330 vdd vdd) p12 w=2.4u l=0.13u
MN9341 (n9339 n9300 vss vss) n12 w=0.8u l=0.13u
MN9342 (n9339 step8 vss vss) n12 w=0.8u l=0.13u
MP9343 (n9339 n9300 n9340 vdd) p12 w=4.8u l=0.13u
MP9344 (n9340 step8 vdd vdd) p12 w=4.8u l=0.13u
MN9346 (n9345 n9339 vss vss) n12 w=0.8u l=0.13u
MP9347 (n9345 n9339 vdd vdd) p12 w=2.4u l=0.13u
MN9350 (n9348 n9336 vss vss) n12 w=0.8u l=0.13u
MN9351 (n9348 n9345 vss vss) n12 w=0.8u l=0.13u
MP9352 (n9348 n9336 n9349 vdd) p12 w=4.8u l=0.13u
MP9353 (n9349 n9345 vdd vdd) p12 w=4.8u l=0.13u
MN9355 (n9354 n9348 vss vss) n12 w=0.8u l=0.13u
MP9356 (n9354 n9348 vdd vdd) p12 w=2.4u l=0.13u
MN9359 (n9357 n9327 n9358 vss) n12 w=1.6u l=0.13u
MN9360 (n9358 was_fast vss vss) n12 w=1.6u l=0.13u
MP9361 (n9357 n9327 vdd vdd) p12 w=2.4u l=0.13u
MP9362 (n9357 was_fast vdd vdd) p12 w=2.4u l=0.13u
MN9365 (n9363 n8996 n9364 vss) n12 w=1.6u l=0.13u
MN9366 (n9364 n9354 vss vss) n12 w=1.6u l=0.13u
MP9367 (n9363 n8996 vdd vdd) p12 w=2.4u l=0.13u
MP9368 (n9363 n9354 vdd vdd) p12 w=2.4u l=0.13u
MN9371 (n9369 n9357 n9370 vss) n12 w=1.6u l=0.13u
MN9372 (n9370 n9363 vss vss) n12 w=1.6u l=0.13u
MP9373 (n9369 n9357 vdd vdd) p12 w=2.4u l=0.13u
MP9374 (n9369 n9363 vdd vdd) p12 w=2.4u l=0.13u
MN9377 (n9375 n9369 n9376 vss) n12 w=1.6u l=0.13u
MN9378 (n9376 s3 vss vss) n12 w=1.6u l=0.13u
MP9379 (n9375 n9369 vdd vdd) p12 w=2.4u l=0.13u
MP9380 (n9375 s3 vdd vdd) p12 w=2.4u l=0.13u
MN9383 (n9381 n9369 n9382 vss) n12 w=1.6u l=0.13u
MN9384 (n9382 n9375 vss vss) n12 w=1.6u l=0.13u
MP9385 (n9381 n9369 vdd vdd) p12 w=2.4u l=0.13u
MP9386 (n9381 n9375 vdd vdd) p12 w=2.4u l=0.13u
MN9389 (n9387 n9375 n9388 vss) n12 w=1.6u l=0.13u
MN9390 (n9388 s3 vss vss) n12 w=1.6u l=0.13u
MP9391 (n9387 n9375 vdd vdd) p12 w=2.4u l=0.13u
MP9392 (n9387 s3 vdd vdd) p12 w=2.4u l=0.13u
MN9395 (n9393 n9381 n9394 vss) n12 w=1.6u l=0.13u
MN9396 (n9394 n9387 vss vss) n12 w=1.6u l=0.13u
MP9397 (n9393 n9381 vdd vdd) p12 w=2.4u l=0.13u
MP9398 (n9393 n9387 vdd vdd) p12 w=2.4u l=0.13u
MN9401 (n9399 n8800 n9400 vss) n12 w=1.6u l=0.13u
MN9402 (n9400 n9393 vss vss) n12 w=1.6u l=0.13u
MP9403 (n9399 n8800 vdd vdd) p12 w=2.4u l=0.13u
MP9404 (n9399 n9393 vdd vdd) p12 w=2.4u l=0.13u
MN9407 (n9405 n8919 n9406 vss) n12 w=1.6u l=0.13u
MN9408 (n9406 s3 vss vss) n12 w=1.6u l=0.13u
MP9409 (n9405 n8919 vdd vdd) p12 w=2.4u l=0.13u
MP9410 (n9405 s3 vdd vdd) p12 w=2.4u l=0.13u
MN9413 (n9411 n9399 n9412 vss) n12 w=1.6u l=0.13u
MN9414 (n9412 n9405 vss vss) n12 w=1.6u l=0.13u
MP9415 (n9411 n9399 vdd vdd) p12 w=2.4u l=0.13u
MP9416 (n9411 n9405 vdd vdd) p12 w=2.4u l=0.13u
MN9421 (n9411 clk_low108 storage9420 vss) n12 w=1.2u l=0.13u
MP9422 (n9411 clk_lowb109 storage9420 vdd) p12 w=3.6u l=0.13u
MN9423 (qm9417 clk_high110 storage9420 vss) n12 w=1.2u l=0.13u
MP9424 (qm9417 clk_highb111 storage9420 vdd) p12 w=3.6u l=0.13u
MN9425 (qmb9418 storage9420 vss vss) n12 w=0.5u l=0.13u
MP9426 (qmb9418 storage9420 vdd vdd) p12 w=1.5u l=0.13u
MN9427 (qm9417 qmb9418 vss vss) n12 w=0.5u l=0.13u
MP9428 (qm9417 qmb9418 vdd vdd) p12 w=1.5u l=0.13u
MN9429 (storage9420 rst vss vss) n12 w=2u l=0.13u
MN9431 (qm9417 clk_high110 storage9430 vss) n12 w=1.2u l=0.13u
MP9432 (qm9417 clk_highb111 storage9430 vdd) p12 w=3.6u l=0.13u
MN9433 (s3 clk_low108 storage9430 vss) n12 w=1.2u l=0.13u
MP9434 (s3 clk_lowb109 storage9430 vdd) p12 w=3.6u l=0.13u
MN9435 (qb9419 storage9430 vss vss) n12 w=0.5u l=0.13u
MP9436 (qb9419 storage9430 vdd vdd) p12 w=1.5u l=0.13u
MN9437 (s3 qb9419 vss vss) n12 w=0.5u l=0.13u
MP9438 (s3 qb9419 vdd vdd) p12 w=1.5u l=0.13u
MN9439 (storage9430 rst vss vss) n12 w=2u l=0.13u
MN9442 (n9440 n8461 n9441 vss) n12 w=1.6u l=0.13u
MN9443 (n9441 n9246 vss vss) n12 w=1.6u l=0.13u
MP9444 (n9440 n8461 vdd vdd) p12 w=2.4u l=0.13u
MP9445 (n9440 n9246 vdd vdd) p12 w=2.4u l=0.13u
MN9447 (n9446 n9440 vss vss) n12 w=0.8u l=0.13u
MP9448 (n9446 n9440 vdd vdd) p12 w=2.4u l=0.13u
MN9451 (n9449 n9264 n9450 vss) n12 w=1.6u l=0.13u
MN9452 (n9450 s3 vss vss) n12 w=1.6u l=0.13u
MP9453 (n9449 n9264 vdd vdd) p12 w=2.4u l=0.13u
MP9454 (n9449 s3 vdd vdd) p12 w=2.4u l=0.13u
MN9456 (n9455 n9449 vss vss) n12 w=0.8u l=0.13u
MP9457 (n9455 n9449 vdd vdd) p12 w=2.4u l=0.13u
MN9460 (n9458 n8482 n9459 vss) n12 w=1.6u l=0.13u
MN9461 (n9459 n9100 vss vss) n12 w=1.6u l=0.13u
MP9462 (n9458 n8482 vdd vdd) p12 w=2.4u l=0.13u
MP9463 (n9458 n9100 vdd vdd) p12 w=2.4u l=0.13u
MN9465 (n9464 n9458 vss vss) n12 w=0.8u l=0.13u
MP9466 (n9464 n9458 vdd vdd) p12 w=2.4u l=0.13u
MN9469 (n9467 n8518 n9468 vss) n12 w=1.6u l=0.13u
MN9470 (n9468 n9109 vss vss) n12 w=1.6u l=0.13u
MP9471 (n9467 n8518 vdd vdd) p12 w=2.4u l=0.13u
MP9472 (n9467 n9109 vdd vdd) p12 w=2.4u l=0.13u
MN9474 (n9473 n9467 vss vss) n12 w=0.8u l=0.13u
MP9475 (n9473 n9467 vdd vdd) p12 w=2.4u l=0.13u
MN9478 (n9476 n8461 n9477 vss) n12 w=1.6u l=0.13u
MN9479 (n9477 n9291 vss vss) n12 w=1.6u l=0.13u
MP9480 (n9476 n8461 vdd vdd) p12 w=2.4u l=0.13u
MP9481 (n9476 n9291 vdd vdd) p12 w=2.4u l=0.13u
MN9483 (n9482 n9476 vss vss) n12 w=0.8u l=0.13u
MP9484 (n9482 n9476 vdd vdd) p12 w=2.4u l=0.13u
MN9487 (n9485 n9300 n9486 vss) n12 w=1.6u l=0.13u
MN9488 (n9486 s3 vss vss) n12 w=1.6u l=0.13u
MP9489 (n9485 n9300 vdd vdd) p12 w=2.4u l=0.13u
MP9490 (n9485 s3 vdd vdd) p12 w=2.4u l=0.13u
MN9492 (n9491 n9485 vss vss) n12 w=0.8u l=0.13u
MP9493 (n9491 n9485 vdd vdd) p12 w=2.4u l=0.13u
MN9496 (n9494 n8461 n9495 vss) n12 w=1.6u l=0.13u
MN9497 (n9495 step8 vss vss) n12 w=1.6u l=0.13u
MP9498 (n9494 n8461 vdd vdd) p12 w=2.4u l=0.13u
MP9499 (n9494 step8 vdd vdd) p12 w=2.4u l=0.13u
MN9501 (n9500 n9494 vss vss) n12 w=0.8u l=0.13u
MP9502 (n9500 n9494 vdd vdd) p12 w=2.4u l=0.13u
MN9505 (n9503 s3 n9504 vss) n12 w=1.6u l=0.13u
MN9506 (n9504 step8 vss vss) n12 w=1.6u l=0.13u
MP9507 (n9503 s3 vdd vdd) p12 w=2.4u l=0.13u
MP9508 (n9503 step8 vdd vdd) p12 w=2.4u l=0.13u
MN9510 (n9509 n9503 vss vss) n12 w=0.8u l=0.13u
MP9511 (n9509 n9503 vdd vdd) p12 w=2.4u l=0.13u
MN9514 (n9512 n9446 vss vss) n12 w=0.8u l=0.13u
MN9515 (n9512 n9464 vss vss) n12 w=0.8u l=0.13u
MP9516 (n9512 n9446 n9513 vdd) p12 w=4.8u l=0.13u
MP9517 (n9513 n9464 vdd vdd) p12 w=4.8u l=0.13u
MN9519 (n9518 n9512 vss vss) n12 w=0.8u l=0.13u
MP9520 (n9518 n9512 vdd vdd) p12 w=2.4u l=0.13u
MN9523 (n9521 n9482 vss vss) n12 w=0.8u l=0.13u
MN9524 (n9521 n9500 vss vss) n12 w=0.8u l=0.13u
MP9525 (n9521 n9482 n9522 vdd) p12 w=4.8u l=0.13u
MP9526 (n9522 n9500 vdd vdd) p12 w=4.8u l=0.13u
MN9528 (n9527 n9521 vss vss) n12 w=0.8u l=0.13u
MP9529 (n9527 n9521 vdd vdd) p12 w=2.4u l=0.13u
MN9532 (n9530 n9518 vss vss) n12 w=0.8u l=0.13u
MN9533 (n9530 n9527 vss vss) n12 w=0.8u l=0.13u
MP9534 (n9530 n9518 n9531 vdd) p12 w=4.8u l=0.13u
MP9535 (n9531 n9527 vdd vdd) p12 w=4.8u l=0.13u
MN9537 (n9536 n9530 vss vss) n12 w=0.8u l=0.13u
MP9538 (n9536 n9530 vdd vdd) p12 w=2.4u l=0.13u
MN9541 (n9539 n9455 vss vss) n12 w=0.8u l=0.13u
MN9542 (n9539 n9473 vss vss) n12 w=0.8u l=0.13u
MP9543 (n9539 n9455 n9540 vdd) p12 w=4.8u l=0.13u
MP9544 (n9540 n9473 vdd vdd) p12 w=4.8u l=0.13u
MN9546 (n9545 n9539 vss vss) n12 w=0.8u l=0.13u
MP9547 (n9545 n9539 vdd vdd) p12 w=2.4u l=0.13u
MN9550 (n9548 n9491 vss vss) n12 w=0.8u l=0.13u
MN9551 (n9548 n9509 vss vss) n12 w=0.8u l=0.13u
MP9552 (n9548 n9491 n9549 vdd) p12 w=4.8u l=0.13u
MP9553 (n9549 n9509 vdd vdd) p12 w=4.8u l=0.13u
MN9555 (n9554 n9548 vss vss) n12 w=0.8u l=0.13u
MP9556 (n9554 n9548 vdd vdd) p12 w=2.4u l=0.13u
MN9559 (n9557 n9545 vss vss) n12 w=0.8u l=0.13u
MN9560 (n9557 n9554 vss vss) n12 w=0.8u l=0.13u
MP9561 (n9557 n9545 n9558 vdd) p12 w=4.8u l=0.13u
MP9562 (n9558 n9554 vdd vdd) p12 w=4.8u l=0.13u
MN9564 (n9563 n9557 vss vss) n12 w=0.8u l=0.13u
MP9565 (n9563 n9557 vdd vdd) p12 w=2.4u l=0.13u
MN9568 (n9566 n9536 n9567 vss) n12 w=1.6u l=0.13u
MN9569 (n9567 was_fast vss vss) n12 w=1.6u l=0.13u
MP9570 (n9566 n9536 vdd vdd) p12 w=2.4u l=0.13u
MP9571 (n9566 was_fast vdd vdd) p12 w=2.4u l=0.13u
MN9574 (n9572 n8996 n9573 vss) n12 w=1.6u l=0.13u
MN9575 (n9573 n9563 vss vss) n12 w=1.6u l=0.13u
MP9576 (n9572 n8996 vdd vdd) p12 w=2.4u l=0.13u
MP9577 (n9572 n9563 vdd vdd) p12 w=2.4u l=0.13u
MN9580 (n9578 n9566 n9579 vss) n12 w=1.6u l=0.13u
MN9581 (n9579 n9572 vss vss) n12 w=1.6u l=0.13u
MP9582 (n9578 n9566 vdd vdd) p12 w=2.4u l=0.13u
MP9583 (n9578 n9572 vdd vdd) p12 w=2.4u l=0.13u
MN9586 (n9584 n9578 n9585 vss) n12 w=1.6u l=0.13u
MN9587 (n9585 s4 vss vss) n12 w=1.6u l=0.13u
MP9588 (n9584 n9578 vdd vdd) p12 w=2.4u l=0.13u
MP9589 (n9584 s4 vdd vdd) p12 w=2.4u l=0.13u
MN9592 (n9590 n9578 n9591 vss) n12 w=1.6u l=0.13u
MN9593 (n9591 n9584 vss vss) n12 w=1.6u l=0.13u
MP9594 (n9590 n9578 vdd vdd) p12 w=2.4u l=0.13u
MP9595 (n9590 n9584 vdd vdd) p12 w=2.4u l=0.13u
MN9598 (n9596 n9584 n9597 vss) n12 w=1.6u l=0.13u
MN9599 (n9597 s4 vss vss) n12 w=1.6u l=0.13u
MP9600 (n9596 n9584 vdd vdd) p12 w=2.4u l=0.13u
MP9601 (n9596 s4 vdd vdd) p12 w=2.4u l=0.13u
MN9604 (n9602 n9590 n9603 vss) n12 w=1.6u l=0.13u
MN9605 (n9603 n9596 vss vss) n12 w=1.6u l=0.13u
MP9606 (n9602 n9590 vdd vdd) p12 w=2.4u l=0.13u
MP9607 (n9602 n9596 vdd vdd) p12 w=2.4u l=0.13u
MN9610 (n9608 n8800 n9609 vss) n12 w=1.6u l=0.13u
MN9611 (n9609 n9602 vss vss) n12 w=1.6u l=0.13u
MP9612 (n9608 n8800 vdd vdd) p12 w=2.4u l=0.13u
MP9613 (n9608 n9602 vdd vdd) p12 w=2.4u l=0.13u
MN9616 (n9614 n8919 n9615 vss) n12 w=1.6u l=0.13u
MN9617 (n9615 s4 vss vss) n12 w=1.6u l=0.13u
MP9618 (n9614 n8919 vdd vdd) p12 w=2.4u l=0.13u
MP9619 (n9614 s4 vdd vdd) p12 w=2.4u l=0.13u
MN9622 (n9620 n9608 n9621 vss) n12 w=1.6u l=0.13u
MN9623 (n9621 n9614 vss vss) n12 w=1.6u l=0.13u
MP9624 (n9620 n9608 vdd vdd) p12 w=2.4u l=0.13u
MP9625 (n9620 n9614 vdd vdd) p12 w=2.4u l=0.13u
MN9629 (n9628 n9620 vss vss) n12 w=0.8u l=0.13u
MP9630 (n9628 n9620 vdd vdd) p12 w=2.4u l=0.13u
MN9633 (n9628 clk_low108 storage9632 vss) n12 w=1.2u l=0.13u
MP9634 (n9628 clk_lowb109 storage9632 vdd) p12 w=3.6u l=0.13u
MN9635 (qm9626 clk_high110 storage9632 vss) n12 w=1.2u l=0.13u
MP9636 (qm9626 clk_highb111 storage9632 vdd) p12 w=3.6u l=0.13u
MN9637 (qmb9627 storage9632 vss vss) n12 w=0.5u l=0.13u
MP9638 (qmb9627 storage9632 vdd vdd) p12 w=1.5u l=0.13u
MN9639 (qm9626 qmb9627 vss vss) n12 w=0.5u l=0.13u
MP9640 (qm9626 qmb9627 vdd vdd) p12 w=1.5u l=0.13u
MN9641 (storage9632 rst vss vss) n12 w=2u l=0.13u
MN9643 (qm9626 clk_high110 storage9642 vss) n12 w=1.2u l=0.13u
MP9644 (qm9626 clk_highb111 storage9642 vdd) p12 w=3.6u l=0.13u
MN9645 (qneg9631 clk_low108 storage9642 vss) n12 w=1.2u l=0.13u
MP9646 (qneg9631 clk_lowb109 storage9642 vdd) p12 w=3.6u l=0.13u
MN9647 (s4 storage9642 vss vss) n12 w=0.5u l=0.13u
MP9648 (s4 storage9642 vdd vdd) p12 w=1.5u l=0.13u
MN9649 (qneg9631 s4 vss vss) n12 w=0.5u l=0.13u
MP9650 (qneg9631 s4 vdd vdd) p12 w=1.5u l=0.13u
MN9651 (storage9642 rst vss vss) n12 w=2u l=0.13u
MN9654 (n9652 n8800 n9653 vss) n12 w=1.6u l=0.13u
MN9655 (n9653 step2 vss vss) n12 w=1.6u l=0.13u
MP9656 (n9652 n8800 vdd vdd) p12 w=2.4u l=0.13u
MP9657 (n9652 step2 vdd vdd) p12 w=2.4u l=0.13u
MN9660 (n9658 n8919 n9659 vss) n12 w=1.6u l=0.13u
MN9661 (n9659 step1 vss vss) n12 w=1.6u l=0.13u
MP9662 (n9658 n8919 vdd vdd) p12 w=2.4u l=0.13u
MP9663 (n9658 step1 vdd vdd) p12 w=2.4u l=0.13u
MN9666 (n9664 n9652 n9665 vss) n12 w=1.6u l=0.13u
MN9667 (n9665 n9658 vss vss) n12 w=1.6u l=0.13u
MP9668 (n9664 n9652 vdd vdd) p12 w=2.4u l=0.13u
MP9669 (n9664 n9658 vdd vdd) p12 w=2.4u l=0.13u
MN9674 (n9664 clk_low108 storage9673 vss) n12 w=1.2u l=0.13u
MP9675 (n9664 clk_lowb109 storage9673 vdd) p12 w=3.6u l=0.13u
MN9676 (qm9670 clk_high110 storage9673 vss) n12 w=1.2u l=0.13u
MP9677 (qm9670 clk_highb111 storage9673 vdd) p12 w=3.6u l=0.13u
MN9678 (qmb9671 storage9673 vss vss) n12 w=0.5u l=0.13u
MP9679 (qmb9671 storage9673 vdd vdd) p12 w=1.5u l=0.13u
MN9680 (qm9670 qmb9671 vss vss) n12 w=0.5u l=0.13u
MP9681 (qm9670 qmb9671 vdd vdd) p12 w=1.5u l=0.13u
MN9682 (storage9673 rst vss vss) n12 w=2u l=0.13u
MN9684 (qm9670 clk_high110 storage9683 vss) n12 w=1.2u l=0.13u
MP9685 (qm9670 clk_highb111 storage9683 vdd) p12 w=3.6u l=0.13u
MN9686 (step1 clk_low108 storage9683 vss) n12 w=1.2u l=0.13u
MP9687 (step1 clk_lowb109 storage9683 vdd) p12 w=3.6u l=0.13u
MN9688 (qb9672 storage9683 vss vss) n12 w=0.5u l=0.13u
MP9689 (qb9672 storage9683 vdd vdd) p12 w=1.5u l=0.13u
MN9690 (step1 qb9672 vss vss) n12 w=0.5u l=0.13u
MP9691 (step1 qb9672 vdd vdd) p12 w=1.5u l=0.13u
MN9692 (storage9683 rst vss vss) n12 w=2u l=0.13u
MN9695 (n9693 n8800 n9694 vss) n12 w=1.6u l=0.13u
MN9696 (n9694 step4 vss vss) n12 w=1.6u l=0.13u
MP9697 (n9693 n8800 vdd vdd) p12 w=2.4u l=0.13u
MP9698 (n9693 step4 vdd vdd) p12 w=2.4u l=0.13u
MN9701 (n9699 n8919 n9700 vss) n12 w=1.6u l=0.13u
MN9702 (n9700 step2 vss vss) n12 w=1.6u l=0.13u
MP9703 (n9699 n8919 vdd vdd) p12 w=2.4u l=0.13u
MP9704 (n9699 step2 vdd vdd) p12 w=2.4u l=0.13u
MN9707 (n9705 n9693 n9706 vss) n12 w=1.6u l=0.13u
MN9708 (n9706 n9699 vss vss) n12 w=1.6u l=0.13u
MP9709 (n9705 n9693 vdd vdd) p12 w=2.4u l=0.13u
MP9710 (n9705 n9699 vdd vdd) p12 w=2.4u l=0.13u
MN9715 (n9705 clk_low108 storage9714 vss) n12 w=1.2u l=0.13u
MP9716 (n9705 clk_lowb109 storage9714 vdd) p12 w=3.6u l=0.13u
MN9717 (qm9711 clk_high110 storage9714 vss) n12 w=1.2u l=0.13u
MP9718 (qm9711 clk_highb111 storage9714 vdd) p12 w=3.6u l=0.13u
MN9719 (qmb9712 storage9714 vss vss) n12 w=0.5u l=0.13u
MP9720 (qmb9712 storage9714 vdd vdd) p12 w=1.5u l=0.13u
MN9721 (qm9711 qmb9712 vss vss) n12 w=0.5u l=0.13u
MP9722 (qm9711 qmb9712 vdd vdd) p12 w=1.5u l=0.13u
MN9723 (storage9714 rst vss vss) n12 w=2u l=0.13u
MN9725 (qm9711 clk_high110 storage9724 vss) n12 w=1.2u l=0.13u
MP9726 (qm9711 clk_highb111 storage9724 vdd) p12 w=3.6u l=0.13u
MN9727 (step2 clk_low108 storage9724 vss) n12 w=1.2u l=0.13u
MP9728 (step2 clk_lowb109 storage9724 vdd) p12 w=3.6u l=0.13u
MN9729 (qb9713 storage9724 vss vss) n12 w=0.5u l=0.13u
MP9730 (qb9713 storage9724 vdd vdd) p12 w=1.5u l=0.13u
MN9731 (step2 qb9713 vss vss) n12 w=0.5u l=0.13u
MP9732 (step2 qb9713 vdd vdd) p12 w=1.5u l=0.13u
MN9733 (storage9724 rst vss vss) n12 w=2u l=0.13u
MN9736 (n9734 n8800 n9735 vss) n12 w=1.6u l=0.13u
MN9737 (n9735 step8 vss vss) n12 w=1.6u l=0.13u
MP9738 (n9734 n8800 vdd vdd) p12 w=2.4u l=0.13u
MP9739 (n9734 step8 vdd vdd) p12 w=2.4u l=0.13u
MN9742 (n9740 n8919 n9741 vss) n12 w=1.6u l=0.13u
MN9743 (n9741 step4 vss vss) n12 w=1.6u l=0.13u
MP9744 (n9740 n8919 vdd vdd) p12 w=2.4u l=0.13u
MP9745 (n9740 step4 vdd vdd) p12 w=2.4u l=0.13u
MN9748 (n9746 n9734 n9747 vss) n12 w=1.6u l=0.13u
MN9749 (n9747 n9740 vss vss) n12 w=1.6u l=0.13u
MP9750 (n9746 n9734 vdd vdd) p12 w=2.4u l=0.13u
MP9751 (n9746 n9740 vdd vdd) p12 w=2.4u l=0.13u
MN9756 (n9746 clk_low108 storage9755 vss) n12 w=1.2u l=0.13u
MP9757 (n9746 clk_lowb109 storage9755 vdd) p12 w=3.6u l=0.13u
MN9758 (qm9752 clk_high110 storage9755 vss) n12 w=1.2u l=0.13u
MP9759 (qm9752 clk_highb111 storage9755 vdd) p12 w=3.6u l=0.13u
MN9760 (qmb9753 storage9755 vss vss) n12 w=0.5u l=0.13u
MP9761 (qmb9753 storage9755 vdd vdd) p12 w=1.5u l=0.13u
MN9762 (qm9752 qmb9753 vss vss) n12 w=0.5u l=0.13u
MP9763 (qm9752 qmb9753 vdd vdd) p12 w=1.5u l=0.13u
MN9764 (storage9755 rst vss vss) n12 w=2u l=0.13u
MN9766 (qm9752 clk_high110 storage9765 vss) n12 w=1.2u l=0.13u
MP9767 (qm9752 clk_highb111 storage9765 vdd) p12 w=3.6u l=0.13u
MN9768 (step4 clk_low108 storage9765 vss) n12 w=1.2u l=0.13u
MP9769 (step4 clk_lowb109 storage9765 vdd) p12 w=3.6u l=0.13u
MN9770 (qb9754 storage9765 vss vss) n12 w=0.5u l=0.13u
MP9771 (qb9754 storage9765 vdd vdd) p12 w=1.5u l=0.13u
MN9772 (step4 qb9754 vss vss) n12 w=0.5u l=0.13u
MP9773 (step4 qb9754 vdd vdd) p12 w=1.5u l=0.13u
MN9774 (storage9765 rst vss vss) n12 w=2u l=0.13u
MN9777 (n9775 n8919 n9776 vss) n12 w=1.6u l=0.13u
MN9778 (n9776 step8 vss vss) n12 w=1.6u l=0.13u
MP9779 (n9775 n8919 vdd vdd) p12 w=2.4u l=0.13u
MP9780 (n9775 step8 vdd vdd) p12 w=2.4u l=0.13u
MN9782 (n9781 n9775 vss vss) n12 w=0.8u l=0.13u
MP9783 (n9781 n9775 vdd vdd) p12 w=2.4u l=0.13u
MN9787 (n9786 n9781 vss vss) n12 w=0.8u l=0.13u
MP9788 (n9786 n9781 vdd vdd) p12 w=2.4u l=0.13u
MN9791 (n9786 clk_low108 storage9790 vss) n12 w=1.2u l=0.13u
MP9792 (n9786 clk_lowb109 storage9790 vdd) p12 w=3.6u l=0.13u
MN9793 (qm9784 clk_high110 storage9790 vss) n12 w=1.2u l=0.13u
MP9794 (qm9784 clk_highb111 storage9790 vdd) p12 w=3.6u l=0.13u
MN9795 (qmb9785 storage9790 vss vss) n12 w=0.5u l=0.13u
MP9796 (qmb9785 storage9790 vdd vdd) p12 w=1.5u l=0.13u
MN9797 (qm9784 qmb9785 vss vss) n12 w=0.5u l=0.13u
MP9798 (qm9784 qmb9785 vdd vdd) p12 w=1.5u l=0.13u
MN9799 (storage9790 rst vss vss) n12 w=2u l=0.13u
MN9801 (qm9784 clk_high110 storage9800 vss) n12 w=1.2u l=0.13u
MP9802 (qm9784 clk_highb111 storage9800 vdd) p12 w=3.6u l=0.13u
MN9803 (qneg9789 clk_low108 storage9800 vss) n12 w=1.2u l=0.13u
MP9804 (qneg9789 clk_lowb109 storage9800 vdd) p12 w=3.6u l=0.13u
MN9805 (step8 storage9800 vss vss) n12 w=0.5u l=0.13u
MP9806 (step8 storage9800 vdd vdd) p12 w=1.5u l=0.13u
MN9807 (qneg9789 step8 vss vss) n12 w=0.5u l=0.13u
MP9808 (qneg9789 step8 vdd vdd) p12 w=1.5u l=0.13u
MN9809 (storage9800 rst vss vss) n12 w=2u l=0.13u
MN9812 (n9810 n8830 n9811 vss) n12 w=1.6u l=0.13u
MN9813 (n9811 settle vss vss) n12 w=1.6u l=0.13u
MP9814 (n9810 n8830 vdd vdd) p12 w=2.4u l=0.13u
MP9815 (n9810 settle vdd vdd) p12 w=2.4u l=0.13u
MN9817 (n9816 n9810 vss vss) n12 w=0.8u l=0.13u
MP9818 (n9816 n9810 vdd vdd) p12 w=2.4u l=0.13u
MN9821 (n9819 n8809 vss vss) n12 w=0.8u l=0.13u
MN9822 (n9819 n9816 vss vss) n12 w=0.8u l=0.13u
MP9823 (n9819 n8809 n9820 vdd) p12 w=4.8u l=0.13u
MP9824 (n9820 n9816 vdd vdd) p12 w=4.8u l=0.13u
MN9826 (n9825 n9819 vss vss) n12 w=0.8u l=0.13u
MP9827 (n9825 n9819 vdd vdd) p12 w=2.4u l=0.13u
MN9832 (n9825 clk_low108 storage9831 vss) n12 w=1.2u l=0.13u
MP9833 (n9825 clk_lowb109 storage9831 vdd) p12 w=3.6u l=0.13u
MN9834 (qm9828 clk_high110 storage9831 vss) n12 w=1.2u l=0.13u
MP9835 (qm9828 clk_highb111 storage9831 vdd) p12 w=3.6u l=0.13u
MN9836 (qmb9829 storage9831 vss vss) n12 w=0.5u l=0.13u
MP9837 (qmb9829 storage9831 vdd vdd) p12 w=1.5u l=0.13u
MN9838 (qm9828 qmb9829 vss vss) n12 w=0.5u l=0.13u
MP9839 (qm9828 qmb9829 vdd vdd) p12 w=1.5u l=0.13u
MN9840 (storage9831 rst vss vss) n12 w=2u l=0.13u
MN9842 (qm9828 clk_high110 storage9841 vss) n12 w=1.2u l=0.13u
MP9843 (qm9828 clk_highb111 storage9841 vdd) p12 w=3.6u l=0.13u
MN9844 (settle clk_low108 storage9841 vss) n12 w=1.2u l=0.13u
MP9845 (settle clk_lowb109 storage9841 vdd) p12 w=3.6u l=0.13u
MN9846 (qb9830 storage9841 vss vss) n12 w=0.5u l=0.13u
MP9847 (qb9830 storage9841 vdd vdd) p12 w=1.5u l=0.13u
MN9848 (settle qb9830 vss vss) n12 w=0.5u l=0.13u
MP9849 (settle qb9830 vdd vdd) p12 w=1.5u l=0.13u
MN9850 (storage9841 rst vss vss) n12 w=2u l=0.13u
MN9853 (n9851 n7860 vss vss) n12 w=0.8u l=0.13u
MN9854 (n9851 n7881 vss vss) n12 w=0.8u l=0.13u
MP9855 (n9851 n7860 n9852 vdd) p12 w=4.8u l=0.13u
MP9856 (n9852 n7881 vdd vdd) p12 w=4.8u l=0.13u
MN9858 (n9857 n9851 vss vss) n12 w=0.8u l=0.13u
MP9859 (n9857 n9851 vdd vdd) p12 w=2.4u l=0.13u
MN9861 (n9860 n9857 vss vss) n12 w=0.8u l=0.13u
MP9862 (n9860 n9857 vdd vdd) p12 w=2.4u l=0.13u
MN9865 (n9863 arm n9864 vss) n12 w=1.6u l=0.13u
MN9866 (n9864 n9860 vss vss) n12 w=1.6u l=0.13u
MP9867 (n9863 arm vdd vdd) p12 w=2.4u l=0.13u
MP9868 (n9863 n9860 vdd vdd) p12 w=2.4u l=0.13u
MN9870 (n9869 n9863 vss vss) n12 w=0.8u l=0.13u
MP9871 (n9869 n9863 vdd vdd) p12 w=2.4u l=0.13u
MN9874 (n9872 n7524 vss vss) n12 w=0.8u l=0.13u
MN9875 (n9872 n9869 vss vss) n12 w=0.8u l=0.13u
MP9876 (n9872 n7524 n9873 vdd) p12 w=4.8u l=0.13u
MP9877 (n9873 n9869 vdd vdd) p12 w=4.8u l=0.13u
MN9879 (n9878 n9872 vss vss) n12 w=0.8u l=0.13u
MP9880 (n9878 n9872 vdd vdd) p12 w=2.4u l=0.13u
MN9885 (n9878 clk_low108 storage9884 vss) n12 w=1.2u l=0.13u
MP9886 (n9878 clk_lowb109 storage9884 vdd) p12 w=3.6u l=0.13u
MN9887 (qm9881 clk_high110 storage9884 vss) n12 w=1.2u l=0.13u
MP9888 (qm9881 clk_highb111 storage9884 vdd) p12 w=3.6u l=0.13u
MN9889 (qmb9882 storage9884 vss vss) n12 w=0.5u l=0.13u
MP9890 (qmb9882 storage9884 vdd vdd) p12 w=1.5u l=0.13u
MN9891 (qm9881 qmb9882 vss vss) n12 w=0.5u l=0.13u
MP9892 (qm9881 qmb9882 vdd vdd) p12 w=1.5u l=0.13u
MN9893 (storage9884 rst vss vss) n12 w=2u l=0.13u
MN9895 (qm9881 clk_high110 storage9894 vss) n12 w=1.2u l=0.13u
MP9896 (qm9881 clk_highb111 storage9894 vdd) p12 w=3.6u l=0.13u
MN9897 (arm clk_low108 storage9894 vss) n12 w=1.2u l=0.13u
MP9898 (arm clk_lowb109 storage9894 vdd) p12 w=3.6u l=0.13u
MN9899 (qb9883 storage9894 vss vss) n12 w=0.5u l=0.13u
MP9900 (qb9883 storage9894 vdd vdd) p12 w=1.5u l=0.13u
MN9901 (arm qb9883 vss vss) n12 w=0.5u l=0.13u
MP9902 (arm qb9883 vdd vdd) p12 w=1.5u l=0.13u
MN9903 (storage9894 rst vss vss) n12 w=2u l=0.13u
MN9906 (n9904 measure n9905 vss) n12 w=1.6u l=0.13u
MN9907 (n9905 n8650 vss vss) n12 w=1.6u l=0.13u
MP9908 (n9904 measure vdd vdd) p12 w=2.4u l=0.13u
MP9909 (n9904 n8650 vdd vdd) p12 w=2.4u l=0.13u
MN9911 (n9910 n9904 vss vss) n12 w=0.8u l=0.13u
MP9912 (n9910 n9904 vdd vdd) p12 w=2.4u l=0.13u
MN9915 (n9913 n7860 vss vss) n12 w=0.8u l=0.13u
MN9916 (n9913 n9910 vss vss) n12 w=0.8u l=0.13u
MP9917 (n9913 n7860 n9914 vdd) p12 w=4.8u l=0.13u
MP9918 (n9914 n9910 vdd vdd) p12 w=4.8u l=0.13u
MN9920 (n9919 n9913 vss vss) n12 w=0.8u l=0.13u
MP9921 (n9919 n9913 vdd vdd) p12 w=2.4u l=0.13u
MN9926 (n9919 clk_low108 storage9925 vss) n12 w=1.2u l=0.13u
MP9927 (n9919 clk_lowb109 storage9925 vdd) p12 w=3.6u l=0.13u
MN9928 (qm9922 clk_high110 storage9925 vss) n12 w=1.2u l=0.13u
MP9929 (qm9922 clk_highb111 storage9925 vdd) p12 w=3.6u l=0.13u
MN9930 (qmb9923 storage9925 vss vss) n12 w=0.5u l=0.13u
MP9931 (qmb9923 storage9925 vdd vdd) p12 w=1.5u l=0.13u
MN9932 (qm9922 qmb9923 vss vss) n12 w=0.5u l=0.13u
MP9933 (qm9922 qmb9923 vdd vdd) p12 w=1.5u l=0.13u
MN9934 (storage9925 rst vss vss) n12 w=2u l=0.13u
MN9936 (qm9922 clk_high110 storage9935 vss) n12 w=1.2u l=0.13u
MP9937 (qm9922 clk_highb111 storage9935 vdd) p12 w=3.6u l=0.13u
MN9938 (measure clk_low108 storage9935 vss) n12 w=1.2u l=0.13u
MP9939 (measure clk_lowb109 storage9935 vdd) p12 w=3.6u l=0.13u
MN9940 (qb9924 storage9935 vss vss) n12 w=0.5u l=0.13u
MP9941 (qb9924 storage9935 vdd vdd) p12 w=1.5u l=0.13u
MN9942 (measure qb9924 vss vss) n12 w=0.5u l=0.13u
MP9943 (measure qb9924 vdd vdd) p12 w=1.5u l=0.13u
MN9944 (storage9935 rst vss vss) n12 w=2u l=0.13u
MN9946 (n9945 n8017 vss vss) n12 w=0.8u l=0.13u
MP9947 (n9945 n8017 vdd vdd) p12 w=2.4u l=0.13u
MN9950 (n9948 drain n9949 vss) n12 w=1.6u l=0.13u
MN9951 (n9949 n9945 vss vss) n12 w=1.6u l=0.13u
MP9952 (n9948 drain vdd vdd) p12 w=2.4u l=0.13u
MP9953 (n9948 n9945 vdd vdd) p12 w=2.4u l=0.13u
MN9955 (n9954 n9948 vss vss) n12 w=0.8u l=0.13u
MP9956 (n9954 n9948 vdd vdd) p12 w=2.4u l=0.13u
MN9959 (n9957 n6187 vss vss) n12 w=0.8u l=0.13u
MN9960 (n9957 n9954 vss vss) n12 w=0.8u l=0.13u
MP9961 (n9957 n6187 n9958 vdd) p12 w=4.8u l=0.13u
MP9962 (n9958 n9954 vdd vdd) p12 w=4.8u l=0.13u
MN9964 (n9963 n9957 vss vss) n12 w=0.8u l=0.13u
MP9965 (n9963 n9957 vdd vdd) p12 w=2.4u l=0.13u
MN9970 (n9963 clk_low108 storage9969 vss) n12 w=1.2u l=0.13u
MP9971 (n9963 clk_lowb109 storage9969 vdd) p12 w=3.6u l=0.13u
MN9972 (qm9966 clk_high110 storage9969 vss) n12 w=1.2u l=0.13u
MP9973 (qm9966 clk_highb111 storage9969 vdd) p12 w=3.6u l=0.13u
MN9974 (qmb9967 storage9969 vss vss) n12 w=0.5u l=0.13u
MP9975 (qmb9967 storage9969 vdd vdd) p12 w=1.5u l=0.13u
MN9976 (qm9966 qmb9967 vss vss) n12 w=0.5u l=0.13u
MP9977 (qm9966 qmb9967 vdd vdd) p12 w=1.5u l=0.13u
MN9978 (storage9969 rst vss vss) n12 w=2u l=0.13u
MN9980 (qm9966 clk_high110 storage9979 vss) n12 w=1.2u l=0.13u
MP9981 (qm9966 clk_highb111 storage9979 vdd) p12 w=3.6u l=0.13u
MN9982 (drain clk_low108 storage9979 vss) n12 w=1.2u l=0.13u
MP9983 (drain clk_lowb109 storage9979 vdd) p12 w=3.6u l=0.13u
MN9984 (qb9968 storage9979 vss vss) n12 w=0.5u l=0.13u
MP9985 (qb9968 storage9979 vdd vdd) p12 w=1.5u l=0.13u
MN9986 (drain qb9968 vss vss) n12 w=0.5u l=0.13u
MP9987 (drain qb9968 vdd vdd) p12 w=1.5u l=0.13u
MN9988 (storage9979 rst vss vss) n12 w=2u l=0.13u
MN9993 (done clk_low108 storage9992 vss) n12 w=1.2u l=0.13u
MP9994 (done clk_lowb109 storage9992 vdd) p12 w=3.6u l=0.13u
MN9995 (qm9989 clk_high110 storage9992 vss) n12 w=1.2u l=0.13u
MP9996 (qm9989 clk_highb111 storage9992 vdd) p12 w=3.6u l=0.13u
MN9997 (qmb9990 storage9992 vss vss) n12 w=0.5u l=0.13u
MP9998 (qmb9990 storage9992 vdd vdd) p12 w=1.5u l=0.13u
MN9999 (qm9989 qmb9990 vss vss) n12 w=0.5u l=0.13u
MP10000 (qm9989 qmb9990 vdd vdd) p12 w=1.5u l=0.13u
MN10001 (storage9992 rst vss vss) n12 w=2u l=0.13u
MN10003 (qm9989 clk_high110 storage10002 vss) n12 w=1.2u l=0.13u
MP10004 (qm9989 clk_highb111 storage10002 vdd) p12 w=3.6u l=0.13u
MN10005 (done_delay1 clk_low108 storage10002 vss) n12 w=1.2u l=0.13u
MP10006 (done_delay1 clk_lowb109 storage10002 vdd) p12 w=3.6u l=0.13u
MN10007 (qb9991 storage10002 vss vss) n12 w=0.5u l=0.13u
MP10008 (qb9991 storage10002 vdd vdd) p12 w=1.5u l=0.13u
MN10009 (done_delay1 qb9991 vss vss) n12 w=0.5u l=0.13u
MP10010 (done_delay1 qb9991 vdd vdd) p12 w=1.5u l=0.13u
MN10011 (storage10002 rst vss vss) n12 w=2u l=0.13u
MN10014 (n10012 done_delay1 n10013 vss) n12 w=1.6u l=0.13u
MN10015 (n10013 n39 vss vss) n12 w=1.6u l=0.13u
MP10016 (n10012 done_delay1 vdd vdd) p12 w=2.4u l=0.13u
MP10017 (n10012 n39 vdd vdd) p12 w=2.4u l=0.13u
MN10019 (n10018 n10012 vss vss) n12 w=0.8u l=0.13u
MP10020 (n10018 n10012 vdd vdd) p12 w=2.4u l=0.13u
MN10025 (n10018 clk_low108 storage10024 vss) n12 w=1.2u l=0.13u
MP10026 (n10018 clk_lowb109 storage10024 vdd) p12 w=3.6u l=0.13u
MN10027 (qm10021 clk_high110 storage10024 vss) n12 w=1.2u l=0.13u
MP10028 (qm10021 clk_highb111 storage10024 vdd) p12 w=3.6u l=0.13u
MN10029 (qmb10022 storage10024 vss vss) n12 w=0.5u l=0.13u
MP10030 (qmb10022 storage10024 vdd vdd) p12 w=1.5u l=0.13u
MN10031 (qm10021 qmb10022 vss vss) n12 w=0.5u l=0.13u
MP10032 (qm10021 qmb10022 vdd vdd) p12 w=1.5u l=0.13u
MN10033 (storage10024 rst vss vss) n12 w=2u l=0.13u
MN10035 (qm10021 clk_high110 storage10034 vss) n12 w=1.2u l=0.13u
MP10036 (qm10021 clk_highb111 storage10034 vdd) p12 w=3.6u l=0.13u
MN10037 (fine_enable clk_low108 storage10034 vss) n12 w=1.2u l=0.13u
MP10038 (fine_enable clk_lowb109 storage10034 vdd) p12 w=3.6u l=0.13u
MN10039 (qb10023 storage10034 vss vss) n12 w=0.5u l=0.13u
MP10040 (qb10023 storage10034 vdd vdd) p12 w=1.5u l=0.13u
MN10041 (fine_enable qb10023 vss vss) n12 w=0.5u l=0.13u
MP10042 (fine_enable qb10023 vdd vdd) p12 w=1.5u l=0.13u
MN10043 (storage10034 rst vss vss) n12 w=2u l=0.13u
MN10045 (n10044 fine_enable vss vss) n12 w=0.8u l=0.13u
MP10046 (n10044 fine_enable vdd vdd) p12 w=2.4u l=0.13u
MN10048 (n10047 n10044 vss vss) n12 w=0.8u l=0.13u
MP10049 (n10047 n10044 vdd vdd) p12 w=2.4u l=0.13u
MN10051 (n10050 n10047 vss vss) n12 w=0.8u l=0.13u
MP10052 (n10050 n10047 vdd vdd) p12 w=2.4u l=0.13u
MN10054 (n10053 n10050 vss vss) n12 w=0.8u l=0.13u
MP10055 (n10053 n10050 vdd vdd) p12 w=2.4u l=0.13u
MN10056 (hold n10053 vss vss) n12 w=0.8u l=0.13u
MP10057 (hold n10053 vdd vdd) p12 w=2.4u l=0.13u
MN10060 (n10058 n10044 vss vss) n12 w=0.8u l=0.13u
MN10061 (n10058 rst vss vss) n12 w=0.8u l=0.13u
MP10062 (n10058 n10044 n10059 vdd) p12 w=4.8u l=0.13u
MP10063 (n10059 rst vdd vdd) p12 w=4.8u l=0.13u
MN10065 (n10064 n10058 vss vss) n12 w=0.8u l=0.13u
MP10066 (n10064 n10058 vdd vdd) p12 w=2.4u l=0.13u
MN10068 (n10067 n10064 vss vss) n12 w=0.8u l=0.13u
MP10069 (n10067 n10064 vdd vdd) p12 w=2.4u l=0.13u
MN10071 (n10070 n10067 vss vss) n12 w=0.8u l=0.13u
MP10072 (n10070 n10067 vdd vdd) p12 w=2.4u l=0.13u
MN10074 (n10073 n10070 vss vss) n12 w=0.8u l=0.13u
MP10075 (n10073 n10070 vdd vdd) p12 w=2.4u l=0.13u
MN10076 (pfd_reset n10073 vss vss) n12 w=0.8u l=0.13u
MP10077 (pfd_reset n10073 vdd vdd) p12 w=2.4u l=0.13u
ends afc2009_mos
