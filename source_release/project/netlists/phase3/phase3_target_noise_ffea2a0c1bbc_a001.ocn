openResults("@PROJECT_ROOT@/results/phase3/phase3_target_noise_ffea2a0c1bbc_a001.raw")
selectResult('pnoise_pm)
pn=phaseNoise(1 "pss_fd" ?result "pnoise_pm")
unless(pn error("phaseNoise returned nil\n"))
ocnPrint(?output "@PROJECT_ROOT@/results/phase3/phase3_target_noise_ffea2a0c1bbc_a001_pn_ssb.txt" ?numberNotation 'scientific ?precision 12 pn)
f=outfile("@PROJECT_ROOT@/results/phase3/phase3_target_noise_ffea2a0c1bbc_a001_pn_scalars.txt")
fprintf(f "PN1M %.15g\n" value(pn 1e6))
fprintf(f "PN10M %.15g\n" value(pn 1e7))
close(f)
exit()
