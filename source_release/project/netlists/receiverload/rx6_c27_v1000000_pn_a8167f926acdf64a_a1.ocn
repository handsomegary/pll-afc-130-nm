openResults("@PROJECT_ROOT@/results/receiverload/rx6_c27_v1000000_pn_a8167f926acdf64a_a1.raw")
selectResult('pnoise_pm)
pn=phaseNoise(1 "pss_fd" ?result "pnoise_pm")
unless(pn error("phaseNoise returned nil\n"))
ocnPrint(?output "@PROJECT_ROOT@/results/receiverload/rx6_c27_v1000000_pn_a8167f926acdf64a_a1_pn_ssb.txt" ?numberNotation 'scientific ?precision 12 pn)
f=outfile("@PROJECT_ROOT@/results/receiverload/rx6_c27_v1000000_pn_a8167f926acdf64a_a1_pn_scalars.txt")
fprintf(f "PN1M %.15g\n" value(pn 1e6))
fprintf(f "PN10M %.15g\n" value(pn 1e7))
close(f)
exit()
