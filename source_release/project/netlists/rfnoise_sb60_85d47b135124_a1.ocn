openResults("@PROJECT_ROOT@/results/rfnoise/rfnoise_sb60_85d47b135124_a1.raw")
selectResult('pnoise_pm)
pn=phaseNoise(1 "pss_fd" ?result "pnoise_pm")
unless(pn error("phaseNoise returned nil\n"))
ocnPrint(?output "@PROJECT_ROOT@/results/rfnoise/rfnoise_sb60_85d47b135124_a1_pn_ssb.txt" ?numberNotation 'scientific ?precision 12 pn)
f=outfile("@PROJECT_ROOT@/results/rfnoise/rfnoise_sb60_85d47b135124_a1_pn_scalars.txt")
fprintf(f "PN1M %.15g\n" value(pn 1e6))
fprintf(f "PN10M %.15g\n" value(pn 1e7))
close(f)
exit()
