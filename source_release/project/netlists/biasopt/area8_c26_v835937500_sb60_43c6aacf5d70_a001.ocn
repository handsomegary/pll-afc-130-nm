openResults("@PROJECT_ROOT@/results/biasopt/area8_c26_v835937500_sb60_43c6aacf5d70_a001.raw")
selectResult('pnoise_pm)
pn=phaseNoise(1 "pss_fd" ?result "pnoise_pm")
unless(pn error("phaseNoise returned nil\n"))
ocnPrint(?output "@PROJECT_ROOT@/results/biasopt/area8_c26_v835937500_sb60_43c6aacf5d70_a001_pn_ssb.txt" ?numberNotation 'scientific ?precision 12 pn)
f=outfile("@PROJECT_ROOT@/results/biasopt/area8_c26_v835937500_sb60_43c6aacf5d70_a001_pn_scalars.txt")
fprintf(f "PN1M %.15g\n" value(pn 1e6))
fprintf(f "PN10M %.15g\n" value(pn 1e7))
close(f)
exit()
